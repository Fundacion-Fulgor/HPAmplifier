* Extracted by KLayout with SG13G2 LVS runset on : 28/03/2026 00:57

.SUBCKT HPA VSS VINp VOUTp VDD VREF VINn VOUTn
M$1 VOUTp \$9 VDD VSS sg13_lv_nmos L=0.15u W=250u AS=85p AD=85p PS=517u PD=517u
M$26 \$31 VOUTp \$9 VSS sg13_lv_nmos L=0.5u W=160u AS=33.4p AD=30.4p PS=186.68u
+ PD=166.08u
M$34 \$31 \$83 \$55 VSS sg13_lv_nmos L=0.5u W=160u AS=30.4p AD=33.4p PS=166.08u
+ PD=186.68u
M$58 VOUTp \$41 VSS VSS sg13_lv_nmos L=1u W=3u AS=1.02p AD=1.02p PS=6.68u
+ PD=6.68u
M$59 \$31 \$41 VSS VSS sg13_lv_nmos L=1u W=9u AS=2.16p AD=2.16p PS=13.44u
+ PD=13.44u
M$62 VSS \$41 \$41 VSS sg13_lv_nmos L=1u W=3u AS=1.02p AD=1.02p PS=6.68u
+ PD=6.68u
M$63 \$83 \$334 VSS VSS sg13_lv_nmos L=1.06u W=264u AS=53.76p AD=53.76p
+ PS=310.4u PD=310.4u
M$118 \$345 \$352 \$368 VSS sg13_lv_nmos L=6.4u W=96u AS=20.04p AD=20.04p
+ PS=114.68u PD=114.68u
M$134 \$417 \$425 VSS VSS sg13_lv_nmos L=0.2u W=179.82u AS=34.6653p AD=34.6653p
+ PS=203.97u PD=203.97u
M$188 \$460 \$466 \$82 VSS sg13_lv_nmos L=0.16u W=57u AS=12.255p AD=12.255p
+ PS=79.4u PD=79.4u
M$218 \$399 \$399 VSS VSS sg13_lv_nmos L=0.2u W=29.97u AS=6.1938p AD=5.6943p
+ PS=37.02u PD=33.39u
M$227 VSS \$425 \$425 VSS sg13_lv_nmos L=0.2u W=29.97u AS=5.6943p AD=6.1938p
+ PS=33.39u PD=37.02u
M$236 \$417 \$539 \$460 VSS sg13_lv_nmos L=0.15u W=33u AS=7.095p AD=7.095p
+ PS=51.4u PD=51.4u
M$266 \$417 \$75 \$578 VSS sg13_lv_nmos L=0.15u W=33u AS=7.095p AD=7.095p
+ PS=51.4u PD=51.4u
M$296 \$578 \$466 \$692 VSS sg13_lv_nmos L=0.16u W=57u AS=12.255p AD=12.255p
+ PS=79.4u PD=79.4u
M$326 \$345 \$345 \$352 VSS sg13_lv_nmos L=1u W=2u AS=0.68p AD=0.68p PS=4.68u
+ PD=4.68u
M$327 \$352 \$352 VSS VSS sg13_lv_nmos L=6.4u W=12u AS=3.18p AD=3.18p PS=19.06u
+ PD=19.06u
M$329 \$387 \$352 VSS VSS sg13_lv_nmos L=6.4u W=12u AS=3.18p AD=3.18p PS=19.06u
+ PD=19.06u
M$331 VSS \$334 \$747 VSS sg13_lv_nmos L=1.06u W=264u AS=53.76p AD=53.76p
+ PS=310.4u PD=310.4u
M$386 \$409 \$334 VSS VSS sg13_lv_nmos L=1.06u W=4.8u AS=1.632p AD=0.912p
+ PS=10.28u PD=5.18u
M$387 VSS \$334 \$459 VSS sg13_lv_nmos L=1.06u W=4.8u AS=0.912p AD=1.632p
+ PS=5.18u PD=10.28u
M$388 VSS \$466 \$466 VSS sg13_lv_nmos L=0.8u W=0.5u AS=0.17p AD=0.17p PS=1.68u
+ PD=1.68u
M$389 VSS \$334 \$334 VSS sg13_lv_nmos L=1.06u W=4.8u AS=1.632p AD=1.632p
+ PS=10.28u PD=10.28u
M$390 \$1072 \$747 \$1075 VSS sg13_lv_nmos L=0.5u W=160u AS=33.4p AD=30.4p
+ PS=186.68u PD=166.08u
M$398 \$1072 VOUTn \$1098 VSS sg13_lv_nmos L=0.5u W=160u AS=30.4p AD=33.4p
+ PS=166.08u PD=186.68u
M$422 \$504 \$504 VSS VSS sg13_lv_nmos L=1u W=3u AS=1.02p AD=1.02p PS=6.68u
+ PD=6.68u
M$423 VSS \$504 \$1072 VSS sg13_lv_nmos L=1u W=9u AS=2.16p AD=2.16p PS=13.44u
+ PD=13.44u
M$426 VSS \$504 VOUTn VSS sg13_lv_nmos L=1u W=3u AS=1.02p AD=1.02p PS=6.68u
+ PD=6.68u
M$427 VDD \$1098 VOUTn VSS sg13_lv_nmos L=0.15u W=250u AS=85p AD=85p PS=517u
+ PD=517u
M$452 VDD \$55 \$9 VDD sg13_lv_pmos L=1u W=40u AS=9.1p AD=7.6p PS=51.82u
+ PD=41.52u
M$456 VDD \$55 \$55 VDD sg13_lv_pmos L=1u W=40u AS=7.6p AD=9.1p PS=41.52u
+ PD=51.82u
M$460 VDD \$82 \$83 VDD sg13_lv_pmos L=0.35u W=342.5u AS=70.2125p AD=70.2125p
+ PS=479.25u PD=479.25u
M$710 VDD \$387 \$387 VDD sg13_lv_pmos L=0.7u W=48u AS=9.27p AD=9.27p PS=67.54u
+ PD=67.54u
M$758 VDD \$387 \$388 VDD sg13_lv_pmos L=0.7u W=144u AS=28.26p AD=27.36p
+ PS=206.52u PD=198.72u
M$782 VDD \$387 \$577 VDD sg13_lv_pmos L=0.7u W=144u AS=27.36p AD=28.26p
+ PS=198.72u PD=206.52u
M$1046 \$399 VREF \$388 VDD sg13_lv_pmos L=0.35u W=35.98u AS=7.2217p AD=6.8362p
+ PS=49.79u PD=46.62u
M$1060 \$399 VREF \$577 VDD sg13_lv_pmos L=0.35u W=35.98u AS=6.8362p AD=7.2217p
+ PS=46.62u PD=49.79u
M$1102 \$408 \$409 \$82 VDD sg13_lv_pmos L=0.5u W=121.5u AS=26.1225p
+ AD=26.1225p PS=154.65u PD=154.65u
M$1132 VDD \$345 \$41 VDD sg13_lv_pmos L=2.5u W=12u AS=3.18p AD=2.28p PS=19.06u
+ PD=12.76u
M$1134 VDD \$345 \$504 VDD sg13_lv_pmos L=2.5u W=12u AS=2.28p AD=2.28p
+ PS=12.76u PD=12.76u
M$1136 VDD \$345 \$334 VDD sg13_lv_pmos L=2.5u W=12u AS=2.28p AD=2.28p
+ PS=12.76u PD=12.76u
M$1138 VDD \$345 \$345 VDD sg13_lv_pmos L=2.5u W=12u AS=2.28p AD=2.28p
+ PS=12.76u PD=12.76u
M$1140 VDD \$345 \$352 VDD sg13_lv_pmos L=2.5u W=12u AS=2.28p AD=3.18p
+ PS=12.76u PD=19.06u
M$1142 VDD \$459 \$408 VDD sg13_lv_pmos L=0.7u W=210u AS=45.15p AD=45.15p
+ PS=257.9u PD=257.9u
M$1172 \$425 \$83 \$388 VDD sg13_lv_pmos L=0.35u W=35.98u AS=7.2217p AD=6.8362p
+ PS=49.79u PD=46.62u
M$1186 \$425 \$747 \$577 VDD sg13_lv_pmos L=0.35u W=35.98u AS=6.8362p
+ AD=7.2217p PS=46.62u PD=49.79u
M$1228 VDD \$459 \$616 VDD sg13_lv_pmos L=0.7u W=210u AS=45.15p AD=45.15p
+ PS=257.9u PD=257.9u
M$1258 \$616 \$409 \$692 VDD sg13_lv_pmos L=0.5u W=121.5u AS=26.1225p
+ AD=26.1225p PS=154.65u PD=154.65u
M$1288 VDD \$692 \$747 VDD sg13_lv_pmos L=0.35u W=342.5u AS=70.2125p
+ AD=70.2125p PS=479.25u PD=479.25u
M$1538 \$466 \$409 VDD VDD sg13_lv_pmos L=0.35u W=2.05u AS=0.697p AD=0.3895p
+ PS=4.78u PD=2.43u
M$1539 VDD \$409 \$409 VDD sg13_lv_pmos L=0.35u W=2.05u AS=0.3895p AD=0.697p
+ PS=2.43u PD=4.78u
M$1540 VDD \$459 \$459 VDD sg13_lv_pmos L=0.35u W=11.2u AS=2.548p AD=2.548p
+ PS=17.64u PD=17.64u
M$1548 VDD \$1075 \$1075 VDD sg13_lv_pmos L=1u W=40u AS=9.1p AD=7.6p PS=51.82u
+ PD=41.52u
M$1552 VDD \$1075 \$1098 VDD sg13_lv_pmos L=1u W=40u AS=7.6p AD=9.1p PS=41.52u
+ PD=51.82u
R$1556 \$83 \$75 rppd w=0.6u l=19u ps=0 b=0 m=1
R$1557 \$75 VINp rppd w=0.6u l=6.73u ps=0 b=0 m=1
R$1558 \$368 VSS rppd w=1u l=11.5u ps=0 b=0 m=1
R$1559 \$346 \$82 rppd w=1.5u l=0.55u ps=0 b=0 m=1
R$1560 \$711 \$692 rppd w=1.5u l=0.55u ps=0 b=0 m=1
R$1561 \$747 \$539 rppd w=0.6u l=19u ps=0 b=0 m=1
R$1562 \$539 VINn rppd w=0.6u l=6.73u ps=0 b=0 m=1
C$1563 \$346 \$83 cap_cmim w=21.4u l=21.4u A=457.96p P=85.6u m=1
C$1564 \$711 \$747 cap_cmim w=21.4u l=21.4u A=457.96p P=85.6u m=1
.ENDS HPA
