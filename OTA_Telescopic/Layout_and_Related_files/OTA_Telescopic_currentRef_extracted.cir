* Extracted by KLayout with SG13G2 LVS runset on : 23/03/2026 02:17

.SUBCKT OTA_Telescopic_currentRef VSS I_N I_P I_P2 I_P3 VDD
M$1 \$5 \$3 \$4 VSS sg13_lv_nmos L=6.4u W=96u AS=20.04p AD=20.04p PS=114.68u
+ PD=114.68u
M$9 I_N \$3 VSS VSS sg13_lv_nmos L=6.4u W=12u AS=3.18p AD=3.18p PS=19.06u
+ PD=19.06u
M$11 \$3 \$3 VSS VSS sg13_lv_nmos L=6.4u W=12u AS=3.18p AD=3.18p PS=19.06u
+ PD=19.06u
M$13 \$3 \$5 \$5 VSS sg13_lv_nmos L=1u W=2u AS=0.68p AD=0.68p PS=4.68u PD=4.68u
M$22 VDD \$5 \$3 VDD sg13_lv_pmos L=2.5u W=12u AS=3.18p AD=2.28p PS=19.06u
+ PD=12.76u
M$24 VDD \$5 \$5 VDD sg13_lv_pmos L=2.5u W=12u AS=2.28p AD=2.28p PS=12.76u
+ PD=12.76u
M$26 VDD \$5 I_P VDD sg13_lv_pmos L=2.5u W=12u AS=2.28p AD=2.28p PS=12.76u
+ PD=12.76u
M$28 VDD \$5 I_P2 VDD sg13_lv_pmos L=2.5u W=12u AS=2.28p AD=2.28p PS=12.76u
+ PD=12.76u
M$30 VDD \$5 I_P3 VDD sg13_lv_pmos L=2.5u W=12u AS=2.28p AD=3.18p PS=12.76u
+ PD=19.06u
R$32 VSS \$4 rppd w=1u l=11.5u ps=0 b=0 m=1
.ENDS OTA_Telescopic_currentRef
