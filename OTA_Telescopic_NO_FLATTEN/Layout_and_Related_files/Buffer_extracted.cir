* Extracted by KLayout with SG13G2 LVS runset on : 23/03/2026 13:43

.SUBCKT Buffer VSS IB VIN VDD VOUT
M$1 IB IB VSS VSS sg13_lv_nmos L=1u W=3u AS=1.02p AD=1.02p PS=6.68u PD=6.68u
M$2 VSS IB \$3 VSS sg13_lv_nmos L=1u W=9u AS=2.16p AD=2.16p PS=13.44u PD=13.44u
M$5 VSS IB VOUT VSS sg13_lv_nmos L=1u W=3u AS=1.02p AD=1.02p PS=6.68u PD=6.68u
M$6 \$3 VIN \$10 VSS sg13_lv_nmos L=0.5u W=160u AS=33.4p AD=30.4p PS=186.68u
+ PD=166.08u
M$14 \$3 VOUT \$11 VSS sg13_lv_nmos L=0.5u W=160u AS=30.4p AD=33.4p PS=166.08u
+ PD=186.68u
M$38 VDD \$11 VOUT VSS sg13_lv_nmos L=0.15u W=250u AS=85p AD=85p PS=517u PD=517u
M$63 VDD \$10 \$10 VDD sg13_lv_pmos L=1u W=40u AS=9.1p AD=7.6p PS=51.82u
+ PD=41.52u
M$67 VDD \$10 \$11 VDD sg13_lv_pmos L=1u W=40u AS=7.6p AD=9.1p PS=41.52u
+ PD=51.82u
.ENDS Buffer
