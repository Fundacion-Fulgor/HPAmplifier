* NGSPICE file created from MPC0349.ext - technology: ihp-sg13

.subckt ihpIC VDD3 analog_io[22] analog_io[23] analog_io[20] analog_io[25] analog_io[19] VSS3 IOVDD3 IOVSS3 analog_io[24] analog_io[21]
X0 user_project_wrapper_0.sg13g2_IOPadIOVdd_0.sg13g2_Clamp_N43N43D4R_0.gate user_project_wrapper_0.sg13g2_IOPadIOVdd_0.sg13g2_RCClampResistor_0.p2 user_project_wrapper_0.IOVDD2 user_project_wrapper_0.IOVDD2 sg13_hv_pmos ad=1.33p pd=7.38u as=1.33p ps=7.38u w=7u l=0.5u
X1 user_project_wrapper_0.IOVSS1 user_project_wrapper_0.sg13g2_IOPadIOVdd_2.sg13g2_Clamp_N43N43D4R_0.gate user_project_wrapper_0.IOVDD4 user_project_wrapper_0.IOVSS1 sg13_hv_nmos ad=1.408p pd=5.04u as=2.596p ps=5.58u w=4.4u l=0.6u
X2 user_project_wrapper_0.IOVDD1 a_41476_258244# user_project_wrapper_0.analog_io[7] user_project_wrapper_0.IOVDD1 sg13_hv_pmos ad=2.1312p pd=7.3u as=3.9294p ps=7.84u w=6.66u l=0.6u
X3 user_project_wrapper_0.IOVSS1 a_29676_197044# user_project_wrapper_0.analog_io[4] user_project_wrapper_0.IOVSS1 sg13_hv_nmos ad=1.408p pd=5.04u as=2.596p ps=5.58u w=4.4u l=0.6u
X4 user_project_wrapper_0.IOVSS1 a_190389_99046# user_project_wrapper_0.analog_io[14] user_project_wrapper_0.IOVSS1 sg13_lv_nmos ad=0.1406p pd=1.12u as=0.1406p ps=1.12u w=0.74u l=0.13u
X5 user_project_wrapper_0.analog_io[27] a_115444_355624# user_project_wrapper_0.IOVDD4 user_project_wrapper_0.IOVDD4 sg13_hv_pmos ad=3.9294p pd=7.84u as=2.1312p ps=7.3u w=6.66u l=0.6u
X6 a_296731_189665# a_296625_189595# VDD3 VDD3 sg13_lv_pmos ad=0.2603p pd=1.75u as=0.4658p ps=3.42u w=1.37u l=0.35u
X7 a_309917_194695# a_296731_189665# a_307232_196607# VDD3 sg13_lv_pmos ad=0.24415p pd=1.665u as=0.24415p ps=1.665u w=1.285u l=0.35u
X8 analog_io[23] a_355624_237844# IOVDD3 IOVDD3 sg13_hv_pmos ad=3.9294p pd=7.84u as=2.1312p ps=7.3u w=6.66u l=0.6u
X9 user_project_wrapper_0.IOVSS1 a_278644_369296# user_project_wrapper_0.analog_io[35] user_project_wrapper_0.IOVSS1 sg13_hv_nmos ad=1.408p pd=5.04u as=2.596p ps=5.58u w=4.4u l=0.6u
X10 user_project_wrapper_0.analog_io[0] a_29676_115444# user_project_wrapper_0.IOVSS1 user_project_wrapper_0.IOVSS1 sg13_hv_nmos ad=2.596p pd=5.58u as=2.068p ps=9.74u w=4.4u l=0.6u
X11 user_project_wrapper_0.IOVSS1 a_115444_369296# user_project_wrapper_0.analog_io[27] user_project_wrapper_0.IOVSS1 sg13_hv_nmos ad=1.408p pd=5.04u as=2.596p ps=5.58u w=4.4u l=0.6u
X12 a_194687_324142# a_194279_327536# user_project_wrapper_0.IOVSS1 user_project_wrapper_0.IOVSS1 sg13_lv_pmos ad=1.824p pd=9.98u as=3.264p ps=19.88u w=9.6u l=0.13u
X13 a_191438_325263# a_191234_325263# user_project_wrapper_0.IOVSS1 user_project_wrapper_0.IOVSS1 sg13_lv_nmos ad=0.19p pd=1.38u as=0.34p ps=2.68u w=1u l=0.13u
X14 user_project_wrapper_0.analog_io[15] a_190389_101343# user_project_wrapper_0.IOVSS1 user_project_wrapper_0.IOVSS1 sg13_lv_nmos ad=0.1406p pd=1.12u as=0.1406p ps=1.12u w=0.74u l=0.13u
X15 a_79025_133504# a_78220_130691# a_79038_132196# user_project_wrapper_0.VDD1 sg13_lv_pmos ad=1.7p pd=10.68u as=0.95p ps=5.38u w=5u l=0.3u
X16 user_project_wrapper_0.sg13g2_IOPadIOVdd_0.sg13g2_Clamp_N43N43D4R_0.gate user_project_wrapper_0.sg13g2_IOPadIOVdd_0.sg13g2_RCClampResistor_0.p2 user_project_wrapper_0.IOVDD2 user_project_wrapper_0.IOVDD2 sg13_hv_pmos ad=1.33p pd=7.38u as=1.33p ps=7.38u w=7u l=0.5u
X17 a_115825_39542# a_115495_35456# user_project_wrapper_0.IOVSS1 rppd l=20u w=1u
X18 user_project_wrapper_0.IOVSS1 user_project_wrapper_0.sg13g2_IOPadVdd_2.sg13g2_RCClampInverter_noptap_0.out user_project_wrapper_0.VDD1 user_project_wrapper_0.IOVSS1 sg13_hv_nmos ad=1.408p pd=5.04u as=2.596p ps=5.58u w=4.4u l=0.6u
X19 user_project_wrapper_0.IOVSS1 user_project_wrapper_0.sg13g2_IOPadIOVdd_0.sg13g2_Clamp_N43N43D4R_0.gate user_project_wrapper_0.IOVDD2 user_project_wrapper_0.IOVSS1 sg13_hv_nmos ad=1.408p pd=5.04u as=2.596p ps=5.58u w=4.4u l=0.6u
X20 a_296732_200582# a_301940_196388# a_296625_208423# VDD3 sg13_lv_pmos ad=0.7695p pd=4.43u as=0.7695p ps=4.43u w=4.05u l=0.5u
X21 user_project_wrapper_0.IOVSS1 user_project_wrapper_0.sg13g2_IOPadVdd_3.sg13g2_RCClampResistor_0.p2 user_project_wrapper_0.sg13g2_IOPadVdd_3.sg13g2_RCClampInverter_noptap_0.out user_project_wrapper_0.IOVSS1 sg13_hv_pmos ad=1.33p pd=7.38u as=1.33p ps=7.38u w=7u l=0.5u
X22 IOVDD3 a_355624_278644# analog_io[26] IOVDD3 sg13_hv_pmos ad=2.1312p pd=7.3u as=3.9294p ps=7.84u w=6.66u l=0.6u
X23 user_project_wrapper_0.IOVDD4 user_project_wrapper_0.sg13g2_IOPadIOVdd_2.sg13g2_Clamp_N43N43D4R_0.gate user_project_wrapper_0.IOVSS1 user_project_wrapper_0.IOVSS1 sg13_hv_nmos ad=2.596p pd=5.58u as=1.408p ps=5.04u w=4.4u l=0.6u
X24 user_project_wrapper_0.IOVDD4 user_project_wrapper_0.sg13g2_IOPadIOVdd_2.sg13g2_RCClampResistor_0.p2 user_project_wrapper_0.sg13g2_IOPadIOVdd_2.sg13g2_Clamp_N43N43D4R_0.gate user_project_wrapper_0.IOVDD4 sg13_hv_pmos ad=1.33p pd=7.38u as=1.33p ps=7.38u w=7u l=0.5u
X25 user_project_wrapper_0.IOVSS1 a_190686_324119# a_190455_324119# user_project_wrapper_0.IOVSS1 sg13_lv_nmos ad=0.19p pd=1.38u as=0.34p ps=2.68u w=1u l=0.13u
X26 user_project_wrapper_0.analog_io[10] a_135844_41476# user_project_wrapper_0.IOVDD2 user_project_wrapper_0.IOVDD2 sg13_hv_pmos ad=3.9294p pd=7.84u as=2.1312p ps=7.3u w=6.66u l=0.6u
X27 user_project_wrapper_0.VDD1 a_83492_127455# a_86594_127896# user_project_wrapper_0.VDD1 sg13_lv_pmos ad=0.3808p pd=2.92u as=0.2128p ps=1.5u w=1.12u l=0.13u
X28 a_78219_134797# a_78220_130691# user_project_wrapper_0.IOVSS1 rppd l=2u w=0.5u
X29 a_296731_208493# a_296625_208423# VDD3 VDD3 sg13_lv_pmos ad=0.2603p pd=1.75u as=0.2603p ps=1.75u w=1.37u l=0.35u
X30 user_project_wrapper_0.VDD2 user_project_wrapper_0.sg13g2_IOPadVdd_1.sg13g2_RCClampInverter_noptap_0.out user_project_wrapper_0.IOVSS1 user_project_wrapper_0.IOVSS1 sg13_hv_nmos ad=2.596p pd=5.58u as=1.408p ps=5.04u w=4.4u l=0.6u
X31 user_project_wrapper_0.IOVDD4 user_project_wrapper_0.sg13g2_IOPadIOVdd_2.sg13g2_Clamp_N43N43D4R_0.gate user_project_wrapper_0.IOVSS1 user_project_wrapper_0.IOVSS1 sg13_hv_nmos ad=2.596p pd=5.58u as=1.408p ps=5.04u w=4.4u l=0.6u
X32 user_project_wrapper_0.IOVSS1 a_369296_115444# analog_io[18] user_project_wrapper_0.IOVSS1 sg13_hv_nmos ad=1.408p pd=5.04u as=2.596p ps=5.58u w=4.4u l=0.6u
X33 user_project_wrapper_0.IOVDD1 a_41476_258244# user_project_wrapper_0.analog_io[7] user_project_wrapper_0.IOVDD1 sg13_hv_pmos ad=2.1312p pd=7.3u as=3.9294p ps=7.84u w=6.66u l=0.6u
X34 user_project_wrapper_0.IOVDD2 a_237844_41476# user_project_wrapper_0.analog_io[15] user_project_wrapper_0.IOVDD2 sg13_hv_pmos ad=2.1312p pd=7.3u as=3.9294p ps=7.84u w=6.66u l=0.6u
X35 a_194687_324142# a_194279_327536# user_project_wrapper_0.IOVSS1 user_project_wrapper_0.IOVSS1 sg13_lv_pmos ad=1.824p pd=9.98u as=1.824p ps=9.98u w=9.6u l=0.13u
X36 a_296731_189665# a_301186_192011# user_project_wrapper_0.IOVSS1 user_project_wrapper_0.IOVSS1 sg13_lv_nmos ad=0.912p pd=5.18u as=0.912p ps=5.18u w=4.8u l=1.06u
X37 user_project_wrapper_0.IOVDD4 a_156244_355624# user_project_wrapper_0.IOVDD4 rppd l=12.9u w=0.5u
X38 user_project_wrapper_0.VDD1 user_project_wrapper_0.sg13g2_IOPadVdd_2.sg13g2_RCClampInverter_noptap_0.out user_project_wrapper_0.IOVSS1 user_project_wrapper_0.IOVSS1 sg13_hv_nmos ad=2.596p pd=5.58u as=1.408p ps=5.04u w=4.4u l=0.6u
X39 user_project_wrapper_0.analog_io[27] a_115444_369296# user_project_wrapper_0.IOVSS1 user_project_wrapper_0.IOVSS1 sg13_hv_nmos ad=2.596p pd=5.58u as=2.068p ps=9.74u w=4.4u l=0.6u
X40 user_project_wrapper_0.IOVSS1 a_211928_324776# a_208855_324776# w_207989_323975# sg13_lv_pmos ad=0.38p pd=2.38u as=0.38p ps=2.38u w=2u l=0.13u
X41 user_project_wrapper_0.sg13g2_IOPadVdd_2.sg13g2_RCClampInverter_noptap_0.out user_project_wrapper_0.sg13g2_IOPadVdd_2.sg13g2_RCClampResistor_0.p2 user_project_wrapper_0.VDD1 user_project_wrapper_0.VDD1 sg13_hv_pmos ad=1.33p pd=7.38u as=1.33p ps=7.38u w=7u l=0.5u
X42 user_project_wrapper_0.IOVSS1 user_project_wrapper_0.sg13g2_IOPadVdd_0.sg13g2_RCClampInverter_noptap_0.out VDD3 user_project_wrapper_0.IOVSS1 sg13_hv_nmos ad=1.408p pd=5.04u as=2.596p ps=5.58u w=4.4u l=0.6u
X43 a_296732_200582# a_301940_196388# a_296625_208423# VDD3 sg13_lv_pmos ad=1.377p pd=8.78u as=0.7695p ps=4.43u w=4.05u l=0.5u
X44 analog_io[20] a_355624_176644# IOVDD3 IOVDD3 sg13_hv_pmos ad=3.9294p pd=7.84u as=2.1312p ps=7.3u w=6.66u l=0.6u
X45 user_project_wrapper_0.analog_io[32] a_202114_326125# user_project_wrapper_0.IOVSS1 user_project_wrapper_0.IOVSS1 sg13_lv_pmos ad=1.824p pd=9.98u as=1.824p ps=9.98u w=9.6u l=0.13u
X46 a_135844_29676# user_project_wrapper_0.IOVSS1 user_project_wrapper_0.IOVSS1 rppd l=3.54u w=0.5u
X47 VDD3 a_309516_194555# a_309917_194695# VDD3 sg13_lv_pmos ad=0.19p pd=1.38u as=0.19p ps=1.38u w=1u l=0.7u
X48 user_project_wrapper_0.IOVDD2 user_project_wrapper_0.sg13g2_IOPadIOVdd_0.sg13g2_Clamp_N43N43D4R_0.gate user_project_wrapper_0.IOVSS1 user_project_wrapper_0.IOVSS1 sg13_hv_nmos ad=2.596p pd=5.58u as=1.408p ps=5.04u w=4.4u l=0.6u
X49 a_82667_125418# a_83490_125209# user_project_wrapper_0.VDD1 user_project_wrapper_0.VDD1 sg13_lv_pmos ad=0.3808p pd=2.92u as=0.3808p ps=2.92u w=1.12u l=0.13u
X50 user_project_wrapper_0.analog_io[30] a_194687_324142# user_project_wrapper_0.IOVSS1 user_project_wrapper_0.IOVSS1 sg13_lv_pmos ad=1.824p pd=9.98u as=1.824p ps=9.98u w=9.6u l=0.13u
X51 a_188184_99046# a_187914_99087# QDLL_TOP_0.VDD QDLL_TOP_0.VDD sg13_lv_pmos ad=0.34p pd=2.68u as=0.1523p ps=1.38u w=1u l=0.5u
X52 a_296731_208493# a_296625_208423# VDD3 VDD3 sg13_lv_pmos ad=0.2603p pd=1.75u as=0.2603p ps=1.75u w=1.37u l=0.35u
X53 user_project_wrapper_0.analog_io[5] a_41476_217444# user_project_wrapper_0.IOVDD1 user_project_wrapper_0.IOVDD1 sg13_hv_pmos ad=3.9294p pd=7.84u as=3.1302p ps=14.26u w=6.66u l=0.6u
X54 user_project_wrapper_0.IOVSS1 user_project_wrapper_0.sg13g2_IOPadIOVdd_1.sg13g2_Clamp_N43N43D4R_0.gate user_project_wrapper_0.IOVDD1 user_project_wrapper_0.IOVSS1 sg13_hv_nmos ad=1.408p pd=5.04u as=2.596p ps=5.58u w=4.4u l=0.6u
X55 user_project_wrapper_0.IOVDD2 user_project_wrapper_0.sg13g2_IOPadIOVdd_0.sg13g2_Clamp_N43N43D4R_0.gate user_project_wrapper_0.IOVSS1 user_project_wrapper_0.IOVSS1 sg13_hv_nmos ad=2.596p pd=5.58u as=1.408p ps=5.04u w=4.4u l=0.6u
X56 user_project_wrapper_0.IOVSS1 user_project_wrapper_0.sg13g2_IOPadVdd_2.sg13g2_RCClampInverter_noptap_0.out user_project_wrapper_0.VDD1 user_project_wrapper_0.IOVSS1 sg13_hv_nmos ad=1.408p pd=5.04u as=2.596p ps=5.58u w=4.4u l=0.6u
X57 analog_io[20] a_355624_156244# IOVDD3 IOVDD3 sg13_hv_pmos ad=3.9294p pd=7.84u as=2.1312p ps=7.3u w=6.66u l=0.6u
X58 user_project_wrapper_0.IOVDD1 user_project_wrapper_0.sg13g2_IOPadIOVdd_1.sg13g2_RCClampResistor_0.p2 user_project_wrapper_0.sg13g2_IOPadIOVdd_1.sg13g2_Clamp_N43N43D4R_0.gate user_project_wrapper_0.IOVDD1 sg13_hv_pmos ad=1.33p pd=7.38u as=1.33p ps=7.38u w=7u l=0.5u
X59 user_project_wrapper_0.IOVSS1 user_project_wrapper_0.sg13g2_IOPadIOVdd_2.sg13g2_Clamp_N43N43D4R_0.gate user_project_wrapper_0.IOVDD4 user_project_wrapper_0.IOVSS1 sg13_hv_nmos ad=1.408p pd=5.04u as=2.596p ps=5.58u w=4.4u l=0.6u
X60 user_project_wrapper_0.analog_io[33] a_237844_355624# user_project_wrapper_0.IOVDD4 user_project_wrapper_0.IOVDD4 sg13_hv_pmos ad=3.9294p pd=7.84u as=2.1312p ps=7.3u w=6.66u l=0.6u
X61 a_202114_326125# a_205385_326221# user_project_wrapper_0.IOVSS1 user_project_wrapper_0.IOVSS1 sg13_lv_pmos ad=1.824p pd=9.98u as=1.824p ps=9.98u w=9.6u l=0.13u
X62 user_project_wrapper_0.sg13g2_IOPadVdd_3.sg13g2_RCClampInverter_noptap_0.out user_project_wrapper_0.sg13g2_IOPadVdd_3.sg13g2_RCClampResistor_0.p2 user_project_wrapper_0.IOVSS1 user_project_wrapper_0.IOVSS1 sg13_hv_nmos ad=1.71p pd=9.38u as=1.71p ps=9.38u w=9u l=0.5u
X63 user_project_wrapper_0.IOVSS1 user_project_wrapper_0.sg13g2_IOPadIOVdd_2.sg13g2_Clamp_N43N43D4R_0.gate user_project_wrapper_0.IOVDD4 user_project_wrapper_0.IOVSS1 sg13_hv_nmos ad=1.408p pd=5.04u as=2.596p ps=5.58u w=4.4u l=0.6u
X64 user_project_wrapper_0.IOVSS1 a_194687_324142# user_project_wrapper_0.analog_io[30] user_project_wrapper_0.IOVSS1 sg13_lv_nmos ad=0.912p pd=5.18u as=0.912p ps=5.18u w=4.8u l=0.13u
X65 user_project_wrapper_0.IOVSS1 user_project_wrapper_0.sg13g2_IOPadIOVdd_2.sg13g2_Clamp_N43N43D4R_0.gate user_project_wrapper_0.IOVDD4 user_project_wrapper_0.IOVSS1 sg13_hv_nmos ad=1.408p pd=5.04u as=2.596p ps=5.58u w=4.4u l=0.6u
X66 user_project_wrapper_0.IOVDD4 a_156244_355624# user_project_wrapper_0.analog_io[29] user_project_wrapper_0.IOVDD4 sg13_hv_pmos ad=2.1312p pd=7.3u as=3.9294p ps=7.84u w=6.66u l=0.6u
X67 IOVDD3 a_355624_197044# analog_io[22] IOVDD3 sg13_hv_pmos ad=2.1312p pd=7.3u as=3.9294p ps=7.84u w=6.66u l=0.6u
X68 analog_io[25] a_355624_258244# IOVDD3 IOVDD3 sg13_hv_pmos ad=3.9294p pd=7.84u as=2.1312p ps=7.3u w=6.66u l=0.6u
X69 a_309917_194695# a_309516_194555# VDD3 VDD3 sg13_lv_pmos ad=0.19p pd=1.38u as=0.19p ps=1.38u w=1u l=0.7u
X70 user_project_wrapper_0.analog_io[4] user_project_wrapper_0.IOVDD1 dpantenna l=27.78u w=1.26u
X71 a_191438_326377# TOP_ROILIFNEURON_0.MEM user_project_wrapper_0.IOVSS1 rppd l=0.5u w=0.5u
X72 QDLL_TOP_0.VOUT a_278644_29676# user_project_wrapper_0.IOVSS1 user_project_wrapper_0.IOVSS1 sg13_hv_nmos ad=2.596p pd=5.58u as=1.408p ps=5.04u w=4.4u l=0.6u
X73 user_project_wrapper_0.analog_io[35] a_278644_355624# user_project_wrapper_0.IOVDD4 user_project_wrapper_0.IOVDD4 sg13_hv_pmos ad=3.9294p pd=7.84u as=2.1312p ps=7.3u w=6.66u l=0.6u
X74 a_210621_325263# a_210417_325263# user_project_wrapper_0.IOVSS1 user_project_wrapper_0.IOVSS1 sg13_lv_nmos ad=0.19p pd=1.38u as=0.34p ps=2.68u w=1u l=0.13u
X75 user_project_wrapper_0.IOVSS1 user_project_wrapper_0.sg13g2_IOPadIOVdd_3.sg13g2_Clamp_N43N43D4R_0.gate IOVDD3 user_project_wrapper_0.IOVSS1 sg13_hv_nmos ad=1.408p pd=5.04u as=2.596p ps=5.58u w=4.4u l=0.6u
X76 user_project_wrapper_0.IOVSS1 user_project_wrapper_0.sg13g2_IOPadVdd_3.sg13g2_RCClampResistor_0.p2 user_project_wrapper_0.sg13g2_IOPadVdd_3.sg13g2_RCClampInverter_noptap_0.out user_project_wrapper_0.IOVSS1 sg13_hv_pmos ad=1.33p pd=7.38u as=1.33p ps=7.38u w=7u l=0.5u
X77 a_304196_200821# a_304889_199957# a_304995_198817# user_project_wrapper_0.IOVSS1 sg13_lv_nmos ad=0.209p pd=1.48u as=0.374p ps=2.88u w=1.1u l=0.15u
X78 user_project_wrapper_0.IOVSS1 user_project_wrapper_0.sg13g2_IOPadIOVdd_3.sg13g2_Clamp_N43N43D4R_0.gate IOVDD3 user_project_wrapper_0.IOVSS1 sg13_hv_nmos ad=1.408p pd=5.04u as=2.596p ps=5.58u w=4.4u l=0.6u
X79 user_project_wrapper_0.analog_io[32] a_217444_355624# user_project_wrapper_0.IOVDD4 user_project_wrapper_0.IOVDD4 sg13_hv_pmos ad=3.9294p pd=7.84u as=3.1302p ps=14.26u w=6.66u l=0.6u
X80 user_project_wrapper_0.IOVSS1 a_213870_324142# user_project_wrapper_0.analog_io[35] user_project_wrapper_0.IOVSS1 sg13_lv_nmos ad=0.912p pd=5.18u as=0.912p ps=5.18u w=4.8u l=0.13u
X81 user_project_wrapper_0.analog_io[6] a_41476_237844# user_project_wrapper_0.IOVDD1 user_project_wrapper_0.IOVDD1 sg13_hv_pmos ad=3.9294p pd=7.84u as=2.1312p ps=7.3u w=6.66u l=0.6u
X82 user_project_wrapper_0.IOVDD2 user_project_wrapper_0.sg13g2_IOPadIOVdd_0.sg13g2_Clamp_N43N43D4R_0.gate user_project_wrapper_0.IOVSS1 user_project_wrapper_0.IOVSS1 sg13_hv_nmos ad=2.596p pd=5.58u as=1.408p ps=5.04u w=4.4u l=0.6u
X83 a_296732_197880# a_301940_196388# a_296625_189595# VDD3 sg13_lv_pmos ad=0.7695p pd=4.43u as=0.7695p ps=4.43u w=4.05u l=0.5u
X84 VDD3 a_296626_197740# a_296732_197880# VDD3 sg13_lv_pmos ad=1.33p pd=7.38u as=1.33p ps=7.38u w=7u l=0.7u
X85 IOVDD3 a_355624_176644# analog_io[20] IOVDD3 sg13_hv_pmos ad=2.1312p pd=7.3u as=3.9294p ps=7.84u w=6.66u l=0.6u
X86 user_project_wrapper_0.sg13g2_IOPadVdd_2.sg13g2_RCClampInverter_noptap_0.out user_project_wrapper_0.sg13g2_IOPadVdd_2.sg13g2_RCClampResistor_0.p2 user_project_wrapper_0.VDD1 user_project_wrapper_0.VDD1 sg13_hv_pmos ad=1.33p pd=7.38u as=1.33p ps=7.38u w=7u l=0.5u
X87 user_project_wrapper_0.IOVSS1 user_project_wrapper_0.sg13g2_IOPadVdd_0.sg13g2_RCClampInverter_noptap_0.out VDD3 user_project_wrapper_0.IOVSS1 sg13_hv_nmos ad=1.408p pd=5.04u as=2.596p ps=5.58u w=4.4u l=0.6u
X88 user_project_wrapper_0.IOVDD1 a_41476_217444# user_project_wrapper_0.analog_io[5] user_project_wrapper_0.IOVDD1 sg13_hv_pmos ad=2.1312p pd=7.3u as=3.9294p ps=7.84u w=6.66u l=0.6u
X89 a_200038_338690# user_project_wrapper_0.sg13g2_IOPadIn$1_2.sg13g2_LevelDown_noptap$1_0.sg13g2_SecondaryProtection$1$1_0.core user_project_wrapper_0.IOVSS1 user_project_wrapper_0.IOVSS1 sg13_hv_nmos ad=0.901p pd=5.98u as=0.901p ps=5.98u w=2.65u l=0.45u
X90 user_project_wrapper_0.IOVSS1 a_208017_327918# a_208469_325785# w_207887_326203# sg13_lv_pmos ad=0.68p pd=4.68u as=0.38p ps=2.38u w=2u l=0.13u
X91 user_project_wrapper_0.IOVDD2 user_project_wrapper_0.sg13g2_IOPadIOVdd_0.sg13g2_Clamp_N43N43D4R_0.gate user_project_wrapper_0.IOVSS1 user_project_wrapper_0.IOVSS1 sg13_hv_nmos ad=2.596p pd=5.58u as=1.408p ps=5.04u w=4.4u l=0.6u
X92 VDD3 a_296625_189595# a_296731_189665# VDD3 sg13_lv_pmos ad=0.2603p pd=1.75u as=0.2603p ps=1.75u w=1.37u l=0.35u
X93 user_project_wrapper_0.analog_io[1] a_41476_135844# user_project_wrapper_0.IOVDD1 user_project_wrapper_0.IOVDD1 sg13_hv_pmos ad=3.9294p pd=7.84u as=2.1312p ps=7.3u w=6.66u l=0.6u
X94 user_project_wrapper_0.IOVDD2 user_project_wrapper_0.sg13g2_IOPadIOVdd_0.sg13g2_Clamp_N43N43D4R_0.gate user_project_wrapper_0.IOVSS1 user_project_wrapper_0.IOVSS1 sg13_hv_nmos ad=2.596p pd=5.58u as=1.408p ps=5.04u w=4.4u l=0.6u
X95 user_project_wrapper_0.IOVDD2 user_project_wrapper_0.sg13g2_IOPadIOVdd_0.sg13g2_Clamp_N43N43D4R_0.gate user_project_wrapper_0.IOVSS1 user_project_wrapper_0.IOVSS1 sg13_hv_nmos ad=2.596p pd=5.58u as=1.408p ps=5.04u w=4.4u l=0.6u
X96 user_project_wrapper_0.IOVDD2 a_258244_41476# user_project_wrapper_0.analog_io[16] user_project_wrapper_0.IOVDD2 sg13_hv_pmos ad=2.1312p pd=7.3u as=3.9294p ps=7.84u w=6.66u l=0.6u
X97 user_project_wrapper_0.VDD1 user_project_wrapper_0.sg13g2_IOPadVdd_2.sg13g2_RCClampInverter_noptap_0.out user_project_wrapper_0.IOVSS1 user_project_wrapper_0.IOVSS1 sg13_hv_nmos ad=2.596p pd=5.58u as=1.408p ps=5.04u w=4.4u l=0.6u
X98 user_project_wrapper_0.IOVSS1 a_188572_99046# a_188760_99480# user_project_wrapper_0.IOVSS1 sg13_lv_nmos ad=0.1323p pd=1.05u as=0.1428p ps=1.52u w=0.42u l=0.13u
X99 user_project_wrapper_0.IOVSS1 a_79038_123516# a_79038_123516# user_project_wrapper_0.IOVSS1 sg13_lv_nmos ad=0.1428p pd=1.52u as=0.1428p ps=1.52u w=0.42u l=0.56u
X100 a_190389_101343# a_189729_101343# user_project_wrapper_0.IOVSS1 user_project_wrapper_0.IOVSS1 sg13_lv_nmos ad=0.1443p pd=1.13u as=0.1406p ps=1.12u w=0.74u l=0.13u
X101 a_309917_199879# a_309516_194555# VDD3 VDD3 sg13_lv_pmos ad=0.19p pd=1.38u as=0.19p ps=1.38u w=1u l=0.7u
X102 a_194687_324142# a_194279_327536# user_project_wrapper_0.IOVSS1 user_project_wrapper_0.IOVSS1 sg13_lv_nmos ad=0.912p pd=5.18u as=0.912p ps=5.18u w=4.8u l=0.13u
X103 VDD3 a_296625_208423# a_296731_208493# VDD3 sg13_lv_pmos ad=0.4658p pd=3.42u as=0.2603p ps=1.75u w=1.37u l=0.35u
X104 user_project_wrapper_0.IOVDD1 a_41476_258244# user_project_wrapper_0.analog_io[7] user_project_wrapper_0.IOVDD1 sg13_hv_pmos ad=2.1312p pd=7.3u as=3.9294p ps=7.84u w=6.66u l=0.6u
X105 user_project_wrapper_0.IOVDD4 a_115444_355624# user_project_wrapper_0.analog_io[27] user_project_wrapper_0.IOVDD4 sg13_hv_pmos ad=2.1312p pd=7.3u as=3.9294p ps=7.84u w=6.66u l=0.6u
X106 user_project_wrapper_0.sg13g2_IOPadOut4mA$1_0.sg13g2_GateLevelUpInv_noptap$1$1_0.pgate user_project_wrapper_0.IOVDD1 dpantenna l=0.48u w=0.48u
X107 analog_io[23] a_355624_217444# IOVDD3 IOVDD3 sg13_hv_pmos ad=3.9294p pd=7.84u as=2.1312p ps=7.3u w=6.66u l=0.6u
X108 user_project_wrapper_0.IOVDD1 user_project_wrapper_0.sg13g2_IOPadIOVdd_1.sg13g2_RCClampResistor_0.p2 user_project_wrapper_0.sg13g2_IOPadIOVdd_1.sg13g2_Clamp_N43N43D4R_0.gate user_project_wrapper_0.IOVDD1 sg13_hv_pmos ad=1.33p pd=7.38u as=1.33p ps=7.38u w=7u l=0.5u
X109 user_project_wrapper_0.IOVSS1 user_project_wrapper_0.IOVSS1 user_project_wrapper_0.IOVSS1 rppd l=0.5u w=0.5u
X110 analog_io[20] IOVDD3 dpantenna l=4.98u w=0.64u
X111 user_project_wrapper_0.analog_io[32] a_202114_326125# user_project_wrapper_0.IOVSS1 user_project_wrapper_0.IOVSS1 sg13_lv_nmos ad=0.912p pd=5.18u as=0.912p ps=5.18u w=4.8u l=0.13u
X112 analog_io[20] a_355624_176644# IOVDD3 IOVDD3 sg13_hv_pmos ad=3.9294p pd=7.84u as=2.1312p ps=7.3u w=6.66u l=0.6u
X113 user_project_wrapper_0.sg13g2_IOPadVdd_3.sg13g2_RCClampInverter_noptap_0.out user_project_wrapper_0.sg13g2_IOPadVdd_3.sg13g2_RCClampResistor_0.p2 user_project_wrapper_0.IOVSS1 user_project_wrapper_0.IOVSS1 sg13_hv_nmos ad=1.71p pd=9.38u as=1.71p ps=9.38u w=9u l=0.5u
X114 a_82859_242012# user_project_wrapper_0.sg13g2_IOPadAnalog_15.padres a_82846_242854# user_project_wrapper_0.VDD1 sg13_lv_pmos ad=0.95p pd=5.38u as=1.7p ps=10.68u w=5u l=0.3u
X115 user_project_wrapper_0.IOVSS1 user_project_wrapper_0.sg13g2_IOPadIOVdd_2.sg13g2_Clamp_N43N43D4R_0.gate user_project_wrapper_0.IOVDD4 user_project_wrapper_0.IOVSS1 sg13_hv_nmos ad=1.408p pd=5.04u as=2.596p ps=5.58u w=4.4u l=0.6u
X116 user_project_wrapper_0.IOVSS1 user_project_wrapper_0.sg13g2_IOPadVdd_3.sg13g2_RCClampInverter_noptap_0.out user_project_wrapper_0.IOVSS1 user_project_wrapper_0.IOVSS1 sg13_hv_nmos ad=1.408p pd=5.04u as=47.82689n ps=0.11865 w=4.4u l=0.6u
X117 VDD3 user_project_wrapper_0.sg13g2_IOPadVdd_0.sg13g2_RCClampInverter_noptap_0.out user_project_wrapper_0.IOVSS1 user_project_wrapper_0.IOVSS1 sg13_hv_nmos ad=2.596p pd=5.58u as=1.408p ps=5.04u w=4.4u l=0.6u
X118 analog_io[20] IOVDD3 dpantenna l=27.78u w=1.26u
X119 a_296731_189665# a_301186_192011# user_project_wrapper_0.IOVSS1 user_project_wrapper_0.IOVSS1 sg13_lv_nmos ad=0.912p pd=5.18u as=0.912p ps=5.18u w=4.8u l=1.06u
X120 user_project_wrapper_0.IOVSS1 user_project_wrapper_0.sg13g2_IOPadVdd_3.sg13g2_RCClampInverter_noptap_0.out user_project_wrapper_0.IOVSS1 user_project_wrapper_0.IOVSS1 sg13_hv_nmos ad=1.408p pd=5.04u as=0 ps=0 w=4.4u l=0.6u
X121 user_project_wrapper_0.IOVSS1 user_project_wrapper_0.IOVSS1 user_project_wrapper_0.IOVSS1 rppd l=0.5u w=0.5u
X122 VDD3 a_296625_208423# a_296731_208493# VDD3 sg13_lv_pmos ad=0.2603p pd=1.75u as=0.2603p ps=1.75u w=1.37u l=0.35u
X123 a_209905_327099# a_208939_326377# user_project_wrapper_0.IOVSS1 user_project_wrapper_0.IOVSS1 sg13_lv_nmos ad=0.19p pd=1.38u as=0.34p ps=2.68u w=1u l=0.13u
X124 user_project_wrapper_0.IOVSS1 a_237844_369296# user_project_wrapper_0.analog_io[33] user_project_wrapper_0.IOVSS1 sg13_hv_nmos ad=1.408p pd=5.04u as=2.596p ps=5.58u w=4.4u l=0.6u
X125 a_82658_129203# a_79025_129571# a_82658_128838# user_project_wrapper_0.IOVSS1 sg13_lv_nmos ad=0.2516p pd=2.16u as=0.1406p ps=1.12u w=0.74u l=0.13u
X126 QDLL_TOP_0.VDD a_189016_101343# a_189148_101407# QDLL_TOP_0.VDD sg13_lv_pmos ad=0.2245p pd=1.53u as=0.445p ps=2.89u w=1u l=0.25u
X127 user_project_wrapper_0.IOVSS1 a_369296_217444# analog_io[23] user_project_wrapper_0.IOVSS1 sg13_hv_nmos ad=1.408p pd=5.04u as=2.596p ps=5.58u w=4.4u l=0.6u
X128 user_project_wrapper_0.analog_io[15] a_237844_41476# user_project_wrapper_0.IOVDD2 user_project_wrapper_0.IOVDD2 sg13_hv_pmos ad=3.9294p pd=7.84u as=2.1312p ps=7.3u w=6.66u l=0.6u
X129 user_project_wrapper_0.IOVSS1 user_project_wrapper_0.sg13g2_IOPadVdd_1.sg13g2_RCClampInverter_noptap_0.out user_project_wrapper_0.VDD2 user_project_wrapper_0.IOVSS1 sg13_hv_nmos ad=1.408p pd=5.04u as=2.596p ps=5.58u w=4.4u l=0.6u
X130 a_309917_199879# a_309516_194555# VDD3 VDD3 sg13_lv_pmos ad=0.19p pd=1.38u as=0.19p ps=1.38u w=1u l=0.7u
X131 a_304196_197873# a_304889_198885# a_304995_198817# user_project_wrapper_0.IOVSS1 sg13_lv_nmos ad=0.209p pd=1.48u as=0.374p ps=2.88u w=1.1u l=0.15u
X132 a_210109_330241# a_208367_329719# a_210007_329719# w_207883_330166# sg13_lv_pmos ad=0.38p pd=2.38u as=0.38p ps=2.38u w=2u l=0.13u
X133 analog_io[19] a_369296_135844# user_project_wrapper_0.IOVSS1 user_project_wrapper_0.IOVSS1 sg13_hv_nmos ad=2.596p pd=5.58u as=2.068p ps=9.74u w=4.4u l=0.6u
X134 a_208939_329719# a_208103_324155# user_project_wrapper_0.IOVSS1 user_project_wrapper_0.IOVSS1 sg13_lv_nmos ad=0.19p pd=1.38u as=0.34p ps=2.68u w=1u l=0.13u
X135 VDD3 a_296625_189595# a_296731_189665# VDD3 sg13_lv_pmos ad=0.2603p pd=1.75u as=0.2603p ps=1.75u w=1.37u l=0.35u
X136 a_309917_194695# a_309516_194555# VDD3 VDD3 sg13_lv_pmos ad=0.19p pd=1.38u as=0.19p ps=1.38u w=1u l=0.7u
X137 user_project_wrapper_0.IOVDD1 user_project_wrapper_0.sg13g2_IOPadIOVdd_1.sg13g2_Clamp_N43N43D4R_0.gate user_project_wrapper_0.IOVSS1 user_project_wrapper_0.IOVSS1 sg13_hv_nmos ad=2.596p pd=5.58u as=1.408p ps=5.04u w=4.4u l=0.6u
X138 user_project_wrapper_0.IOVDD2 user_project_wrapper_0.sg13g2_IOPadIOVdd_0.sg13g2_Clamp_N43N43D4R_0.gate user_project_wrapper_0.IOVSS1 user_project_wrapper_0.IOVSS1 sg13_hv_nmos ad=2.596p pd=5.58u as=1.408p ps=5.04u w=4.4u l=0.6u
X139 user_project_wrapper_0.IOVDD1 user_project_wrapper_0.sg13g2_IOPadIOVdd_1.sg13g2_Clamp_N43N43D4R_0.gate user_project_wrapper_0.IOVSS1 user_project_wrapper_0.IOVSS1 sg13_hv_nmos ad=2.596p pd=5.58u as=1.408p ps=5.04u w=4.4u l=0.6u
X140 a_309917_199879# a_296731_208493# a_307232_196607# VDD3 sg13_lv_pmos ad=0.24415p pd=1.665u as=0.24415p ps=1.665u w=1.285u l=0.35u
X141 a_309917_199879# a_309516_194555# VDD3 VDD3 sg13_lv_pmos ad=0.19p pd=1.38u as=0.19p ps=1.38u w=1u l=0.7u
X142 user_project_wrapper_0.IOVSS1 user_project_wrapper_0.sg13g2_IOPadVdd_0.sg13g2_RCClampInverter_noptap_0.out VDD3 user_project_wrapper_0.IOVSS1 sg13_hv_nmos ad=1.408p pd=5.04u as=2.596p ps=5.58u w=4.4u l=0.6u
X143 a_360372_75025# a_364458_74695# user_project_wrapper_0.IOVSS1 rppd l=20u w=1u
X144 user_project_wrapper_0.analog_io[30] a_194687_324142# user_project_wrapper_0.IOVSS1 user_project_wrapper_0.IOVSS1 sg13_lv_nmos ad=0.912p pd=5.18u as=0.912p ps=5.18u w=4.8u l=0.13u
X145 user_project_wrapper_0.analog_io[15] a_190389_101343# user_project_wrapper_0.IOVSS1 user_project_wrapper_0.IOVSS1 sg13_lv_nmos ad=0.1406p pd=1.12u as=0.1406p ps=1.12u w=0.74u l=0.13u
X146 user_project_wrapper_0.IOVDD1 a_41476_135844# user_project_wrapper_0.analog_io[1] user_project_wrapper_0.IOVDD1 sg13_hv_pmos ad=2.1312p pd=7.3u as=3.9294p ps=7.84u w=6.66u l=0.6u
X147 user_project_wrapper_0.IOVSS1 user_project_wrapper_0.sg13g2_IOPadIOVdd_0.sg13g2_Clamp_N43N43D4R_0.gate user_project_wrapper_0.IOVDD2 user_project_wrapper_0.IOVSS1 sg13_hv_nmos ad=1.408p pd=5.04u as=2.596p ps=5.58u w=4.4u l=0.6u
X148 user_project_wrapper_0.IOVSS1 user_project_wrapper_0.sg13g2_IOPadOut4mA$1_1.c2p a_58798_281951# user_project_wrapper_0.IOVSS1 sg13_lv_nmos ad=0.935p pd=6.18u as=0.935p ps=6.18u w=2.75u l=0.13u
X149 VDD3 a_309516_194555# a_309516_194555# VDD3 sg13_lv_pmos ad=0.19p pd=1.38u as=0.19p ps=1.38u w=1u l=0.7u
X150 VDD3 a_296625_208423# a_296731_208493# VDD3 sg13_lv_pmos ad=0.2603p pd=1.75u as=0.2603p ps=1.75u w=1.37u l=0.35u
X151 user_project_wrapper_0.sg13g2_IOPadVdd_3.sg13g2_RCClampInverter_noptap_0.out user_project_wrapper_0.sg13g2_IOPadVdd_3.sg13g2_RCClampResistor_0.p2 user_project_wrapper_0.IOVSS1 user_project_wrapper_0.IOVSS1 sg13_hv_nmos ad=1.71p pd=9.38u as=1.71p ps=9.38u w=9u l=0.5u
X152 user_project_wrapper_0.sg13g2_IOPadVdd_2.sg13g2_RCClampInverter_noptap_0.out user_project_wrapper_0.sg13g2_IOPadVdd_2.sg13g2_RCClampResistor_0.p2 user_project_wrapper_0.VDD1 user_project_wrapper_0.VDD1 sg13_hv_pmos ad=1.33p pd=7.38u as=1.33p ps=7.38u w=7u l=0.5u
X153 user_project_wrapper_0.IOVSS1 user_project_wrapper_0.analog_io[14] a_190319_97955# user_project_wrapper_0.IOVSS1 sg13_lv_nmos ad=0.15245p pd=1.17u as=0.17462p ps=1.185u w=0.55u l=0.13u
X154 user_project_wrapper_0.IOVSS1 a_314793_201808# a_314793_201808# user_project_wrapper_0.IOVSS1 sg13_lv_nmos ad=1.14p pd=6.38u as=2.04p ps=12.68u w=6u l=6.4u
X155 a_205385_326221# a_206201_328627# user_project_wrapper_0.IOVSS1 user_project_wrapper_0.IOVSS1 sg13_lv_nmos ad=0.912p pd=5.18u as=0.912p ps=5.18u w=4.8u l=0.13u
X156 IOVDD3 a_355624_217444# analog_io[23] IOVDD3 sg13_hv_pmos ad=2.1312p pd=7.3u as=3.9294p ps=7.84u w=6.66u l=0.6u
X157 a_83164_127455# a_82840_127455# user_project_wrapper_0.IOVSS1 user_project_wrapper_0.IOVSS1 sg13_lv_nmos ad=0.1406p pd=1.12u as=0.2516p ps=2.16u w=0.74u l=0.13u
X158 a_311846_195517# user_project_wrapper_0.sg13g2_IOPadAnalog_29.padres a_309917_194695# VDD3 sg13_lv_pmos ad=0.24415p pd=1.665u as=0.24415p ps=1.665u w=1.285u l=0.35u
X159 VDD3 a_296625_208423# a_296731_208493# VDD3 sg13_lv_pmos ad=0.2603p pd=1.75u as=0.2603p ps=1.75u w=1.37u l=0.35u
X160 a_207985_330987# a_208871_330987# user_project_wrapper_0.IOVSS1 rhigh l=4u w=0.5u
X161 a_79025_124824# user_project_wrapper_0.sg13g2_IOPadAnalog_9.padres a_79038_123982# user_project_wrapper_0.VDD1 sg13_lv_pmos ad=1.7p pd=10.68u as=0.95p ps=5.38u w=5u l=0.3u
X162 a_309917_194695# user_project_wrapper_0.sg13g2_IOPadAnalog_29.padres a_311846_195517# VDD3 sg13_lv_pmos ad=0.24415p pd=1.665u as=0.4369p ps=3.25u w=1.285u l=0.35u
X163 user_project_wrapper_0.IOVSS1 user_project_wrapper_0.sg13g2_IOPadVdd_0.sg13g2_RCClampInverter_noptap_0.out VDD3 user_project_wrapper_0.IOVSS1 sg13_hv_nmos ad=1.408p pd=5.04u as=2.596p ps=5.58u w=4.4u l=0.6u
X164 a_355624_115444# IOVDD3 IOVDD3 rppd l=12.9u w=0.5u
X165 analog_io[19] a_355624_135844# IOVDD3 IOVDD3 sg13_hv_pmos ad=3.9294p pd=7.84u as=2.1312p ps=7.3u w=6.66u l=0.6u
X166 a_311189_211724# a_296731_208493# a_313884_211353# user_project_wrapper_0.IOVSS1 sg13_lv_nmos ad=1.9p pd=10.38u as=1.9p ps=10.38u w=10u l=0.5u
X167 user_project_wrapper_0.IOVDD1 user_project_wrapper_0.sg13g2_IOPadIOVdd_1.sg13g2_Clamp_N43N43D4R_0.gate user_project_wrapper_0.IOVSS1 user_project_wrapper_0.IOVSS1 sg13_hv_nmos ad=2.596p pd=5.58u as=1.408p ps=5.04u w=4.4u l=0.6u
X168 user_project_wrapper_0.IOVDD2 a_217444_41476# user_project_wrapper_0.analog_io[14] user_project_wrapper_0.IOVDD2 sg13_hv_pmos ad=2.1312p pd=7.3u as=3.9294p ps=7.84u w=6.66u l=0.6u
X169 user_project_wrapper_0.IOVDD4 a_237844_355624# user_project_wrapper_0.analog_io[33] user_project_wrapper_0.IOVDD4 sg13_hv_pmos ad=2.1312p pd=7.3u as=3.9294p ps=7.84u w=6.66u l=0.6u
X170 QDLL_TOP_0.VDD a_271172_100118# QDLL_TOP_0.VOUT QDLL_TOP_0.VDD sg13_lv_pmos ad=0.2128p pd=1.5u as=0.2128p ps=1.5u w=1.12u l=0.13u
X171 a_309917_199879# a_309516_194555# VDD3 VDD3 sg13_lv_pmos ad=0.19p pd=1.38u as=0.19p ps=1.38u w=1u l=0.7u
X172 a_360372_301405# a_364458_301075# user_project_wrapper_0.IOVSS1 rppd l=20u w=1u
X173 user_project_wrapper_0.IOVSS1 user_project_wrapper_0.sg13g2_IOPadIOVdd_1.sg13g2_Clamp_N43N43D4R_0.gate user_project_wrapper_0.IOVDD1 user_project_wrapper_0.IOVSS1 sg13_hv_nmos ad=1.408p pd=5.04u as=2.596p ps=5.58u w=4.4u l=0.6u
X174 user_project_wrapper_0.IOVSS1 user_project_wrapper_0.sg13g2_IOPadIOVdd_3.sg13g2_Clamp_N43N43D4R_0.gate IOVDD3 user_project_wrapper_0.IOVSS1 sg13_hv_nmos ad=1.408p pd=5.04u as=2.596p ps=5.58u w=4.4u l=0.6u
X175 user_project_wrapper_0.VDD2 user_project_wrapper_0.sg13g2_IOPadVdd_1.sg13g2_RCClampInverter_noptap_0.out user_project_wrapper_0.IOVSS1 user_project_wrapper_0.IOVSS1 sg13_hv_nmos ad=2.596p pd=5.58u as=1.408p ps=5.04u w=4.4u l=0.6u
X176 user_project_wrapper_0.IOVSS1 user_project_wrapper_0.sg13g2_IOPadVdd_1.sg13g2_RCClampInverter_noptap_0.out user_project_wrapper_0.VDD2 user_project_wrapper_0.IOVSS1 sg13_hv_nmos ad=1.408p pd=5.04u as=2.596p ps=5.58u w=4.4u l=0.6u
X177 user_project_wrapper_0.IOVSS1 user_project_wrapper_0.sg13g2_IOPadIOVdd_3.sg13g2_Clamp_N43N43D4R_0.gate IOVDD3 user_project_wrapper_0.IOVSS1 sg13_hv_nmos ad=1.408p pd=5.04u as=2.596p ps=5.58u w=4.4u l=0.6u
X178 a_81295_364458# a_80965_360372# user_project_wrapper_0.IOVSS1 rppd l=20u w=1u
X179 a_194687_324142# a_194279_327536# user_project_wrapper_0.IOVSS1 user_project_wrapper_0.IOVSS1 sg13_lv_pmos ad=1.824p pd=9.98u as=1.824p ps=9.98u w=9.6u l=0.13u
X180 user_project_wrapper_0.IOVSS1 a_156244_369296# user_project_wrapper_0.analog_io[29] user_project_wrapper_0.IOVSS1 sg13_hv_nmos ad=1.408p pd=5.04u as=2.596p ps=5.58u w=4.4u l=0.6u
X181 user_project_wrapper_0.analog_io[28] a_135844_355624# user_project_wrapper_0.IOVDD4 user_project_wrapper_0.IOVDD4 sg13_hv_pmos ad=3.9294p pd=7.84u as=2.1312p ps=7.3u w=6.66u l=0.6u
X182 user_project_wrapper_0.analog_io[6] a_29676_237844# user_project_wrapper_0.IOVSS1 user_project_wrapper_0.IOVSS1 sg13_hv_nmos ad=2.596p pd=5.58u as=1.408p ps=5.04u w=4.4u l=0.6u
X183 user_project_wrapper_0.analog_io[32] a_217444_369296# user_project_wrapper_0.IOVSS1 user_project_wrapper_0.IOVSS1 sg13_hv_nmos ad=2.596p pd=5.58u as=1.408p ps=5.04u w=4.4u l=0.6u
X184 user_project_wrapper_0.analog_io[10] a_135844_29676# user_project_wrapper_0.IOVSS1 user_project_wrapper_0.IOVSS1 sg13_hv_nmos ad=2.596p pd=5.58u as=1.408p ps=5.04u w=4.4u l=0.6u
X185 analog_io[23] a_355624_237844# IOVDD3 IOVDD3 sg13_hv_pmos ad=3.9294p pd=7.84u as=3.1302p ps=14.26u w=6.66u l=0.6u
X186 a_360372_77665# a_364458_77995# user_project_wrapper_0.IOVSS1 rppd l=20u w=1u
X187 user_project_wrapper_0.IOVDD2 a_258244_41476# user_project_wrapper_0.analog_io[16] user_project_wrapper_0.IOVDD2 sg13_hv_pmos ad=2.1312p pd=7.3u as=3.9294p ps=7.84u w=6.66u l=0.6u
X188 user_project_wrapper_0.IOVSS1 user_project_wrapper_0.sg13g2_IOPadVdd_0.sg13g2_RCClampInverter_noptap_0.out VDD3 user_project_wrapper_0.IOVSS1 sg13_hv_nmos ad=1.408p pd=5.04u as=2.596p ps=5.58u w=4.4u l=0.6u
X189 user_project_wrapper_0.VDD1 a_84332_125209# a_91090_127895# user_project_wrapper_0.VDD1 sg13_lv_pmos ad=0.3808p pd=2.92u as=0.2128p ps=1.5u w=1.12u l=0.13u
X190 IOVDD3 user_project_wrapper_0.sg13g2_IOPadIOVdd_3.sg13g2_Clamp_N43N43D4R_0.gate user_project_wrapper_0.IOVSS1 user_project_wrapper_0.IOVSS1 sg13_hv_nmos ad=2.596p pd=5.58u as=1.408p ps=5.04u w=4.4u l=0.6u
X191 user_project_wrapper_0.analog_io[14] a_190389_99046# QDLL_TOP_0.VDD QDLL_TOP_0.VDD sg13_lv_pmos ad=0.2128p pd=1.5u as=0.2128p ps=1.5u w=1.12u l=0.13u
X192 user_project_wrapper_0.analog_io[30] a_194687_324142# user_project_wrapper_0.IOVSS1 user_project_wrapper_0.IOVSS1 sg13_lv_pmos ad=1.824p pd=9.98u as=1.824p ps=9.98u w=9.6u l=0.13u
X193 a_296731_208493# a_296625_208423# VDD3 VDD3 sg13_lv_pmos ad=0.2603p pd=1.75u as=0.2603p ps=1.75u w=1.37u l=0.35u
X194 a_296731_189665# a_296625_189595# VDD3 VDD3 sg13_lv_pmos ad=0.2603p pd=1.75u as=0.2603p ps=1.75u w=1.37u l=0.35u
X195 user_project_wrapper_0.IOVSS1 a_237844_29676# user_project_wrapper_0.analog_io[15] user_project_wrapper_0.IOVSS1 sg13_hv_nmos ad=1.408p pd=5.04u as=2.596p ps=5.58u w=4.4u l=0.6u
X196 user_project_wrapper_0.IOVSS1 user_project_wrapper_0.sg13g2_IOPadVdd_1.sg13g2_RCClampInverter_noptap_0.out user_project_wrapper_0.VDD2 user_project_wrapper_0.IOVSS1 sg13_hv_nmos ad=1.408p pd=5.04u as=2.596p ps=5.58u w=4.4u l=0.6u
X197 analog_io[23] a_355624_217444# IOVDD3 IOVDD3 sg13_hv_pmos ad=3.9294p pd=7.84u as=2.1312p ps=7.3u w=6.66u l=0.6u
X198 user_project_wrapper_0.IOVDD4 a_278644_355624# user_project_wrapper_0.analog_io[35] user_project_wrapper_0.IOVDD4 sg13_hv_pmos ad=2.1312p pd=7.3u as=3.9294p ps=7.84u w=6.66u l=0.6u
X199 user_project_wrapper_0.IOVDD4 user_project_wrapper_0.sg13g2_IOPadIOVdd_2.sg13g2_RCClampResistor_0.p2 user_project_wrapper_0.sg13g2_IOPadIOVdd_2.sg13g2_Clamp_N43N43D4R_0.gate user_project_wrapper_0.IOVDD4 sg13_hv_pmos ad=1.33p pd=7.38u as=1.33p ps=7.38u w=7u l=0.5u
X200 a_208017_326341# user_project_wrapper_0.sg13g2_IOPadAnalog_21.padres user_project_wrapper_0.IOVSS1 user_project_wrapper_0.IOVSS1 sg13_lv_nmos ad=0.34p pd=2.68u as=0.34p ps=2.68u w=1u l=0.13u
X201 a_189609_324119# user_project_wrapper_0.sg13g2_IOPadIn$1_2.p2c a_189737_324155# w_188806_323975# sg13_lv_pmos ad=0.68p pd=4.68u as=0.38p ps=2.38u w=2u l=0.13u
X202 user_project_wrapper_0.IOVSS1 user_project_wrapper_0.sg13g2_IOPadIOVdd_2.sg13g2_Clamp_N43N43D4R_0.gate user_project_wrapper_0.IOVDD4 user_project_wrapper_0.IOVSS1 sg13_hv_nmos ad=1.408p pd=5.04u as=2.596p ps=5.58u w=4.4u l=0.6u
X203 a_35456_299755# a_39542_300085# user_project_wrapper_0.IOVSS1 rppd l=20u w=1u
X204 user_project_wrapper_0.sg13g2_IOPadIOVdd_0.sg13g2_Clamp_N43N43D4R_0.gate user_project_wrapper_0.sg13g2_IOPadIOVdd_0.sg13g2_RCClampResistor_0.p2 user_project_wrapper_0.IOVDD2 user_project_wrapper_0.IOVDD2 sg13_hv_pmos ad=1.33p pd=7.38u as=1.33p ps=7.38u w=7u l=0.5u
X205 a_313884_185173# analog_io[20] a_311108_179669# user_project_wrapper_0.IOVSS1 sg13_lv_nmos ad=1.9p pd=10.38u as=1.9p ps=10.38u w=10u l=0.5u
X206 user_project_wrapper_0.IOVSS1 user_project_wrapper_0.IOVSS1 user_project_wrapper_0.IOVSS1 rppd l=0.5u w=0.5u
X207 user_project_wrapper_0.IOVSS1 user_project_wrapper_0.sg13g2_IOPadIOVdd_0.sg13g2_Clamp_N43N43D4R_0.gate user_project_wrapper_0.IOVDD2 user_project_wrapper_0.IOVSS1 sg13_hv_nmos ad=1.408p pd=5.04u as=2.596p ps=5.58u w=4.4u l=0.6u
X208 a_85435_125173# a_85257_125209# user_project_wrapper_0.IOVSS1 user_project_wrapper_0.IOVSS1 sg13_lv_nmos ad=0.1406p pd=1.12u as=0.2516p ps=2.16u w=0.74u l=0.13u
X209 a_89114_129426# a_88274_129426# user_project_wrapper_0.VDD1 user_project_wrapper_0.VDD1 sg13_lv_pmos ad=0.2128p pd=1.5u as=0.3808p ps=2.92u w=1.12u l=0.13u
X210 a_296625_189595# a_304090_197941# a_304196_197873# user_project_wrapper_0.IOVSS1 sg13_lv_nmos ad=0.361p pd=2.28u as=0.361p ps=2.28u w=1.9u l=0.16u
X211 VDD3 user_project_wrapper_0.sg13g2_IOPadVdd_0.sg13g2_RCClampInverter_noptap_0.out user_project_wrapper_0.IOVSS1 user_project_wrapper_0.IOVSS1 sg13_hv_nmos ad=2.596p pd=5.58u as=1.408p ps=5.04u w=4.4u l=0.6u
X212 user_project_wrapper_0.analog_io[27] a_182931_326125# user_project_wrapper_0.IOVSS1 user_project_wrapper_0.IOVSS1 sg13_lv_nmos ad=0.912p pd=5.18u as=0.912p ps=5.18u w=4.8u l=0.13u
X213 user_project_wrapper_0.IOVSS1 a_307232_196607# a_304995_198817# user_project_wrapper_0.IOVSS1 sg13_lv_nmos ad=0.6327p pd=3.71u as=0.6327p ps=3.71u w=3.33u l=0.2u
X214 a_296625_208423# a_304090_197941# a_304196_200821# user_project_wrapper_0.IOVSS1 sg13_lv_nmos ad=0.361p pd=2.28u as=0.361p ps=2.28u w=1.9u l=0.16u
X215 user_project_wrapper_0.sg13g2_IOPadVdd_0.sg13g2_RCClampInverter_noptap_0.out user_project_wrapper_0.sg13g2_IOPadVdd_0.sg13g2_RCClampResistor_0.p2 VDD3 VDD3 sg13_hv_pmos ad=1.33p pd=7.38u as=1.33p ps=7.38u w=7u l=0.5u
X216 a_296731_189665# a_296625_189595# VDD3 VDD3 sg13_lv_pmos ad=0.2603p pd=1.75u as=0.2603p ps=1.75u w=1.37u l=0.35u
X217 user_project_wrapper_0.IOVSS1 user_project_wrapper_0.sg13g2_IOPadIOVdd_0.sg13g2_Clamp_N43N43D4R_0.gate user_project_wrapper_0.IOVDD2 user_project_wrapper_0.IOVSS1 sg13_hv_nmos ad=1.408p pd=5.04u as=2.596p ps=5.58u w=4.4u l=0.6u
X218 a_304196_197873# a_304889_198885# a_304995_198817# user_project_wrapper_0.IOVSS1 sg13_lv_nmos ad=0.209p pd=1.48u as=0.209p ps=1.48u w=1.1u l=0.15u
X219 user_project_wrapper_0.IOVSS1 user_project_wrapper_0.IOVSS1 user_project_wrapper_0.IOVSS1 rppd l=0.5u w=0.5u
X220 user_project_wrapper_0.IOVSS1 user_project_wrapper_0.sg13g2_IOPadIOVdd_0.sg13g2_Clamp_N43N43D4R_0.gate user_project_wrapper_0.IOVDD2 user_project_wrapper_0.IOVSS1 sg13_hv_nmos ad=1.408p pd=5.04u as=2.596p ps=5.58u w=4.4u l=0.6u
X221 a_296731_189665# a_296625_189595# VDD3 VDD3 sg13_lv_pmos ad=0.2603p pd=1.75u as=0.2603p ps=1.75u w=1.37u l=0.35u
X222 user_project_wrapper_0.IOVSS1 user_project_wrapper_0.sg13g2_IOPadIOVdd_3.sg13g2_Clamp_N43N43D4R_0.gate IOVDD3 user_project_wrapper_0.IOVSS1 sg13_hv_nmos ad=1.408p pd=5.04u as=2.596p ps=5.58u w=4.4u l=0.6u
X223 user_project_wrapper_0.IOVSS1 user_project_wrapper_0.analog_io[15] dantenna l=1.26u w=27.78u
X224 IOVDD3 a_355624_135844# analog_io[19] IOVDD3 sg13_hv_pmos ad=3.1302p pd=14.26u as=3.9294p ps=7.84u w=6.66u l=0.6u
X225 VDD3 a_309516_194555# a_309917_194695# VDD3 sg13_lv_pmos ad=0.19p pd=1.38u as=0.19p ps=1.38u w=1u l=0.7u
X226 user_project_wrapper_0.analog_io[30] a_194687_324142# user_project_wrapper_0.IOVSS1 user_project_wrapper_0.IOVSS1 sg13_lv_pmos ad=1.824p pd=9.98u as=1.824p ps=9.98u w=9.6u l=0.13u
X227 a_210417_325263# a_210007_325263# user_project_wrapper_0.IOVSS1 user_project_wrapper_0.IOVSS1 sg13_lv_nmos ad=0.34p pd=2.68u as=0.34p ps=2.68u w=1u l=0.13u
X228 user_project_wrapper_0.IOVDD4 a_156244_355624# user_project_wrapper_0.analog_io[29] user_project_wrapper_0.IOVDD4 sg13_hv_pmos ad=2.1312p pd=7.3u as=3.9294p ps=7.84u w=6.66u l=0.6u
X229 user_project_wrapper_0.sg13g2_IOPadVdd_2.sg13g2_RCClampInverter_noptap_0.out user_project_wrapper_0.sg13g2_IOPadVdd_2.sg13g2_RCClampResistor_0.p2 user_project_wrapper_0.VDD1 user_project_wrapper_0.VDD1 sg13_hv_pmos ad=1.33p pd=7.38u as=1.33p ps=7.38u w=7u l=0.5u
X230 a_296732_200582# a_301940_196388# a_296625_208423# VDD3 sg13_lv_pmos ad=0.7695p pd=4.43u as=0.7695p ps=4.43u w=4.05u l=0.5u
X231 a_296731_208493# a_296625_208423# VDD3 VDD3 sg13_lv_pmos ad=0.2603p pd=1.75u as=0.2603p ps=1.75u w=1.37u l=0.35u
X232 a_296731_189665# a_296625_189595# VDD3 VDD3 sg13_lv_pmos ad=0.2603p pd=1.75u as=0.2603p ps=1.75u w=1.37u l=0.35u
X233 user_project_wrapper_0.VDD1 user_project_wrapper_0.sg13g2_IOPadIn$1_1.p2c a_85591_241748# user_project_wrapper_0.VDD1 sg13_lv_pmos ad=0.3808p pd=2.92u as=0.2128p ps=1.5u w=1.12u l=0.13u
X234 user_project_wrapper_0.IOVDD4 a_258244_355624# user_project_wrapper_0.analog_io[34] user_project_wrapper_0.IOVDD4 sg13_hv_pmos ad=2.1312p pd=7.3u as=3.9294p ps=7.84u w=6.66u l=0.6u
X235 user_project_wrapper_0.analog_io[29] user_project_wrapper_0.IOVDD4 dpantenna l=1.26u w=27.78u
X236 user_project_wrapper_0.sg13g2_IOPadVdd_3.sg13g2_RCClampInverter_noptap_0.out user_project_wrapper_0.sg13g2_IOPadVdd_3.sg13g2_RCClampResistor_0.p2 user_project_wrapper_0.IOVSS1 user_project_wrapper_0.IOVSS1 sg13_hv_nmos ad=1.71p pd=9.38u as=1.71p ps=9.38u w=9u l=0.5u
X237 a_202114_326125# a_205385_326221# user_project_wrapper_0.IOVSS1 user_project_wrapper_0.IOVSS1 sg13_lv_pmos ad=1.824p pd=9.98u as=1.824p ps=9.98u w=9.6u l=0.13u
X238 user_project_wrapper_0.IOVSS1 user_project_wrapper_0.sg13g2_IOPadIOVdd_1.sg13g2_Clamp_N43N43D4R_0.gate user_project_wrapper_0.IOVDD1 user_project_wrapper_0.IOVSS1 sg13_hv_nmos ad=1.408p pd=5.04u as=2.596p ps=5.58u w=4.4u l=0.6u
X239 user_project_wrapper_0.IOVSS1 user_project_wrapper_0.sg13g2_IOPadVdd_1.sg13g2_RCClampInverter_noptap_0.out user_project_wrapper_0.VDD2 user_project_wrapper_0.IOVSS1 sg13_hv_nmos ad=1.408p pd=5.04u as=2.596p ps=5.58u w=4.4u l=0.6u
X240 user_project_wrapper_0.IOVSS1 a_270178_100118# a_270512_100118# user_project_wrapper_0.IOVSS1 sg13_lv_nmos ad=0.1406p pd=1.12u as=0.1406p ps=1.12u w=0.74u l=0.13u
X241 IOVDD3 a_355624_237844# analog_io[23] IOVDD3 sg13_hv_pmos ad=2.1312p pd=7.3u as=3.9294p ps=7.84u w=6.66u l=0.6u
X242 analog_io[20] a_355624_156244# IOVDD3 IOVDD3 sg13_hv_pmos ad=3.9294p pd=7.84u as=2.1312p ps=7.3u w=6.66u l=0.6u
X243 a_296731_189665# a_296625_189595# VDD3 VDD3 sg13_lv_pmos ad=0.2603p pd=1.75u as=0.2603p ps=1.75u w=1.37u l=0.35u
X244 VDD3 a_296625_189595# a_296731_189665# VDD3 sg13_lv_pmos ad=0.4658p pd=3.42u as=0.2603p ps=1.75u w=1.37u l=0.35u
X245 user_project_wrapper_0.IOVSS1 a_307232_196607# a_304995_198817# user_project_wrapper_0.IOVSS1 sg13_lv_nmos ad=0.6327p pd=3.71u as=1.1322p ps=7.34u w=3.33u l=0.2u
X246 a_186430_102197# a_185968_102197# QDLL_TOP_0.VDD QDLL_TOP_0.VDD sg13_lv_pmos ad=0.7616p pd=5.16u as=0.7616p ps=5.16u w=2.24u l=0.13u
X247 a_189016_99480# a_188760_99480# QDLL_TOP_0.VDD QDLL_TOP_0.VDD sg13_lv_pmos ad=0.34p pd=2.68u as=0.2481p ps=1.56u w=1u l=0.25u
X248 a_208367_325263# user_project_wrapper_0.IOVSS1 user_project_wrapper_0.IOVSS1 w_207887_326203# sg13_lv_pmos ad=0.38p pd=2.38u as=0.68p ps=4.68u w=2u l=0.13u
X249 user_project_wrapper_0.analog_io[32] a_202114_326125# user_project_wrapper_0.IOVSS1 user_project_wrapper_0.IOVSS1 sg13_lv_nmos ad=0.912p pd=5.18u as=0.912p ps=5.18u w=4.8u l=0.13u
X250 a_311189_211724# a_311189_211724# VDD3 VDD3 sg13_lv_pmos ad=1.9p pd=10.38u as=1.9p ps=10.38u w=10u l=1u
X251 user_project_wrapper_0.VDD2 user_project_wrapper_0.sg13g2_IOPadVdd_1.sg13g2_RCClampInverter_noptap_0.out user_project_wrapper_0.IOVSS1 user_project_wrapper_0.IOVSS1 sg13_hv_nmos ad=2.596p pd=5.58u as=1.408p ps=5.04u w=4.4u l=0.6u
X252 a_296731_208493# a_296625_208423# VDD3 VDD3 sg13_lv_pmos ad=0.2603p pd=1.75u as=0.2603p ps=1.75u w=1.37u l=0.35u
X253 user_project_wrapper_0.IOVSS1 user_project_wrapper_0.IOVSS1 user_project_wrapper_0.IOVSS1 rhigh l=0.96u w=0.5u
X254 a_209684_328605# a_208367_328605# user_project_wrapper_0.IOVSS1 w_207887_327938# sg13_lv_pmos ad=0.68p pd=4.68u as=0.68p ps=4.68u w=2u l=0.13u
X255 VDD3 a_309516_194555# a_309917_194695# VDD3 sg13_lv_pmos ad=0.19p pd=1.38u as=0.19p ps=1.38u w=1u l=0.7u
X256 a_82645_242401# a_82645_242401# user_project_wrapper_0.VDD1 user_project_wrapper_0.VDD1 sg13_lv_pmos ad=0.95p pd=5.38u as=1.7p ps=10.68u w=5u l=0.15u
X257 user_project_wrapper_0.IOVSS1 user_project_wrapper_0.sg13g2_IOPadIOVdd_0.sg13g2_Clamp_N43N43D4R_0.gate user_project_wrapper_0.IOVDD2 user_project_wrapper_0.IOVSS1 sg13_hv_nmos ad=1.408p pd=5.04u as=2.596p ps=5.58u w=4.4u l=0.6u
X258 a_190389_101343# a_189729_101343# user_project_wrapper_0.IOVSS1 user_project_wrapper_0.IOVSS1 sg13_lv_nmos ad=0.1406p pd=1.12u as=0.1406p ps=1.12u w=0.74u l=0.13u
X259 a_296731_189665# a_301186_192011# user_project_wrapper_0.IOVSS1 user_project_wrapper_0.IOVSS1 sg13_lv_nmos ad=0.912p pd=5.18u as=0.912p ps=5.18u w=4.8u l=1.06u
X260 user_project_wrapper_0.IOVSS1 user_project_wrapper_0.IOVDD4 dpantenna l=27.78u w=1.26u
X261 user_project_wrapper_0.IOVSS1 a_301186_192011# a_296731_189665# user_project_wrapper_0.IOVSS1 sg13_lv_nmos ad=0.912p pd=5.18u as=0.912p ps=5.18u w=4.8u l=1.06u
X262 user_project_wrapper_0.IOVDD2 a_197044_41476# user_project_wrapper_0.analog_io[13] user_project_wrapper_0.IOVDD2 sg13_hv_pmos ad=2.1312p pd=7.3u as=3.9294p ps=7.84u w=6.66u l=0.6u
X263 user_project_wrapper_0.analog_io[14] a_190389_99046# QDLL_TOP_0.VDD QDLL_TOP_0.VDD sg13_lv_pmos ad=0.2128p pd=1.5u as=0.4368p ps=3.02u w=1.12u l=0.13u
X264 user_project_wrapper_0.IOVSS1 user_project_wrapper_0.sg13g2_IOPadVdd_2.sg13g2_RCClampResistor_0.p2 user_project_wrapper_0.IOVSS1 user_project_wrapper_0.IOVSS1 sg13_hv_nmos ad=1.71p pd=9.38u as=0 ps=0 w=9u l=9.5u
X265 VDD3 a_296625_189595# a_296731_189665# VDD3 sg13_lv_pmos ad=0.2603p pd=1.75u as=0.2603p ps=1.75u w=1.37u l=0.35u
X266 a_314793_197200# a_314697_196700# VDD3 VDD3 sg13_lv_pmos ad=1.14p pd=6.38u as=2.04p ps=12.68u w=6u l=2.5u
X267 IOVDD3 user_project_wrapper_0.sg13g2_IOPadIOVdd_3.sg13g2_Clamp_N43N43D4R_0.gate user_project_wrapper_0.IOVSS1 user_project_wrapper_0.IOVSS1 sg13_hv_nmos ad=2.596p pd=5.58u as=1.408p ps=5.04u w=4.4u l=0.6u
X268 user_project_wrapper_0.IOVDD4 a_156244_355624# user_project_wrapper_0.analog_io[29] user_project_wrapper_0.IOVDD4 sg13_hv_pmos ad=3.1302p pd=14.26u as=3.9294p ps=7.84u w=6.66u l=0.6u
X269 VDD3 a_309516_194555# a_309917_194695# VDD3 sg13_lv_pmos ad=0.19p pd=1.38u as=0.19p ps=1.38u w=1u l=0.7u
X270 a_309917_194695# a_309516_194555# VDD3 VDD3 sg13_lv_pmos ad=0.19p pd=1.38u as=0.19p ps=1.38u w=1u l=0.7u
X271 user_project_wrapper_0.IOVDD1 user_project_wrapper_0.sg13g2_IOPadIOVdd_1.sg13g2_Clamp_N43N43D4R_0.gate user_project_wrapper_0.IOVSS1 user_project_wrapper_0.IOVSS1 sg13_hv_nmos ad=2.596p pd=5.58u as=1.408p ps=5.04u w=4.4u l=0.6u
X272 a_208792_324119# user_project_wrapper_0.sg13g2_IOPadIn$1_2.p2c a_208920_324155# w_207989_323975# sg13_lv_pmos ad=0.68p pd=4.68u as=0.38p ps=2.38u w=2u l=0.13u
X273 QDLL_TOP_0.VDD a_270512_100118# a_271172_100118# QDLL_TOP_0.VDD sg13_lv_pmos ad=0.2128p pd=1.5u as=0.2128p ps=1.5u w=1.12u l=0.13u
X274 VDD3 a_309516_194555# a_309917_199879# VDD3 sg13_lv_pmos ad=0.19p pd=1.38u as=0.19p ps=1.38u w=1u l=0.7u
X275 user_project_wrapper_0.sg13g2_IOPadIOVdd_0.sg13g2_Clamp_N43N43D4R_0.gate user_project_wrapper_0.sg13g2_IOPadIOVdd_0.sg13g2_RCClampResistor_0.p2 user_project_wrapper_0.IOVDD2 user_project_wrapper_0.IOVDD2 sg13_hv_pmos ad=1.33p pd=7.38u as=1.33p ps=7.38u w=7u l=0.5u
X276 user_project_wrapper_0.IOVSS1 user_project_wrapper_0.IOVSS1 user_project_wrapper_0.IOVSS1 rppd l=0.5u w=0.5u
X277 user_project_wrapper_0.sg13g2_IOPadVdd_3.sg13g2_RCClampInverter_noptap_0.out user_project_wrapper_0.sg13g2_IOPadVdd_3.sg13g2_RCClampResistor_0.p2 user_project_wrapper_0.IOVSS1 user_project_wrapper_0.IOVSS1 sg13_hv_pmos ad=1.33p pd=7.38u as=1.33p ps=7.38u w=7u l=0.5u
X278 user_project_wrapper_0.IOVSS1 user_project_wrapper_0.IOVSS1 user_project_wrapper_0.IOVSS1 rhigh l=0.96u w=0.5u
X279 user_project_wrapper_0.IOVSS1 user_project_wrapper_0.sg13g2_IOPadVdd_2.sg13g2_RCClampInverter_noptap_0.out user_project_wrapper_0.VDD1 user_project_wrapper_0.IOVSS1 sg13_hv_nmos ad=1.408p pd=5.04u as=2.596p ps=5.58u w=4.4u l=0.6u
X280 user_project_wrapper_0.analog_io[7] a_41476_258244# user_project_wrapper_0.IOVDD1 user_project_wrapper_0.IOVDD1 sg13_hv_pmos ad=3.9294p pd=7.84u as=2.1312p ps=7.3u w=6.66u l=0.6u
X281 VDD3 user_project_wrapper_0.sg13g2_IOPadVdd_0.sg13g2_RCClampInverter_noptap_0.out user_project_wrapper_0.IOVSS1 user_project_wrapper_0.IOVSS1 sg13_hv_nmos ad=2.596p pd=5.58u as=2.068p ps=9.74u w=4.4u l=0.6u
X282 VDD3 a_296625_208423# a_296731_208493# VDD3 sg13_lv_pmos ad=0.4658p pd=3.42u as=0.2603p ps=1.75u w=1.37u l=0.35u
X283 user_project_wrapper_0.VDD2 user_project_wrapper_0.sg13g2_IOPadVdd_1.sg13g2_RCClampInverter_noptap_0.out user_project_wrapper_0.IOVSS1 user_project_wrapper_0.IOVSS1 sg13_hv_nmos ad=3.256p pd=10.28u as=1.408p ps=5.04u w=4.4u l=0.6u
X284 IOVDD3 a_355624_135844# analog_io[19] IOVDD3 sg13_hv_pmos ad=2.1312p pd=7.3u as=3.9294p ps=7.84u w=6.66u l=0.6u
X285 IOVDD3 a_355624_156244# analog_io[20] IOVDD3 sg13_hv_pmos ad=2.1312p pd=7.3u as=3.9294p ps=7.84u w=6.66u l=0.6u
X286 user_project_wrapper_0.IOVSS1 user_project_wrapper_0.sg13g2_IOPadIOVdd_1.sg13g2_Clamp_N43N43D4R_0.gate user_project_wrapper_0.IOVDD1 user_project_wrapper_0.IOVSS1 sg13_hv_nmos ad=1.408p pd=5.04u as=2.596p ps=5.58u w=4.4u l=0.6u
X287 user_project_wrapper_0.analog_io[32] a_217444_355624# user_project_wrapper_0.IOVDD4 user_project_wrapper_0.IOVDD4 sg13_hv_pmos ad=3.9294p pd=7.84u as=2.1312p ps=7.3u w=6.66u l=0.6u
X288 a_314697_196700# a_314793_201808# a_315347_192648# user_project_wrapper_0.IOVSS1 sg13_lv_nmos ad=2.04p pd=12.68u as=1.14p ps=6.38u w=6u l=6.4u
X289 user_project_wrapper_0.analog_io[30] a_194687_324142# user_project_wrapper_0.IOVSS1 user_project_wrapper_0.IOVSS1 sg13_lv_nmos ad=0.912p pd=5.18u as=0.912p ps=5.18u w=4.8u l=0.13u
X290 user_project_wrapper_0.analog_io[5] a_29676_217444# user_project_wrapper_0.IOVSS1 user_project_wrapper_0.IOVSS1 sg13_hv_nmos ad=2.596p pd=5.58u as=1.408p ps=5.04u w=4.4u l=0.6u
X291 IOVDD3 a_355624_258244# analog_io[25] IOVDD3 sg13_hv_pmos ad=2.1312p pd=7.3u as=3.9294p ps=7.84u w=6.66u l=0.6u
X292 user_project_wrapper_0.analog_io[15] a_237844_29676# user_project_wrapper_0.IOVSS1 user_project_wrapper_0.IOVSS1 sg13_hv_nmos ad=2.596p pd=5.58u as=1.408p ps=5.04u w=4.4u l=0.6u
X293 user_project_wrapper_0.IOVSS1 a_217444_369296# user_project_wrapper_0.analog_io[32] user_project_wrapper_0.IOVSS1 sg13_hv_nmos ad=1.408p pd=5.04u as=2.596p ps=5.58u w=4.4u l=0.6u
X294 user_project_wrapper_0.IOVSS1 user_project_wrapper_0.IOVSS1 user_project_wrapper_0.IOVSS1 rppd l=0.5u w=0.5u
X295 a_83164_127820# a_82840_127455# user_project_wrapper_0.VDD1 user_project_wrapper_0.VDD1 sg13_lv_pmos ad=0.2128p pd=1.5u as=0.3808p ps=2.92u w=1.12u l=0.13u
X296 user_project_wrapper_0.IOVSS1 user_project_wrapper_0.sg13g2_IOPadIOVdd_3.sg13g2_Clamp_N43N43D4R_0.gate IOVDD3 user_project_wrapper_0.IOVSS1 sg13_hv_nmos ad=1.408p pd=5.04u as=2.596p ps=5.58u w=4.4u l=0.6u
X297 user_project_wrapper_0.IOVDD4 a_135844_355624# user_project_wrapper_0.analog_io[28] user_project_wrapper_0.IOVDD4 sg13_hv_pmos ad=2.1312p pd=7.3u as=3.9294p ps=7.84u w=6.66u l=0.6u
X298 VDD3 a_296625_189595# a_296731_189665# VDD3 sg13_lv_pmos ad=0.2603p pd=1.75u as=0.2603p ps=1.75u w=1.37u l=0.35u
X299 a_205385_326221# a_206201_328627# user_project_wrapper_0.IOVSS1 user_project_wrapper_0.IOVSS1 sg13_lv_nmos ad=0.912p pd=5.18u as=0.912p ps=5.18u w=4.8u l=0.13u
X300 user_project_wrapper_0.IOVDD1 a_41476_115444# user_project_wrapper_0.analog_io[0] user_project_wrapper_0.IOVDD1 sg13_hv_pmos ad=2.1312p pd=7.3u as=3.9294p ps=7.84u w=6.66u l=0.6u
X301 VDD3 a_296625_208423# a_296731_208493# VDD3 sg13_lv_pmos ad=0.2603p pd=1.75u as=0.2603p ps=1.75u w=1.37u l=0.35u
X302 user_project_wrapper_0.IOVSS1 user_project_wrapper_0.sg13g2_IOPadAnalog_28.padres dantenna l=0.64u w=3.1u
X303 QDLL_TOP_0.VDD a_271172_100118# QDLL_TOP_0.VOUT QDLL_TOP_0.VDD sg13_lv_pmos ad=0.2128p pd=1.5u as=0.2128p ps=1.5u w=1.12u l=0.13u
X304 a_309516_194555# a_309516_194555# VDD3 VDD3 sg13_lv_pmos ad=0.19p pd=1.38u as=0.19p ps=1.38u w=1u l=0.7u
X305 user_project_wrapper_0.IOVSS1 a_301186_192011# a_296731_208493# user_project_wrapper_0.IOVSS1 sg13_lv_nmos ad=0.912p pd=5.18u as=0.912p ps=5.18u w=4.8u l=1.06u
X306 user_project_wrapper_0.IOVSS1 a_369296_197044# analog_io[22] user_project_wrapper_0.IOVSS1 sg13_hv_nmos ad=1.408p pd=5.04u as=2.596p ps=5.58u w=4.4u l=0.6u
X307 analog_io[25] a_369296_258244# user_project_wrapper_0.IOVSS1 user_project_wrapper_0.IOVSS1 sg13_hv_nmos ad=2.596p pd=5.58u as=1.408p ps=5.04u w=4.4u l=0.6u
X308 user_project_wrapper_0.analog_io[32] a_202114_326125# user_project_wrapper_0.IOVSS1 user_project_wrapper_0.IOVSS1 sg13_lv_pmos ad=1.824p pd=9.98u as=1.824p ps=9.98u w=9.6u l=0.13u
X309 user_project_wrapper_0.IOVSS1 a_194279_327536# a_194687_324142# user_project_wrapper_0.IOVSS1 sg13_lv_nmos ad=0.912p pd=5.18u as=0.912p ps=5.18u w=4.8u l=0.13u
X310 user_project_wrapper_0.VDD1 user_project_wrapper_0.sg13g2_IOPadVdd_2.sg13g2_RCClampInverter_noptap_0.out user_project_wrapper_0.IOVSS1 user_project_wrapper_0.IOVSS1 sg13_hv_nmos ad=2.596p pd=5.58u as=1.408p ps=5.04u w=4.4u l=0.6u
X311 user_project_wrapper_0.IOVSS1 user_project_wrapper_0.sg13g2_IOPadVdd_3.sg13g2_RCClampInverter_noptap_0.out user_project_wrapper_0.IOVSS1 user_project_wrapper_0.IOVSS1 sg13_hv_nmos ad=1.408p pd=5.04u as=0 ps=0 w=4.4u l=0.6u
X312 user_project_wrapper_0.IOVDD2 a_217444_41476# user_project_wrapper_0.analog_io[14] user_project_wrapper_0.IOVDD2 sg13_hv_pmos ad=2.1312p pd=7.3u as=3.9294p ps=7.84u w=6.66u l=0.6u
X313 user_project_wrapper_0.IOVSS1 a_202114_326125# user_project_wrapper_0.analog_io[32] user_project_wrapper_0.IOVSS1 sg13_lv_nmos ad=0.912p pd=5.18u as=0.912p ps=5.18u w=4.8u l=0.13u
X314 user_project_wrapper_0.IOVSS1 user_project_wrapper_0.sg13g2_IOPadVdd_3.sg13g2_RCClampInverter_noptap_0.out user_project_wrapper_0.IOVSS1 user_project_wrapper_0.IOVSS1 sg13_hv_nmos ad=1.408p pd=5.04u as=0 ps=0 w=4.4u l=0.6u
X315 user_project_wrapper_0.IOVSS1 a_301186_192011# a_296731_208493# user_project_wrapper_0.IOVSS1 sg13_lv_nmos ad=0.912p pd=5.18u as=0.912p ps=5.18u w=4.8u l=1.06u
X316 QDLL_TOP_0.VOUT user_project_wrapper_0.sg13g2_IOPadAnalog_6.padres a_186430_98275# QDLL_TOP_0.VDD sg13_lv_pmos ad=1.5164p pd=9.6u as=1.5164p ps=9.6u w=4.46u l=0.13u
X317 user_project_wrapper_0.analog_io[28] a_135844_355624# user_project_wrapper_0.IOVDD4 user_project_wrapper_0.IOVDD4 sg13_hv_pmos ad=3.9294p pd=7.84u as=3.1302p ps=14.26u w=6.66u l=0.6u
X318 user_project_wrapper_0.IOVSS1 a_258244_29676# user_project_wrapper_0.analog_io[16] user_project_wrapper_0.IOVSS1 sg13_hv_nmos ad=1.408p pd=5.04u as=2.596p ps=5.58u w=4.4u l=0.6u
X319 user_project_wrapper_0.IOVSS1 a_29676_217444# user_project_wrapper_0.analog_io[5] user_project_wrapper_0.IOVSS1 sg13_hv_nmos ad=1.408p pd=5.04u as=2.596p ps=5.58u w=4.4u l=0.6u
X320 a_307232_196607# a_296731_189665# a_309917_194695# VDD3 sg13_lv_pmos ad=0.24415p pd=1.665u as=0.24415p ps=1.665u w=1.285u l=0.35u
X321 user_project_wrapper_0.IOVDD4 a_115444_355624# user_project_wrapper_0.analog_io[27] user_project_wrapper_0.IOVDD4 sg13_hv_pmos ad=2.1312p pd=7.3u as=3.9294p ps=7.84u w=6.66u l=0.6u
X322 user_project_wrapper_0.IOVSS1 user_project_wrapper_0.sg13g2_IOPadVdd_3.sg13g2_RCClampInverter_noptap_0.out user_project_wrapper_0.IOVSS1 user_project_wrapper_0.IOVSS1 sg13_hv_nmos ad=1.408p pd=5.04u as=0 ps=0 w=4.4u l=0.6u
X323 user_project_wrapper_0.analog_io[1] a_29676_135844# user_project_wrapper_0.IOVSS1 user_project_wrapper_0.IOVSS1 sg13_hv_nmos ad=2.596p pd=5.58u as=1.408p ps=5.04u w=4.4u l=0.6u
X324 VDD3 user_project_wrapper_0.sg13g2_IOPadVdd_0.sg13g2_RCClampInverter_noptap_0.out user_project_wrapper_0.IOVSS1 user_project_wrapper_0.IOVSS1 sg13_hv_nmos ad=2.596p pd=5.58u as=1.408p ps=5.04u w=4.4u l=0.6u
X325 user_project_wrapper_0.analog_io[0] a_41476_115444# user_project_wrapper_0.IOVDD1 user_project_wrapper_0.IOVDD1 sg13_hv_pmos ad=3.9294p pd=7.84u as=2.1312p ps=7.3u w=6.66u l=0.6u
X326 a_304995_198817# a_304889_199957# a_304196_200821# user_project_wrapper_0.IOVSS1 sg13_lv_nmos ad=0.374p pd=2.88u as=0.209p ps=1.48u w=1.1u l=0.15u
X327 a_208469_328013# a_208367_328605# a_208367_327491# w_207887_327938# sg13_lv_pmos ad=0.38p pd=2.38u as=0.38p ps=2.38u w=2u l=0.13u
X328 user_project_wrapper_0.analog_io[27] a_182931_326125# user_project_wrapper_0.IOVSS1 user_project_wrapper_0.IOVSS1 sg13_lv_nmos ad=0.912p pd=5.18u as=0.912p ps=5.18u w=4.8u l=0.13u
X329 user_project_wrapper_0.analog_io[1] a_41476_135844# user_project_wrapper_0.IOVDD1 user_project_wrapper_0.IOVDD1 sg13_hv_pmos ad=3.9294p pd=7.84u as=2.1312p ps=7.3u w=6.66u l=0.6u
X330 IOVDD3 a_355624_197044# analog_io[22] IOVDD3 sg13_hv_pmos ad=2.1312p pd=7.3u as=3.9294p ps=7.84u w=6.66u l=0.6u
X331 user_project_wrapper_0.IOVSS1 user_project_wrapper_0.IOVSS1 user_project_wrapper_0.IOVSS1 rhigh l=4u w=0.5u
X332 user_project_wrapper_0.analog_io[30] a_194687_324142# user_project_wrapper_0.IOVSS1 user_project_wrapper_0.IOVSS1 sg13_lv_pmos ad=1.824p pd=9.98u as=1.824p ps=9.98u w=9.6u l=0.13u
X333 user_project_wrapper_0.IOVDD1 user_project_wrapper_0.sg13g2_IOPadIOVdd_1.sg13g2_RCClampResistor_0.p2 user_project_wrapper_0.sg13g2_IOPadIOVdd_1.sg13g2_Clamp_N43N43D4R_0.gate user_project_wrapper_0.IOVDD1 sg13_hv_pmos ad=1.33p pd=7.38u as=1.33p ps=7.38u w=7u l=0.5u
X334 user_project_wrapper_0.IOVSS1 a_191234_325263# a_191438_325263# w_188704_326203# sg13_lv_pmos ad=0.38p pd=2.38u as=0.38p ps=2.38u w=2u l=0.13u
X335 a_304995_198817# a_304889_198885# a_304196_197873# user_project_wrapper_0.IOVSS1 sg13_lv_nmos ad=0.209p pd=1.48u as=0.209p ps=1.48u w=1.1u l=0.15u
X336 a_296731_189665# a_296625_189595# VDD3 VDD3 sg13_lv_pmos ad=0.2603p pd=1.75u as=0.2603p ps=1.75u w=1.37u l=0.35u
X337 a_79975_364458# a_79645_360372# user_project_wrapper_0.IOVSS1 rppd l=20u w=1u
X338 user_project_wrapper_0.analog_io[32] a_217444_355624# user_project_wrapper_0.IOVDD4 user_project_wrapper_0.IOVDD4 sg13_hv_pmos ad=3.9294p pd=7.84u as=2.1312p ps=7.3u w=6.66u l=0.6u
X339 analog_io[20] a_369296_176644# user_project_wrapper_0.IOVSS1 user_project_wrapper_0.IOVSS1 sg13_hv_nmos ad=2.596p pd=5.58u as=1.408p ps=5.04u w=4.4u l=0.6u
X340 user_project_wrapper_0.IOVSS1 user_project_wrapper_0.analog_io[13] dantenna l=3.1u w=0.64u
X341 VDD3 a_309516_194555# a_309917_194695# VDD3 sg13_lv_pmos ad=0.19p pd=1.38u as=0.19p ps=1.38u w=1u l=0.7u
X342 user_project_wrapper_0.analog_io[5] a_29676_217444# user_project_wrapper_0.IOVSS1 user_project_wrapper_0.IOVSS1 sg13_hv_nmos ad=2.596p pd=5.58u as=1.408p ps=5.04u w=4.4u l=0.6u
X343 user_project_wrapper_0.IOVSS1 a_189672_324776# a_192138_324119# w_188806_323975# sg13_lv_pmos ad=0.68p pd=4.68u as=0.68p ps=4.68u w=2u l=0.65u
X344 a_188920_324155# a_188988_324119# user_project_wrapper_0.IOVSS1 user_project_wrapper_0.IOVSS1 sg13_lv_nmos ad=0.19p pd=1.38u as=0.19p ps=1.38u w=1u l=0.13u
X345 a_86594_127896# a_83492_127455# a_86594_127531# user_project_wrapper_0.IOVSS1 sg13_lv_nmos ad=0.2516p pd=2.16u as=0.1406p ps=1.12u w=0.74u l=0.13u
X346 a_309917_199879# a_309516_194555# VDD3 VDD3 sg13_lv_pmos ad=0.19p pd=1.38u as=0.19p ps=1.38u w=1u l=0.7u
X347 VDD3 a_309516_194555# a_309917_199879# VDD3 sg13_lv_pmos ad=0.19p pd=1.38u as=0.19p ps=1.38u w=1u l=0.7u
X348 user_project_wrapper_0.IOVSS1 a_301186_192011# a_296731_189665# user_project_wrapper_0.IOVSS1 sg13_lv_nmos ad=0.912p pd=5.18u as=0.912p ps=5.18u w=4.8u l=1.06u
X349 user_project_wrapper_0.IOVSS1 user_project_wrapper_0.sg13g2_IOPadIOVdd_1.sg13g2_RCClampResistor_0.p2 user_project_wrapper_0.IOVSS1 user_project_wrapper_0.IOVSS1 sg13_hv_nmos ad=3.06p pd=18.68u as=0 ps=0 w=9u l=9.5u
X350 user_project_wrapper_0.analog_io[28] a_135844_355624# user_project_wrapper_0.IOVDD4 user_project_wrapper_0.IOVDD4 sg13_hv_pmos ad=3.9294p pd=7.84u as=2.1312p ps=7.3u w=6.66u l=0.6u
X351 user_project_wrapper_0.IOVSS1 user_project_wrapper_0.sg13g2_IOPadVdd_0.sg13g2_RCClampInverter_noptap_0.out VDD3 user_project_wrapper_0.IOVSS1 sg13_hv_nmos ad=1.408p pd=5.04u as=2.596p ps=5.58u w=4.4u l=0.6u
X352 user_project_wrapper_0.analog_io[32] a_217444_369296# user_project_wrapper_0.IOVSS1 user_project_wrapper_0.IOVSS1 sg13_hv_nmos ad=2.596p pd=5.58u as=1.408p ps=5.04u w=4.4u l=0.6u
X353 user_project_wrapper_0.IOVSS1 analog_io[20] dantenna l=27.78u w=1.26u
X354 a_189858_330241# a_189756_325263# a_189756_329719# w_188700_330166# sg13_lv_pmos ad=0.38p pd=2.38u as=0.38p ps=2.38u w=2u l=0.13u
X355 user_project_wrapper_0.analog_io[32] a_202114_326125# user_project_wrapper_0.IOVSS1 user_project_wrapper_0.IOVSS1 sg13_lv_nmos ad=0.912p pd=5.18u as=0.912p ps=5.18u w=4.8u l=0.13u
X356 user_project_wrapper_0.sg13g2_IOPadAnalog_17.padres a_189688_330987# user_project_wrapper_0.IOVSS1 rhigh l=4u w=0.5u
X357 a_296731_189665# a_301186_192011# user_project_wrapper_0.IOVSS1 user_project_wrapper_0.IOVSS1 sg13_lv_nmos ad=0.912p pd=5.18u as=0.912p ps=5.18u w=4.8u l=1.06u
X358 a_296731_208493# a_296625_208423# VDD3 VDD3 sg13_lv_pmos ad=0.2603p pd=1.75u as=0.2603p ps=1.75u w=1.37u l=0.35u
X359 a_209480_328605# a_208939_328605# user_project_wrapper_0.IOVSS1 w_207887_327938# sg13_lv_pmos ad=0.68p pd=4.68u as=0.68p ps=4.68u w=2u l=0.13u
X360 user_project_wrapper_0.IOVSS1 user_project_wrapper_0.sg13g2_IOPadVdd_1.sg13g2_RCClampInverter_noptap_0.out user_project_wrapper_0.VDD2 user_project_wrapper_0.IOVSS1 sg13_hv_nmos ad=1.408p pd=5.04u as=2.596p ps=5.58u w=4.4u l=0.6u
X361 user_project_wrapper_0.analog_io[27] a_182931_326125# user_project_wrapper_0.IOVSS1 user_project_wrapper_0.IOVSS1 sg13_lv_nmos ad=0.912p pd=5.18u as=0.912p ps=5.18u w=4.8u l=0.13u
X362 user_project_wrapper_0.analog_io[13] a_197044_41476# user_project_wrapper_0.IOVDD2 user_project_wrapper_0.IOVDD2 sg13_hv_pmos ad=3.9294p pd=7.84u as=2.1312p ps=7.3u w=6.66u l=0.6u
X363 a_296625_208423# a_304090_197941# a_304196_200821# user_project_wrapper_0.IOVSS1 sg13_lv_nmos ad=0.361p pd=2.28u as=0.646p ps=4.48u w=1.9u l=0.16u
X364 user_project_wrapper_0.analog_io[6] a_41476_237844# user_project_wrapper_0.IOVDD1 user_project_wrapper_0.IOVDD1 sg13_hv_pmos ad=3.9294p pd=7.84u as=2.1312p ps=7.3u w=6.66u l=0.6u
X365 user_project_wrapper_0.sg13g2_IOPadIOVdd_0.sg13g2_Clamp_N43N43D4R_0.gate user_project_wrapper_0.sg13g2_IOPadIOVdd_0.sg13g2_RCClampResistor_0.p2 user_project_wrapper_0.IOVDD2 user_project_wrapper_0.IOVDD2 sg13_hv_pmos ad=1.33p pd=7.38u as=1.33p ps=7.38u w=7u l=0.5u
X366 user_project_wrapper_0.IOVSS1 a_29676_135844# user_project_wrapper_0.analog_io[1] user_project_wrapper_0.IOVSS1 sg13_hv_nmos ad=2.068p pd=9.74u as=2.596p ps=5.58u w=4.4u l=0.6u
X367 a_296731_189665# a_296625_189595# VDD3 VDD3 sg13_lv_pmos ad=0.2603p pd=1.75u as=0.4658p ps=3.42u w=1.37u l=0.35u
X368 user_project_wrapper_0.sg13g2_IOPadVdd_3.sg13g2_RCClampInverter_noptap_0.out user_project_wrapper_0.sg13g2_IOPadVdd_3.sg13g2_RCClampResistor_0.p2 user_project_wrapper_0.IOVSS1 user_project_wrapper_0.IOVSS1 sg13_hv_pmos ad=1.33p pd=7.38u as=1.33p ps=7.38u w=7u l=0.5u
X369 user_project_wrapper_0.IOVDD2 a_258244_41476# user_project_wrapper_0.analog_io[16] user_project_wrapper_0.IOVDD2 sg13_hv_pmos ad=2.1312p pd=7.3u as=3.9294p ps=7.84u w=6.66u l=0.6u
X370 user_project_wrapper_0.IOVSS1 user_project_wrapper_0.sg13g2_IOPadVdd_3.sg13g2_RCClampInverter_noptap_0.out user_project_wrapper_0.IOVSS1 user_project_wrapper_0.IOVSS1 sg13_hv_nmos ad=1.408p pd=5.04u as=0 ps=0 w=4.4u l=0.6u
X371 user_project_wrapper_0.IOVDD4 a_217444_355624# user_project_wrapper_0.analog_io[32] user_project_wrapper_0.IOVDD4 sg13_hv_pmos ad=2.1312p pd=7.3u as=3.9294p ps=7.84u w=6.66u l=0.6u
X372 QDLL_TOP_0.CPIN a_190319_97955# a_190490_98199# QDLL_TOP_0.VDD sg13_lv_pmos ad=0.3808p pd=2.92u as=0.2128p ps=1.5u w=1.12u l=0.13u
X373 user_project_wrapper_0.analog_io[28] user_project_wrapper_0.IOVDD4 dpantenna l=1.26u w=27.78u
X374 user_project_wrapper_0.analog_io[34] a_258244_369296# user_project_wrapper_0.IOVSS1 user_project_wrapper_0.IOVSS1 sg13_hv_nmos ad=2.596p pd=5.58u as=1.408p ps=5.04u w=4.4u l=0.6u
X375 user_project_wrapper_0.IOVDD2 a_217444_41476# user_project_wrapper_0.analog_io[14] user_project_wrapper_0.IOVDD2 sg13_hv_pmos ad=2.1312p pd=7.3u as=3.9294p ps=7.84u w=6.66u l=0.6u
X376 user_project_wrapper_0.IOVSS1 a_307232_196607# a_304995_198817# user_project_wrapper_0.IOVSS1 sg13_lv_nmos ad=0.6327p pd=3.71u as=0.6327p ps=3.71u w=3.33u l=0.2u
X377 a_296731_208493# a_296625_208423# VDD3 VDD3 sg13_lv_pmos ad=0.2603p pd=1.75u as=0.2603p ps=1.75u w=1.37u l=0.35u
X378 user_project_wrapper_0.IOVSS1 user_project_wrapper_0.sg13g2_IOPadIOVdd_1.sg13g2_RCClampResistor_0.p2 user_project_wrapper_0.IOVSS1 user_project_wrapper_0.IOVSS1 sg13_hv_nmos ad=3.06p pd=18.68u as=0 ps=0 w=9u l=9.5u
X379 a_156244_29676# user_project_wrapper_0.IOVSS1 user_project_wrapper_0.IOVSS1 rppd l=3.54u w=0.5u
X380 user_project_wrapper_0.IOVSS1 a_208792_324119# a_208579_324119# w_207989_323975# sg13_lv_pmos ad=0.38p pd=2.38u as=0.68p ps=4.68u w=2u l=0.13u
X381 QDLL_TOP_0.VDD a_270512_100118# a_271172_100118# QDLL_TOP_0.VDD sg13_lv_pmos ad=0.2128p pd=1.5u as=0.2128p ps=1.5u w=1.12u l=0.13u
X382 analog_io[26] a_355624_278644# IOVDD3 IOVDD3 sg13_hv_pmos ad=3.9294p pd=7.84u as=2.1312p ps=7.3u w=6.66u l=0.6u
X383 a_79025_129571# a_78824_128711# user_project_wrapper_0.VDD1 user_project_wrapper_0.VDD1 sg13_lv_pmos ad=1.7p pd=10.68u as=1.7p ps=10.68u w=5u l=0.15u
X384 a_296731_208493# a_296625_208423# VDD3 VDD3 sg13_lv_pmos ad=0.2603p pd=1.75u as=0.2603p ps=1.75u w=1.37u l=0.35u
X385 a_309917_194695# user_project_wrapper_0.sg13g2_IOPadAnalog_29.padres a_311846_195517# VDD3 sg13_lv_pmos ad=0.24415p pd=1.665u as=0.24415p ps=1.665u w=1.285u l=0.35u
X386 a_313884_211353# a_296731_208493# a_311189_211724# user_project_wrapper_0.IOVSS1 sg13_lv_nmos ad=1.9p pd=10.38u as=1.9p ps=10.38u w=10u l=0.5u
X387 user_project_wrapper_0.IOVSS1 a_197044_29676# user_project_wrapper_0.analog_io[13] user_project_wrapper_0.IOVSS1 sg13_hv_nmos ad=1.408p pd=5.04u as=2.596p ps=5.58u w=4.4u l=0.6u
X388 VDD3 a_296625_189595# a_296731_189665# VDD3 sg13_lv_pmos ad=0.2603p pd=1.75u as=0.2603p ps=1.75u w=1.37u l=0.35u
X389 user_project_wrapper_0.analog_io[11] a_156244_41476# user_project_wrapper_0.IOVDD2 user_project_wrapper_0.IOVDD2 sg13_hv_pmos ad=3.9294p pd=7.84u as=2.1312p ps=7.3u w=6.66u l=0.6u
X390 a_296731_208493# a_296625_208423# VDD3 VDD3 sg13_lv_pmos ad=0.2603p pd=1.75u as=0.4658p ps=3.42u w=1.37u l=0.35u
X391 a_209041_325263# a_208939_326377# a_208939_325263# user_project_wrapper_0.IOVSS1 sg13_lv_nmos ad=0.19p pd=1.38u as=0.19p ps=1.38u w=1u l=0.13u
X392 user_project_wrapper_0.IOVDD4 a_156244_355624# user_project_wrapper_0.analog_io[29] user_project_wrapper_0.IOVDD4 sg13_hv_pmos ad=2.1312p pd=7.3u as=3.9294p ps=7.84u w=6.66u l=0.6u
X393 user_project_wrapper_0.IOVDD2 user_project_wrapper_0.sg13g2_IOPadIOVdd_0.sg13g2_Clamp_N43N43D4R_0.gate user_project_wrapper_0.IOVSS1 user_project_wrapper_0.IOVSS1 sg13_hv_nmos ad=3.256p pd=10.28u as=1.408p ps=5.04u w=4.4u l=0.6u
X394 user_project_wrapper_0.analog_io[32] a_202114_326125# user_project_wrapper_0.IOVSS1 user_project_wrapper_0.IOVSS1 sg13_lv_nmos ad=0.912p pd=5.18u as=0.912p ps=5.18u w=4.8u l=0.13u
X395 user_project_wrapper_0.IOVDD4 a_258244_355624# user_project_wrapper_0.analog_io[34] user_project_wrapper_0.IOVDD4 sg13_hv_pmos ad=2.1312p pd=7.3u as=3.9294p ps=7.84u w=6.66u l=0.6u
X396 a_93400_129062# a_92512_129426# a_93298_129062# user_project_wrapper_0.IOVSS1 sg13_lv_nmos ad=0.1406p pd=1.12u as=0.1406p ps=1.12u w=0.74u l=0.13u
X397 user_project_wrapper_0.IOVSS1 a_210417_325263# a_210621_325263# w_207887_326203# sg13_lv_pmos ad=0.38p pd=2.38u as=0.38p ps=2.38u w=2u l=0.13u
X398 user_project_wrapper_0.analog_io[28] a_135844_369296# user_project_wrapper_0.IOVSS1 user_project_wrapper_0.IOVSS1 sg13_hv_nmos ad=2.596p pd=5.58u as=1.408p ps=5.04u w=4.4u l=0.6u
X399 user_project_wrapper_0.IOVDD1 a_41476_197044# user_project_wrapper_0.analog_io[4] user_project_wrapper_0.IOVDD1 sg13_hv_pmos ad=2.1312p pd=7.3u as=3.9294p ps=7.84u w=6.66u l=0.6u
X400 user_project_wrapper_0.analog_io[27] a_182931_326125# user_project_wrapper_0.IOVSS1 user_project_wrapper_0.IOVSS1 sg13_lv_pmos ad=1.824p pd=9.98u as=1.824p ps=9.98u w=9.6u l=0.13u
X401 user_project_wrapper_0.IOVSS1 user_project_wrapper_0.sg13g2_IOPadIOVdd_3.sg13g2_Clamp_N43N43D4R_0.gate IOVDD3 user_project_wrapper_0.IOVSS1 sg13_hv_nmos ad=1.408p pd=5.04u as=2.596p ps=5.58u w=4.4u l=0.6u
X402 VDD3 a_309516_194555# a_309516_194555# VDD3 sg13_lv_pmos ad=0.19p pd=1.38u as=0.19p ps=1.38u w=1u l=0.7u
X403 a_304995_198817# a_304889_198885# a_304196_197873# user_project_wrapper_0.IOVSS1 sg13_lv_nmos ad=0.374p pd=2.88u as=0.209p ps=1.48u w=1.1u l=0.15u
X404 user_project_wrapper_0.IOVDD2 user_project_wrapper_0.sg13g2_IOPadIOVdd_0.sg13g2_Clamp_N43N43D4R_0.gate user_project_wrapper_0.IOVSS1 user_project_wrapper_0.IOVSS1 sg13_hv_nmos ad=2.596p pd=5.58u as=1.408p ps=5.04u w=4.4u l=0.6u
X405 user_project_wrapper_0.IOVSS1 a_311846_195517# a_311846_195517# user_project_wrapper_0.IOVSS1 sg13_lv_nmos ad=0.6327p pd=3.71u as=1.1322p ps=7.34u w=3.33u l=0.2u
X406 user_project_wrapper_0.IOVSS1 user_project_wrapper_0.sg13g2_IOPadVdd_3.sg13g2_RCClampInverter_noptap_0.out user_project_wrapper_0.IOVSS1 user_project_wrapper_0.IOVSS1 sg13_hv_nmos ad=2.596p pd=5.58u as=0 ps=0 w=4.4u l=0.6u
X407 VDD3 a_296625_208423# a_296731_208493# VDD3 sg13_lv_pmos ad=0.4658p pd=3.42u as=0.2603p ps=1.75u w=1.37u l=0.35u
X408 user_project_wrapper_0.IOVDD1 a_41476_237844# user_project_wrapper_0.analog_io[6] user_project_wrapper_0.IOVDD1 sg13_hv_pmos ad=3.1302p pd=14.26u as=3.9294p ps=7.84u w=6.66u l=0.6u
X409 user_project_wrapper_0.IOVSS1 user_project_wrapper_0.sg13g2_IOPadVdd_1.sg13g2_RCClampInverter_noptap_0.out user_project_wrapper_0.VDD2 user_project_wrapper_0.IOVSS1 sg13_hv_nmos ad=1.408p pd=5.04u as=2.596p ps=5.58u w=4.4u l=0.6u
X410 analog_io[20] a_311108_179669# VDD3 user_project_wrapper_0.IOVSS1 sg13_lv_nmos ad=3.4p pd=20.68u as=3.4p ps=20.68u w=10u l=0.15u
X411 a_190722_325263# a_189756_325263# user_project_wrapper_0.IOVSS1 user_project_wrapper_0.IOVSS1 sg13_lv_nmos ad=0.19p pd=1.38u as=0.34p ps=2.68u w=1u l=0.13u
X412 a_299095_364458# a_298765_360372# user_project_wrapper_0.IOVSS1 rppd l=20u w=1u
X413 user_project_wrapper_0.IOVSS1 a_369296_258244# analog_io[25] user_project_wrapper_0.IOVSS1 sg13_hv_nmos ad=1.408p pd=5.04u as=2.596p ps=5.58u w=4.4u l=0.6u
X414 user_project_wrapper_0.sg13g2_IOPadVdd_0.sg13g2_RCClampInverter_noptap_0.out user_project_wrapper_0.sg13g2_IOPadVdd_0.sg13g2_RCClampResistor_0.p2 VDD3 VDD3 sg13_hv_pmos ad=1.33p pd=7.38u as=1.33p ps=7.38u w=7u l=0.5u
X415 a_360372_74365# a_364458_74695# user_project_wrapper_0.IOVSS1 rppd l=20u w=1u
X416 user_project_wrapper_0.IOVSS1 user_project_wrapper_0.sg13g2_IOPadIOVdd_0.sg13g2_Clamp_N43N43D4R_0.gate user_project_wrapper_0.IOVDD2 user_project_wrapper_0.IOVSS1 sg13_hv_nmos ad=1.408p pd=5.04u as=2.596p ps=5.58u w=4.4u l=0.6u
X417 a_35456_298435# a_39542_298765# user_project_wrapper_0.IOVSS1 rppd l=20u w=1u
X418 user_project_wrapper_0.analog_io[15] a_237844_41476# user_project_wrapper_0.IOVDD2 user_project_wrapper_0.IOVDD2 sg13_hv_pmos ad=3.9294p pd=7.84u as=2.1312p ps=7.3u w=6.66u l=0.6u
X419 user_project_wrapper_0.IOVDD1 user_project_wrapper_0.sg13g2_IOPadIOVdd_1.sg13g2_Clamp_N43N43D4R_0.gate user_project_wrapper_0.IOVSS1 user_project_wrapper_0.IOVSS1 sg13_hv_nmos ad=2.596p pd=5.58u as=1.408p ps=5.04u w=4.4u l=0.6u
X420 user_project_wrapper_0.analog_io[32] a_202114_326125# user_project_wrapper_0.IOVSS1 user_project_wrapper_0.IOVSS1 sg13_lv_pmos ad=1.824p pd=9.98u as=1.824p ps=9.98u w=9.6u l=0.13u
X421 user_project_wrapper_0.sg13g2_IOPadIOVdd_0.sg13g2_Clamp_N43N43D4R_0.gate user_project_wrapper_0.sg13g2_IOPadIOVdd_0.sg13g2_RCClampResistor_0.p2 user_project_wrapper_0.IOVDD2 user_project_wrapper_0.IOVDD2 sg13_hv_pmos ad=1.33p pd=7.38u as=1.33p ps=7.38u w=7u l=0.5u
X422 a_296625_208423# a_304090_197941# a_304196_200821# user_project_wrapper_0.IOVSS1 sg13_lv_nmos ad=0.361p pd=2.28u as=0.361p ps=2.28u w=1.9u l=0.16u
X423 user_project_wrapper_0.IOVSS1 a_194279_327536# a_194687_324142# user_project_wrapper_0.IOVSS1 sg13_lv_nmos ad=0.912p pd=5.18u as=0.912p ps=5.18u w=4.8u l=0.13u
X424 user_project_wrapper_0.VDD1 user_project_wrapper_0.sg13g2_IOPadVdd_2.sg13g2_RCClampInverter_noptap_0.out user_project_wrapper_0.IOVSS1 user_project_wrapper_0.IOVSS1 sg13_hv_nmos ad=2.596p pd=5.58u as=1.408p ps=5.04u w=4.4u l=0.6u
X425 VDD3 a_311108_215937# analog_io[23] user_project_wrapper_0.IOVSS1 sg13_lv_nmos ad=3.4p pd=20.68u as=3.4p ps=20.68u w=10u l=0.15u
X426 a_35456_77995# a_39542_78325# user_project_wrapper_0.IOVSS1 rppd l=20u w=1u
X427 user_project_wrapper_0.analog_io[0] a_41476_115444# user_project_wrapper_0.IOVDD1 user_project_wrapper_0.IOVDD1 sg13_hv_pmos ad=3.9294p pd=7.84u as=2.1312p ps=7.3u w=6.66u l=0.6u
X428 user_project_wrapper_0.VDD1 user_project_wrapper_0.sg13g2_IOPadVdd_2.sg13g2_RCClampInverter_noptap_0.out user_project_wrapper_0.IOVSS1 user_project_wrapper_0.IOVSS1 sg13_hv_nmos ad=3.256p pd=10.28u as=1.408p ps=5.04u w=4.4u l=0.6u
X429 user_project_wrapper_0.sg13g2_IOPadVdd_0.sg13g2_RCClampInverter_noptap_0.out user_project_wrapper_0.sg13g2_IOPadVdd_0.sg13g2_RCClampResistor_0.p2 VDD3 VDD3 sg13_hv_pmos ad=1.33p pd=7.38u as=1.33p ps=7.38u w=7u l=0.5u
X430 user_project_wrapper_0.IOVDD2 a_278644_41476# QDLL_TOP_0.VOUT user_project_wrapper_0.IOVDD2 sg13_hv_pmos ad=2.1312p pd=7.3u as=3.9294p ps=7.84u w=6.66u l=0.6u
X431 user_project_wrapper_0.IOVSS1 a_213870_324142# user_project_wrapper_0.analog_io[35] user_project_wrapper_0.IOVSS1 sg13_lv_pmos ad=1.824p pd=9.98u as=1.824p ps=9.98u w=9.6u l=0.13u
X432 user_project_wrapper_0.VDD1 a_82645_242401# a_82645_242401# user_project_wrapper_0.VDD1 sg13_lv_pmos ad=1.7p pd=10.68u as=0.95p ps=5.38u w=5u l=0.15u
X433 user_project_wrapper_0.IOVSS1 a_29676_258244# user_project_wrapper_0.analog_io[7] user_project_wrapper_0.IOVSS1 sg13_hv_nmos ad=1.408p pd=5.04u as=2.596p ps=5.58u w=4.4u l=0.6u
X434 user_project_wrapper_0.IOVSS1 a_202114_326125# user_project_wrapper_0.analog_io[32] user_project_wrapper_0.IOVSS1 sg13_lv_nmos ad=0.912p pd=5.18u as=0.912p ps=5.18u w=4.8u l=0.13u
X435 user_project_wrapper_0.IOVSS1 user_project_wrapper_0.sg13g2_IOPadVdd_3.sg13g2_RCClampInverter_noptap_0.out user_project_wrapper_0.IOVSS1 user_project_wrapper_0.IOVSS1 sg13_hv_nmos ad=2.068p pd=9.74u as=0 ps=0 w=4.4u l=0.6u
X436 user_project_wrapper_0.analog_io[33] a_237844_355624# user_project_wrapper_0.IOVDD4 user_project_wrapper_0.IOVDD4 sg13_hv_pmos ad=3.9294p pd=7.84u as=2.1312p ps=7.3u w=6.66u l=0.6u
X437 a_191438_327491# a_191234_327491# user_project_wrapper_0.IOVSS1 w_188704_327938# sg13_lv_pmos ad=0.68p pd=4.68u as=0.38p ps=2.38u w=2u l=0.13u
X438 user_project_wrapper_0.IOVSS1 user_project_wrapper_0.sg13g2_IOPadIOVdd_0.sg13g2_Clamp_N43N43D4R_0.gate user_project_wrapper_0.IOVDD2 user_project_wrapper_0.IOVSS1 sg13_hv_nmos ad=1.408p pd=5.04u as=2.596p ps=5.58u w=4.4u l=0.6u
X439 user_project_wrapper_0.IOVDD1 user_project_wrapper_0.sg13g2_IOPadIOVdd_1.sg13g2_RCClampResistor_0.p2 user_project_wrapper_0.sg13g2_IOPadIOVdd_1.sg13g2_Clamp_N43N43D4R_0.gate user_project_wrapper_0.IOVDD1 sg13_hv_pmos ad=1.33p pd=7.38u as=1.33p ps=7.38u w=7u l=0.5u
X440 VDD3 a_296625_189595# a_296731_189665# VDD3 sg13_lv_pmos ad=0.2603p pd=1.75u as=0.2603p ps=1.75u w=1.37u l=0.35u
X441 a_296731_208493# a_301186_192011# user_project_wrapper_0.IOVSS1 user_project_wrapper_0.IOVSS1 sg13_lv_nmos ad=0.912p pd=5.18u as=1.632p ps=10.28u w=4.8u l=1.06u
X442 user_project_wrapper_0.IOVSS1 user_project_wrapper_0.IOVSS1 user_project_wrapper_0.IOVSS1 rppd l=0.5u w=0.5u
X443 user_project_wrapper_0.IOVDD4 a_217444_355624# user_project_wrapper_0.analog_io[32] user_project_wrapper_0.IOVDD4 sg13_hv_pmos ad=2.1312p pd=7.3u as=3.9294p ps=7.84u w=6.66u l=0.6u
X444 user_project_wrapper_0.analog_io[30] a_176644_355624# user_project_wrapper_0.IOVDD4 user_project_wrapper_0.IOVDD4 sg13_hv_pmos ad=3.9294p pd=7.84u as=2.1312p ps=7.3u w=6.66u l=0.6u
X445 user_project_wrapper_0.IOVDD1 user_project_wrapper_0.sg13g2_IOPadIOVdd_1.sg13g2_Clamp_N43N43D4R_0.gate user_project_wrapper_0.IOVSS1 user_project_wrapper_0.IOVSS1 sg13_hv_nmos ad=2.596p pd=5.58u as=1.408p ps=5.04u w=4.4u l=0.6u
X446 analog_io[20] a_355624_156244# IOVDD3 IOVDD3 sg13_hv_pmos ad=3.9294p pd=7.84u as=2.1312p ps=7.3u w=6.66u l=0.6u
X447 user_project_wrapper_0.analog_io[32] a_202114_326125# user_project_wrapper_0.IOVSS1 user_project_wrapper_0.IOVSS1 sg13_lv_pmos ad=1.824p pd=9.98u as=1.824p ps=9.98u w=9.6u l=0.13u
X448 user_project_wrapper_0.IOVSS1 user_project_wrapper_0.sg13g2_IOPadVdd_2.sg13g2_RCClampInverter_noptap_0.out user_project_wrapper_0.VDD1 user_project_wrapper_0.IOVSS1 sg13_hv_nmos ad=1.408p pd=5.04u as=2.596p ps=5.58u w=4.4u l=0.6u
X449 user_project_wrapper_0.IOVDD1 a_41476_135844# user_project_wrapper_0.analog_io[1] user_project_wrapper_0.IOVDD1 sg13_hv_pmos ad=2.1312p pd=7.3u as=3.9294p ps=7.84u w=6.66u l=0.6u
X450 user_project_wrapper_0.analog_io[4] a_41476_197044# user_project_wrapper_0.IOVDD1 user_project_wrapper_0.IOVDD1 sg13_hv_pmos ad=3.9294p pd=7.84u as=2.1312p ps=7.3u w=6.66u l=0.6u
X451 user_project_wrapper_0.IOVSS1 a_217444_369296# user_project_wrapper_0.analog_io[32] user_project_wrapper_0.IOVSS1 sg13_hv_nmos ad=1.408p pd=5.04u as=2.596p ps=5.58u w=4.4u l=0.6u
X452 user_project_wrapper_0.analog_io[27] a_182931_326125# user_project_wrapper_0.IOVSS1 user_project_wrapper_0.IOVSS1 sg13_lv_nmos ad=0.912p pd=5.18u as=0.912p ps=5.18u w=4.8u l=0.13u
X453 VDD3 a_296625_189595# a_296731_189665# VDD3 sg13_lv_pmos ad=0.2603p pd=1.75u as=0.2603p ps=1.75u w=1.37u l=0.35u
X454 user_project_wrapper_0.analog_io[32] a_202114_326125# user_project_wrapper_0.IOVSS1 user_project_wrapper_0.IOVSS1 sg13_lv_pmos ad=1.824p pd=9.98u as=1.824p ps=9.98u w=9.6u l=0.13u
X455 a_309917_199879# a_309516_194555# VDD3 VDD3 sg13_lv_pmos ad=0.19p pd=1.38u as=0.19p ps=1.38u w=1u l=0.7u
X456 VDD3 a_296625_208423# a_296731_208493# VDD3 sg13_lv_pmos ad=0.2603p pd=1.75u as=0.2603p ps=1.75u w=1.37u l=0.35u
X457 IOVDD3 user_project_wrapper_0.sg13g2_IOPadIOVdd_3.sg13g2_Clamp_N43N43D4R_0.gate user_project_wrapper_0.IOVSS1 user_project_wrapper_0.IOVSS1 sg13_hv_nmos ad=2.596p pd=5.58u as=1.408p ps=5.04u w=4.4u l=0.6u
X458 user_project_wrapper_0.IOVSS1 a_194687_324142# user_project_wrapper_0.analog_io[30] user_project_wrapper_0.IOVSS1 sg13_lv_nmos ad=0.912p pd=5.18u as=0.912p ps=5.18u w=4.8u l=0.13u
X459 a_304196_197873# a_304889_198885# a_304995_198817# user_project_wrapper_0.IOVSS1 sg13_lv_nmos ad=0.209p pd=1.48u as=0.209p ps=1.48u w=1.1u l=0.15u
X460 user_project_wrapper_0.IOVSS1 user_project_wrapper_0.sg13g2_IOPadVdd_1.sg13g2_RCClampInverter_noptap_0.out user_project_wrapper_0.VDD2 user_project_wrapper_0.IOVSS1 sg13_hv_nmos ad=1.408p pd=5.04u as=2.596p ps=5.58u w=4.4u l=0.6u
X461 a_309917_194695# a_296731_189665# a_307232_196607# VDD3 sg13_lv_pmos ad=0.24415p pd=1.665u as=0.24415p ps=1.665u w=1.285u l=0.35u
X462 a_296731_189665# a_296625_189595# VDD3 VDD3 sg13_lv_pmos ad=0.2603p pd=1.75u as=0.2603p ps=1.75u w=1.37u l=0.35u
X463 analog_io[23] a_369296_237844# user_project_wrapper_0.IOVSS1 user_project_wrapper_0.IOVSS1 sg13_hv_nmos ad=2.596p pd=5.58u as=1.408p ps=5.04u w=4.4u l=0.6u
X464 user_project_wrapper_0.IOVSS1 user_project_wrapper_0.IOVSS1 user_project_wrapper_0.IOVSS1 rppd l=0.5u w=0.5u
X465 user_project_wrapper_0.IOVSS1 a_369296_176644# analog_io[20] user_project_wrapper_0.IOVSS1 sg13_hv_nmos ad=1.408p pd=5.04u as=2.596p ps=5.58u w=4.4u l=0.6u
X466 user_project_wrapper_0.IOVSS1 user_project_wrapper_0.sg13g2_IOPadVdd_2.sg13g2_RCClampInverter_noptap_0.out user_project_wrapper_0.VDD1 user_project_wrapper_0.IOVSS1 sg13_hv_nmos ad=1.408p pd=5.04u as=2.596p ps=5.58u w=4.4u l=0.6u
X467 a_296731_189665# a_301186_192011# user_project_wrapper_0.IOVSS1 user_project_wrapper_0.IOVSS1 sg13_lv_nmos ad=0.912p pd=5.18u as=0.912p ps=5.18u w=4.8u l=1.06u
X468 analog_io[20] a_355624_156244# IOVDD3 IOVDD3 sg13_hv_pmos ad=3.9294p pd=7.84u as=2.1312p ps=7.3u w=6.66u l=0.6u
X469 user_project_wrapper_0.IOVSS1 a_205385_326221# a_202114_326125# user_project_wrapper_0.IOVSS1 sg13_lv_nmos ad=0.912p pd=5.18u as=0.912p ps=5.18u w=4.8u l=0.13u
X470 user_project_wrapper_0.IOVSS1 user_project_wrapper_0.sg13g2_IOPadVdd_3.sg13g2_RCClampInverter_noptap_0.out user_project_wrapper_0.IOVSS1 user_project_wrapper_0.IOVSS1 sg13_hv_nmos ad=2.596p pd=5.58u as=0 ps=0 w=4.4u l=0.6u
X471 user_project_wrapper_0.IOVSS1 user_project_wrapper_0.sg13g2_IOPadVdd_3.sg13g2_RCClampInverter_noptap_0.out user_project_wrapper_0.IOVSS1 user_project_wrapper_0.IOVSS1 sg13_hv_nmos ad=2.596p pd=5.58u as=0 ps=0 w=4.4u l=0.6u
X472 VDD3 a_309516_194555# a_309516_194555# VDD3 sg13_lv_pmos ad=0.19p pd=1.38u as=0.19p ps=1.38u w=1u l=0.7u
X473 user_project_wrapper_0.IOVDD1 user_project_wrapper_0.sg13g2_IOPadIOVdd_1.sg13g2_Clamp_N43N43D4R_0.gate user_project_wrapper_0.IOVSS1 user_project_wrapper_0.IOVSS1 sg13_hv_nmos ad=2.596p pd=5.58u as=1.408p ps=5.04u w=4.4u l=0.6u
X474 user_project_wrapper_0.ui_PAD[2] user_project_wrapper_0.IOVDD1 dpantenna l=1.26u w=27.78u
X475 user_project_wrapper_0.sg13g2_IOPadVdd_0.sg13g2_RCClampInverter_noptap_0.out user_project_wrapper_0.sg13g2_IOPadVdd_0.sg13g2_RCClampResistor_0.p2 VDD3 VDD3 sg13_hv_pmos ad=1.33p pd=7.38u as=1.33p ps=7.38u w=7u l=0.5u
X476 user_project_wrapper_0.IOVSS1 a_258244_369296# user_project_wrapper_0.analog_io[34] user_project_wrapper_0.IOVSS1 sg13_hv_nmos ad=1.408p pd=5.04u as=2.596p ps=5.58u w=4.4u l=0.6u
X477 VDD3 a_296625_208423# a_296731_208493# VDD3 sg13_lv_pmos ad=0.2603p pd=1.75u as=0.2603p ps=1.75u w=1.37u l=0.35u
X478 user_project_wrapper_0.analog_io[6] user_project_wrapper_0.IOVDD1 dpantenna l=27.78u w=1.26u
X479 VDD3 a_296625_189595# a_296731_189665# VDD3 sg13_lv_pmos ad=0.2603p pd=1.75u as=0.2603p ps=1.75u w=1.37u l=0.35u
X480 a_360372_80305# a_364458_79975# user_project_wrapper_0.IOVSS1 rppd l=20u w=1u
X481 user_project_wrapper_0.analog_io[32] a_202114_326125# user_project_wrapper_0.IOVSS1 user_project_wrapper_0.IOVSS1 sg13_lv_nmos ad=0.912p pd=5.18u as=1.632p ps=10.28u w=4.8u l=0.13u
X482 analog_io[18] a_355624_115444# IOVDD3 IOVDD3 sg13_hv_pmos ad=3.9294p pd=7.84u as=2.1312p ps=7.3u w=6.66u l=0.6u
X483 user_project_wrapper_0.IOVSS1 a_190455_324119# a_190047_324119# w_188806_323975# sg13_lv_pmos ad=0.68p pd=4.68u as=0.68p ps=4.68u w=2u l=0.13u
X484 a_296625_189595# a_301940_196388# a_296732_197880# VDD3 sg13_lv_pmos ad=0.7695p pd=4.43u as=0.7695p ps=4.43u w=4.05u l=0.5u
X485 user_project_wrapper_0.IOVSS1 a_301186_192011# a_296731_189665# user_project_wrapper_0.IOVSS1 sg13_lv_nmos ad=0.912p pd=5.18u as=1.632p ps=10.28u w=4.8u l=1.06u
X486 a_296731_189665# a_296625_189595# VDD3 VDD3 sg13_lv_pmos ad=0.2603p pd=1.75u as=0.2603p ps=1.75u w=1.37u l=0.35u
X487 QDLL_TOP_0.VDD a_190218_102763# a_190490_102497# QDLL_TOP_0.VDD sg13_lv_pmos ad=0.2128p pd=1.5u as=0.3808p ps=2.92u w=1.12u l=0.13u
X488 a_309917_199879# a_309516_194555# VDD3 VDD3 sg13_lv_pmos ad=0.19p pd=1.38u as=0.19p ps=1.38u w=1u l=0.7u
X489 user_project_wrapper_0.IOVSS1 user_project_wrapper_0.sg13g2_IOPadIOVdd_3.sg13g2_Clamp_N43N43D4R_0.gate IOVDD3 user_project_wrapper_0.IOVSS1 sg13_hv_nmos ad=1.408p pd=5.04u as=2.596p ps=5.58u w=4.4u l=0.6u
X490 user_project_wrapper_0.IOVSS1 user_project_wrapper_0.sg13g2_IOPadIOVdd_3.sg13g2_Clamp_N43N43D4R_0.gate IOVDD3 user_project_wrapper_0.IOVSS1 sg13_hv_nmos ad=1.408p pd=5.04u as=2.596p ps=5.58u w=4.4u l=0.6u
X491 user_project_wrapper_0.analog_io[16] a_258244_41476# user_project_wrapper_0.IOVDD2 user_project_wrapper_0.IOVDD2 sg13_hv_pmos ad=3.9294p pd=7.84u as=2.1312p ps=7.3u w=6.66u l=0.6u
X492 a_91090_127895# a_84332_125209# a_91090_127530# user_project_wrapper_0.IOVSS1 sg13_lv_nmos ad=0.2516p pd=2.16u as=0.1406p ps=1.12u w=0.74u l=0.13u
X493 user_project_wrapper_0.IOVSS1 a_29676_197044# user_project_wrapper_0.analog_io[4] user_project_wrapper_0.IOVSS1 sg13_hv_nmos ad=1.408p pd=5.04u as=2.596p ps=5.58u w=4.4u l=0.6u
X494 user_project_wrapper_0.IOVSS1 a_213870_324142# user_project_wrapper_0.analog_io[35] user_project_wrapper_0.IOVSS1 sg13_lv_nmos ad=0.912p pd=5.18u as=0.912p ps=5.18u w=4.8u l=0.13u
X495 user_project_wrapper_0.analog_io[27] a_182931_326125# user_project_wrapper_0.IOVSS1 user_project_wrapper_0.IOVSS1 sg13_lv_nmos ad=0.912p pd=5.18u as=0.912p ps=5.18u w=4.8u l=0.13u
X496 a_210621_327491# a_210417_327491# user_project_wrapper_0.IOVSS1 w_207887_327938# sg13_lv_pmos ad=0.68p pd=4.68u as=0.38p ps=2.38u w=2u l=0.13u
X497 analog_io[23] a_311108_215937# VDD3 user_project_wrapper_0.IOVSS1 sg13_lv_nmos ad=3.4p pd=20.68u as=3.4p ps=20.68u w=10u l=0.15u
X498 user_project_wrapper_0.IOVSS1 user_project_wrapper_0.sg13g2_IOPadIOVdd_1.sg13g2_Clamp_N43N43D4R_0.gate user_project_wrapper_0.IOVDD1 user_project_wrapper_0.IOVSS1 sg13_hv_nmos ad=1.408p pd=5.04u as=2.596p ps=5.58u w=4.4u l=0.6u
X499 user_project_wrapper_0.IOVSS1 a_135844_369296# user_project_wrapper_0.analog_io[28] user_project_wrapper_0.IOVSS1 sg13_hv_nmos ad=1.408p pd=5.04u as=2.596p ps=5.58u w=4.4u l=0.6u
X500 VDD3 a_296625_208423# a_296731_208493# VDD3 sg13_lv_pmos ad=0.2603p pd=1.75u as=0.2603p ps=1.75u w=1.37u l=0.35u
X501 a_86046_241645# a_82846_241091# a_86407_241748# user_project_wrapper_0.VDD1 sg13_lv_pmos ad=0.3808p pd=2.92u as=0.2128p ps=1.5u w=1.12u l=0.13u
X502 a_209905_327491# a_208939_327491# user_project_wrapper_0.IOVSS1 user_project_wrapper_0.IOVSS1 sg13_lv_nmos ad=0.19p pd=1.38u as=0.34p ps=2.68u w=1u l=0.13u
X503 user_project_wrapper_0.IOVDD2 a_278644_41476# QDLL_TOP_0.VOUT user_project_wrapper_0.IOVDD2 sg13_hv_pmos ad=2.1312p pd=7.3u as=3.9294p ps=7.84u w=6.66u l=0.6u
X504 user_project_wrapper_0.analog_io[0] a_41476_115444# user_project_wrapper_0.IOVDD1 user_project_wrapper_0.IOVDD1 sg13_hv_pmos ad=3.9294p pd=7.84u as=2.1312p ps=7.3u w=6.66u l=0.6u
X505 user_project_wrapper_0.IOVSS1 user_project_wrapper_0.sg13g2_IOPadAnalog_19.padres dantenna l=3.1u w=0.64u
X506 a_309917_199879# a_309516_194555# VDD3 VDD3 sg13_lv_pmos ad=0.19p pd=1.38u as=0.19p ps=1.38u w=1u l=0.7u
X507 user_project_wrapper_0.IOVSS1 user_project_wrapper_0.sg13g2_IOPadVdd_3.sg13g2_RCClampInverter_noptap_0.out user_project_wrapper_0.IOVSS1 user_project_wrapper_0.IOVSS1 sg13_hv_nmos ad=1.408p pd=5.04u as=0 ps=0 w=4.4u l=0.6u
X508 VDD3 a_309516_194555# a_309917_199879# VDD3 sg13_lv_pmos ad=0.19p pd=1.38u as=0.19p ps=1.38u w=1u l=0.7u
X509 user_project_wrapper_0.sg13g2_IOPadVdd_3.sg13g2_RCClampInverter_noptap_0.out user_project_wrapper_0.sg13g2_IOPadVdd_3.sg13g2_RCClampResistor_0.p2 user_project_wrapper_0.IOVSS1 user_project_wrapper_0.IOVSS1 sg13_hv_pmos ad=1.33p pd=7.38u as=1.33p ps=7.38u w=7u l=0.5u
X510 user_project_wrapper_0.IOVSS1 a_258244_29676# user_project_wrapper_0.analog_io[16] user_project_wrapper_0.IOVSS1 sg13_hv_nmos ad=1.408p pd=5.04u as=2.596p ps=5.58u w=4.4u l=0.6u
X511 IOVDD3 a_355624_135844# analog_io[19] IOVDD3 sg13_hv_pmos ad=2.1312p pd=7.3u as=3.9294p ps=7.84u w=6.66u l=0.6u
X512 analog_io[22] a_355624_197044# IOVDD3 IOVDD3 sg13_hv_pmos ad=3.9294p pd=7.84u as=2.1312p ps=7.3u w=6.66u l=0.6u
X513 user_project_wrapper_0.IOVDD2 user_project_wrapper_0.sg13g2_IOPadIOVdd_0.sg13g2_Clamp_N43N43D4R_0.gate user_project_wrapper_0.IOVSS1 user_project_wrapper_0.IOVSS1 sg13_hv_nmos ad=2.596p pd=5.58u as=1.408p ps=5.04u w=4.4u l=0.6u
X514 user_project_wrapper_0.IOVSS1 user_project_wrapper_0.sg13g2_IOPadVdd_1.sg13g2_RCClampInverter_noptap_0.out user_project_wrapper_0.VDD2 user_project_wrapper_0.IOVSS1 sg13_hv_nmos ad=1.408p pd=5.04u as=2.596p ps=5.58u w=4.4u l=0.6u
X515 user_project_wrapper_0.IOVDD2 user_project_wrapper_0.sg13g2_IOPadIOVdd_0.sg13g2_Clamp_N43N43D4R_0.gate user_project_wrapper_0.IOVSS1 user_project_wrapper_0.IOVSS1 sg13_hv_nmos ad=2.596p pd=5.58u as=1.408p ps=5.04u w=4.4u l=0.6u
X516 user_project_wrapper_0.VDD2 user_project_wrapper_0.sg13g2_IOPadVdd_1.sg13g2_RCClampInverter_noptap_0.out user_project_wrapper_0.IOVSS1 user_project_wrapper_0.IOVSS1 sg13_hv_nmos ad=2.596p pd=5.58u as=1.408p ps=5.04u w=4.4u l=0.6u
X517 user_project_wrapper_0.IOVSS1 a_217444_29676# user_project_wrapper_0.analog_io[14] user_project_wrapper_0.IOVSS1 sg13_hv_nmos ad=1.408p pd=5.04u as=2.596p ps=5.58u w=4.4u l=0.6u
X518 user_project_wrapper_0.IOVSS1 user_project_wrapper_0.sg13g2_IOPadVdd_2.sg13g2_RCClampInverter_noptap_0.out user_project_wrapper_0.VDD1 user_project_wrapper_0.IOVSS1 sg13_hv_nmos ad=1.408p pd=5.04u as=2.596p ps=5.58u w=4.4u l=0.6u
X519 user_project_wrapper_0.analog_io[32] a_202114_326125# user_project_wrapper_0.IOVSS1 user_project_wrapper_0.IOVSS1 sg13_lv_nmos ad=0.912p pd=5.18u as=0.912p ps=5.18u w=4.8u l=0.13u
X520 VDD3 user_project_wrapper_0.sg13g2_IOPadVdd_0.sg13g2_RCClampInverter_noptap_0.out user_project_wrapper_0.IOVSS1 user_project_wrapper_0.IOVSS1 sg13_hv_nmos ad=2.596p pd=5.58u as=2.068p ps=9.74u w=4.4u l=0.6u
X521 user_project_wrapper_0.IOVSS1 a_176644_369296# user_project_wrapper_0.analog_io[30] user_project_wrapper_0.IOVSS1 sg13_hv_nmos ad=1.408p pd=5.04u as=2.596p ps=5.58u w=4.4u l=0.6u
X522 user_project_wrapper_0.analog_io[29] a_156244_355624# user_project_wrapper_0.IOVDD4 user_project_wrapper_0.IOVDD4 sg13_hv_pmos ad=3.9294p pd=7.84u as=2.1312p ps=7.3u w=6.66u l=0.6u
X523 user_project_wrapper_0.IOVDD2 a_217444_41476# user_project_wrapper_0.analog_io[14] user_project_wrapper_0.IOVDD2 sg13_hv_pmos ad=2.1312p pd=7.3u as=3.9294p ps=7.84u w=6.66u l=0.6u
X524 user_project_wrapper_0.IOVSS1 user_project_wrapper_0.IOVSS1 user_project_wrapper_0.IOVSS1 rhigh l=0.96u w=0.5u
X525 user_project_wrapper_0.IOVSS1 a_307232_196607# a_304995_198817# user_project_wrapper_0.IOVSS1 sg13_lv_nmos ad=0.6327p pd=3.71u as=0.6327p ps=3.71u w=3.33u l=0.2u
X526 user_project_wrapper_0.IOVDD1 a_41476_258244# user_project_wrapper_0.analog_io[7] user_project_wrapper_0.IOVDD1 sg13_hv_pmos ad=2.1312p pd=7.3u as=3.9294p ps=7.84u w=6.66u l=0.6u
X527 user_project_wrapper_0.IOVSS1 a_190297_329719# a_190926_329719# user_project_wrapper_0.IOVSS1 sg13_lv_nmos ad=0.34p pd=2.68u as=0.19p ps=1.38u w=1u l=0.13u
X528 user_project_wrapper_0.analog_io[32] a_217444_355624# user_project_wrapper_0.IOVDD4 user_project_wrapper_0.IOVDD4 sg13_hv_pmos ad=3.9294p pd=7.84u as=2.1312p ps=7.3u w=6.66u l=0.6u
X529 user_project_wrapper_0.analog_io[27] a_182931_326125# user_project_wrapper_0.IOVSS1 user_project_wrapper_0.IOVSS1 sg13_lv_pmos ad=1.824p pd=9.98u as=1.824p ps=9.98u w=9.6u l=0.13u
X530 user_project_wrapper_0.IOVSS1 a_301186_192011# a_296731_189665# user_project_wrapper_0.IOVSS1 sg13_lv_nmos ad=1.632p pd=10.28u as=0.912p ps=5.18u w=4.8u l=1.06u
X531 a_296731_208493# a_296625_208423# VDD3 VDD3 sg13_lv_pmos ad=0.2603p pd=1.75u as=0.2603p ps=1.75u w=1.37u l=0.35u
X532 user_project_wrapper_0.IOVDD4 a_135844_355624# user_project_wrapper_0.analog_io[28] user_project_wrapper_0.IOVDD4 sg13_hv_pmos ad=2.1312p pd=7.3u as=3.9294p ps=7.84u w=6.66u l=0.6u
X533 IOVDD3 user_project_wrapper_0.sg13g2_IOPadIOVdd_3.sg13g2_Clamp_N43N43D4R_0.gate user_project_wrapper_0.IOVSS1 user_project_wrapper_0.IOVSS1 sg13_hv_nmos ad=2.596p pd=5.58u as=1.408p ps=5.04u w=4.4u l=0.6u
X534 user_project_wrapper_0.IOVSS1 user_project_wrapper_0.analog_io[16] dantenna l=1.26u w=27.78u
X535 user_project_wrapper_0.analog_io[15] a_190389_101343# QDLL_TOP_0.VDD QDLL_TOP_0.VDD sg13_lv_pmos ad=0.2128p pd=1.5u as=0.2128p ps=1.5u w=1.12u l=0.13u
X536 user_project_wrapper_0.IOVDD2 a_135844_41476# user_project_wrapper_0.analog_io[10] user_project_wrapper_0.IOVDD2 sg13_hv_pmos ad=2.1312p pd=7.3u as=3.9294p ps=7.84u w=6.66u l=0.6u
X537 user_project_wrapper_0.IOVSS1 user_project_wrapper_0.sg13g2_IOPadVdd_3.sg13g2_RCClampInverter_noptap_0.out user_project_wrapper_0.IOVSS1 user_project_wrapper_0.IOVSS1 sg13_hv_nmos ad=2.596p pd=5.58u as=0 ps=0 w=4.4u l=0.6u
X538 user_project_wrapper_0.IOVSS1 user_project_wrapper_0.sg13g2_IOPadIOVdd_0.sg13g2_Clamp_N43N43D4R_0.gate user_project_wrapper_0.IOVDD2 user_project_wrapper_0.IOVSS1 sg13_hv_nmos ad=1.408p pd=5.04u as=2.596p ps=5.58u w=4.4u l=0.6u
X539 user_project_wrapper_0.IOVSS1 user_project_wrapper_0.sg13g2_IOPadVdd_3.sg13g2_RCClampInverter_noptap_0.out user_project_wrapper_0.IOVSS1 user_project_wrapper_0.IOVSS1 sg13_hv_nmos ad=2.596p pd=5.58u as=0 ps=0 w=4.4u l=0.6u
X540 a_210007_329719# a_208367_329719# a_209905_329719# user_project_wrapper_0.IOVSS1 sg13_lv_nmos ad=0.19p pd=1.38u as=0.19p ps=1.38u w=1u l=0.13u
X541 a_360372_298765# a_364458_299095# user_project_wrapper_0.IOVSS1 rppd l=20u w=1u
X542 user_project_wrapper_0.IOVSS1 user_project_wrapper_0.sg13g2_IOPadVdd_2.sg13g2_RCClampInverter_noptap_0.out user_project_wrapper_0.VDD1 user_project_wrapper_0.IOVSS1 sg13_hv_nmos ad=1.408p pd=5.04u as=2.596p ps=5.58u w=4.4u l=0.6u
X543 user_project_wrapper_0.IOVDD4 a_237844_355624# user_project_wrapper_0.analog_io[33] user_project_wrapper_0.IOVDD4 sg13_hv_pmos ad=2.1312p pd=7.3u as=3.9294p ps=7.84u w=6.66u l=0.6u
X544 analog_io[26] a_355624_278644# IOVDD3 IOVDD3 sg13_hv_pmos ad=3.9294p pd=7.84u as=3.1302p ps=14.26u w=6.66u l=0.6u
X545 user_project_wrapper_0.IOVSS1 user_project_wrapper_0.sg13g2_IOPadAnalog_6.padres dantenna l=3.1u w=0.64u
X546 user_project_wrapper_0.IOVSS1 user_project_wrapper_0.sg13g2_IOPadIOVdd_2.sg13g2_Clamp_N43N43D4R_0.gate dantenna l=0.48u w=0.48u
X547 user_project_wrapper_0.sg13g2_IOPadVdd_2.sg13g2_RCClampInverter_noptap_0.out user_project_wrapper_0.sg13g2_IOPadVdd_2.sg13g2_RCClampResistor_0.p2 user_project_wrapper_0.VDD1 user_project_wrapper_0.VDD1 sg13_hv_pmos ad=1.33p pd=7.38u as=1.33p ps=7.38u w=7u l=0.5u
X548 a_296731_189665# a_296625_189595# VDD3 VDD3 sg13_lv_pmos ad=0.2603p pd=1.75u as=0.4658p ps=3.42u w=1.37u l=0.35u
X549 VDD3 a_296626_197740# a_296732_200582# VDD3 sg13_lv_pmos ad=1.33p pd=7.38u as=1.33p ps=7.38u w=7u l=0.7u
X550 user_project_wrapper_0.sg13g2_IOPadOut4mA$1_0.sg13g2_GateLevelUpInv_noptap$1$1_0.ngate a_57810_179517# user_project_wrapper_0.IOVSS1 user_project_wrapper_0.IOVSS1 sg13_hv_nmos ad=0.646p pd=4.48u as=0.646p ps=4.48u w=1.9u l=0.45u
X551 user_project_wrapper_0.IOVSS1 user_project_wrapper_0.sg13g2_IOPadVdd_3.sg13g2_RCClampInverter_noptap_0.out user_project_wrapper_0.IOVSS1 user_project_wrapper_0.IOVSS1 sg13_hv_nmos ad=2.596p pd=5.58u as=0 ps=0 w=4.4u l=0.6u
X552 user_project_wrapper_0.IOVSS1 user_project_wrapper_0.sg13g2_IOPadIOVdd_2.sg13g2_RCClampResistor_0.p2 user_project_wrapper_0.IOVSS1 user_project_wrapper_0.IOVSS1 sg13_hv_nmos ad=1.71p pd=9.38u as=0 ps=0 w=9u l=9.5u
X553 user_project_wrapper_0.IOVDD1 a_41476_258244# user_project_wrapper_0.IOVDD1 rppd l=12.9u w=0.5u
X554 user_project_wrapper_0.IOVSS1 user_project_wrapper_0.IOVSS1 user_project_wrapper_0.IOVSS1 rhigh l=0.96u w=0.5u
X555 a_304995_198817# a_307232_196607# user_project_wrapper_0.IOVSS1 user_project_wrapper_0.IOVSS1 sg13_lv_nmos ad=0.6327p pd=3.71u as=0.6327p ps=3.71u w=3.33u l=0.2u
X556 user_project_wrapper_0.VDD2 user_project_wrapper_0.sg13g2_IOPadVdd_1.sg13g2_RCClampInverter_noptap_0.out user_project_wrapper_0.IOVSS1 user_project_wrapper_0.IOVSS1 sg13_hv_nmos ad=2.596p pd=5.58u as=1.408p ps=5.04u w=4.4u l=0.6u
X557 analog_io[20] IOVDD3 dpantenna l=27.78u w=1.26u
X558 VDD3 a_311108_179669# analog_io[20] user_project_wrapper_0.IOVSS1 sg13_lv_nmos ad=3.4p pd=20.68u as=3.4p ps=20.68u w=10u l=0.15u
X559 a_296731_189665# a_296625_189595# VDD3 VDD3 sg13_lv_pmos ad=0.2603p pd=1.75u as=0.2603p ps=1.75u w=1.37u l=0.35u
X560 user_project_wrapper_0.analog_io[27] a_182931_326125# user_project_wrapper_0.IOVSS1 user_project_wrapper_0.IOVSS1 sg13_lv_pmos ad=1.824p pd=9.98u as=1.824p ps=9.98u w=9.6u l=0.13u
X561 a_309917_199879# a_309516_194555# VDD3 VDD3 sg13_lv_pmos ad=0.19p pd=1.38u as=0.19p ps=1.38u w=1u l=0.7u
X562 a_296731_208493# a_301186_192011# user_project_wrapper_0.IOVSS1 user_project_wrapper_0.IOVSS1 sg13_lv_nmos ad=0.912p pd=5.18u as=0.912p ps=5.18u w=4.8u l=1.06u
X563 user_project_wrapper_0.analog_io[16] a_258244_41476# user_project_wrapper_0.IOVDD2 user_project_wrapper_0.IOVDD2 sg13_hv_pmos ad=3.9294p pd=7.84u as=3.1302p ps=14.26u w=6.66u l=0.6u
X564 VDD3 a_296625_189595# a_296731_189665# VDD3 sg13_lv_pmos ad=0.4658p pd=3.42u as=0.2603p ps=1.75u w=1.37u l=0.35u
X565 user_project_wrapper_0.IOVSS1 a_369296_278644# analog_io[26] user_project_wrapper_0.IOVSS1 sg13_hv_nmos ad=1.408p pd=5.04u as=2.596p ps=5.58u w=4.4u l=0.6u
X566 user_project_wrapper_0.IOVDD1 user_project_wrapper_0.sg13g2_IOPadIOVdd_1.sg13g2_Clamp_N43N43D4R_0.gate user_project_wrapper_0.IOVSS1 user_project_wrapper_0.IOVSS1 sg13_hv_nmos ad=3.256p pd=10.28u as=1.408p ps=5.04u w=4.4u l=0.6u
X567 a_208017_327918# user_project_wrapper_0.sg13g2_IOPadAnalog_22.padres user_project_wrapper_0.IOVSS1 user_project_wrapper_0.IOVSS1 sg13_lv_nmos ad=0.34p pd=2.68u as=0.34p ps=2.68u w=1u l=0.13u
X568 user_project_wrapper_0.IOVSS1 a_213870_324142# user_project_wrapper_0.analog_io[35] user_project_wrapper_0.IOVSS1 sg13_lv_pmos ad=1.824p pd=9.98u as=1.824p ps=9.98u w=9.6u l=0.13u
X569 a_296731_208493# a_296625_208423# VDD3 VDD3 sg13_lv_pmos ad=0.2603p pd=1.75u as=0.2603p ps=1.75u w=1.37u l=0.35u
X570 user_project_wrapper_0.analog_io[27] a_182931_326125# user_project_wrapper_0.IOVSS1 user_project_wrapper_0.IOVSS1 sg13_lv_pmos ad=1.824p pd=9.98u as=1.824p ps=9.98u w=9.6u l=0.13u
X571 a_190501_325263# a_189184_325263# user_project_wrapper_0.IOVSS1 w_188704_326203# sg13_lv_pmos ad=0.68p pd=4.68u as=0.68p ps=4.68u w=2u l=0.13u
X572 user_project_wrapper_0.IOVSS1 user_project_wrapper_0.sg13g2_IOPadVdd_3.sg13g2_RCClampInverter_noptap_0.out user_project_wrapper_0.IOVSS1 user_project_wrapper_0.IOVSS1 sg13_hv_nmos ad=1.408p pd=5.04u as=0 ps=0 w=4.4u l=0.6u
X573 a_191438_327491# a_191234_327491# user_project_wrapper_0.IOVSS1 w_188704_327938# sg13_lv_pmos ad=0.38p pd=2.38u as=0.68p ps=4.68u w=2u l=0.13u
X574 user_project_wrapper_0.IOVSS1 IOVDD3 dpantenna l=1.26u w=27.78u
X575 user_project_wrapper_0.IOVSS1 user_project_wrapper_0.sg13g2_IOPadIOVdd_3.sg13g2_Clamp_N43N43D4R_0.gate IOVDD3 user_project_wrapper_0.IOVSS1 sg13_hv_nmos ad=1.408p pd=5.04u as=2.596p ps=5.58u w=4.4u l=0.6u
X576 user_project_wrapper_0.VDD2 user_project_wrapper_0.sg13g2_IOPadVdd_1.sg13g2_RCClampInverter_noptap_0.out user_project_wrapper_0.IOVSS1 user_project_wrapper_0.IOVSS1 sg13_hv_nmos ad=2.596p pd=5.58u as=1.408p ps=5.04u w=4.4u l=0.6u
X577 user_project_wrapper_0.analog_io[15] a_237844_29676# user_project_wrapper_0.IOVSS1 user_project_wrapper_0.IOVSS1 sg13_hv_nmos ad=2.596p pd=5.58u as=1.408p ps=5.04u w=4.4u l=0.6u
X578 user_project_wrapper_0.IOVSS1 user_project_wrapper_0.sg13g2_IOPadIOVdd_3.sg13g2_Clamp_N43N43D4R_0.gate IOVDD3 user_project_wrapper_0.IOVSS1 sg13_hv_nmos ad=1.408p pd=5.04u as=2.596p ps=5.58u w=4.4u l=0.6u
X579 a_86970_241383# a_85989_241383# user_project_wrapper_0.VDD1 user_project_wrapper_0.VDD1 sg13_lv_pmos ad=0.3808p pd=2.92u as=0.3808p ps=2.92u w=1.12u l=0.13u
X580 user_project_wrapper_0.sg13g2_IOPadVdd_3.sg13g2_RCClampInverter_noptap_0.out user_project_wrapper_0.sg13g2_IOPadVdd_3.sg13g2_RCClampResistor_0.p2 user_project_wrapper_0.IOVSS1 user_project_wrapper_0.IOVSS1 sg13_hv_pmos ad=1.33p pd=7.38u as=1.33p ps=7.38u w=7u l=0.5u
X581 user_project_wrapper_0.IOVDD2 a_217444_41476# user_project_wrapper_0.analog_io[14] user_project_wrapper_0.IOVDD2 sg13_hv_pmos ad=2.1312p pd=7.3u as=3.9294p ps=7.84u w=6.66u l=0.6u
X582 a_311108_179669# a_311189_185546# VDD3 VDD3 sg13_lv_pmos ad=1.9p pd=10.38u as=1.9p ps=10.38u w=10u l=1u
X583 user_project_wrapper_0.IOVSS1 user_project_wrapper_0.sg13g2_IOPadVdd_0.sg13g2_RCClampInverter_noptap_0.out VDD3 user_project_wrapper_0.IOVSS1 sg13_hv_nmos ad=1.408p pd=5.04u as=2.596p ps=5.58u w=4.4u l=0.6u
X584 user_project_wrapper_0.analog_io[5] a_41476_217444# user_project_wrapper_0.IOVDD1 user_project_wrapper_0.IOVDD1 sg13_hv_pmos ad=3.9294p pd=7.84u as=3.1302p ps=14.26u w=6.66u l=0.6u
X585 a_360372_304045# a_364458_304375# user_project_wrapper_0.IOVSS1 rppd l=20u w=1u
X586 a_304196_197873# a_304889_198885# a_304995_198817# user_project_wrapper_0.IOVSS1 sg13_lv_nmos ad=0.209p pd=1.48u as=0.209p ps=1.48u w=1.1u l=0.15u
X587 analog_io[23] a_355624_217444# IOVDD3 IOVDD3 sg13_hv_pmos ad=3.9294p pd=7.84u as=2.1312p ps=7.3u w=6.66u l=0.6u
X588 IOVDD3 a_355624_156244# analog_io[20] IOVDD3 sg13_hv_pmos ad=2.1312p pd=7.3u as=3.9294p ps=7.84u w=6.66u l=0.6u
X589 a_189286_325263# a_189184_326377# a_189184_325263# user_project_wrapper_0.IOVSS1 sg13_lv_nmos ad=0.19p pd=1.38u as=0.19p ps=1.38u w=1u l=0.13u
X590 user_project_wrapper_0.analog_io[32] a_202114_326125# user_project_wrapper_0.IOVSS1 user_project_wrapper_0.IOVSS1 sg13_lv_pmos ad=1.824p pd=9.98u as=1.824p ps=9.98u w=9.6u l=0.13u
X591 a_307232_196607# a_307232_196607# user_project_wrapper_0.IOVSS1 user_project_wrapper_0.IOVSS1 sg13_lv_nmos ad=1.1322p pd=7.34u as=0.6327p ps=3.71u w=3.33u l=0.2u
X592 user_project_wrapper_0.analog_io[28] a_135844_369296# user_project_wrapper_0.IOVSS1 user_project_wrapper_0.IOVSS1 sg13_hv_nmos ad=2.596p pd=5.58u as=1.408p ps=5.04u w=4.4u l=0.6u
X593 user_project_wrapper_0.IOVSS1 user_project_wrapper_0.IOVSS1 user_project_wrapper_0.IOVSS1 rppd l=0.5u w=0.5u
X594 IOVDD3 a_355624_278644# analog_io[26] IOVDD3 sg13_hv_pmos ad=2.1312p pd=7.3u as=3.9294p ps=7.84u w=6.66u l=0.6u
X595 VDD3 a_296625_208423# a_296731_208493# VDD3 sg13_lv_pmos ad=0.4658p pd=3.42u as=0.2603p ps=1.75u w=1.37u l=0.35u
X596 user_project_wrapper_0.IOVSS1 a_209480_329719# a_210109_329719# user_project_wrapper_0.IOVSS1 sg13_lv_nmos ad=0.34p pd=2.68u as=0.19p ps=1.38u w=1u l=0.13u
X597 a_309917_199879# a_309516_194555# VDD3 VDD3 sg13_lv_pmos ad=0.19p pd=1.38u as=0.19p ps=1.38u w=1u l=0.7u
X598 user_project_wrapper_0.IOVSS1 a_213870_324142# user_project_wrapper_0.analog_io[35] user_project_wrapper_0.IOVSS1 sg13_lv_pmos ad=1.824p pd=9.98u as=1.824p ps=9.98u w=9.6u l=0.13u
X599 user_project_wrapper_0.analog_io[32] a_202114_326125# user_project_wrapper_0.IOVSS1 user_project_wrapper_0.IOVSS1 sg13_lv_pmos ad=1.824p pd=9.98u as=1.824p ps=9.98u w=9.6u l=0.13u
X600 user_project_wrapper_0.IOVSS1 user_project_wrapper_0.sg13g2_IOPadVdd_0.sg13g2_RCClampInverter_noptap_0.out VDD3 user_project_wrapper_0.IOVSS1 sg13_hv_nmos ad=1.408p pd=5.04u as=2.596p ps=5.58u w=4.4u l=0.6u
X601 analog_io[22] a_355624_197044# IOVDD3 IOVDD3 sg13_hv_pmos ad=3.9294p pd=7.84u as=2.1312p ps=7.3u w=6.66u l=0.6u
X602 user_project_wrapper_0.IOVSS1 a_194687_324142# user_project_wrapper_0.analog_io[30] user_project_wrapper_0.IOVSS1 sg13_lv_nmos ad=0.912p pd=5.18u as=0.912p ps=5.18u w=4.8u l=0.13u
X603 a_304196_197873# a_304090_197941# a_296625_189595# user_project_wrapper_0.IOVSS1 sg13_lv_nmos ad=0.361p pd=2.28u as=0.361p ps=2.28u w=1.9u l=0.16u
X604 user_project_wrapper_0.sg13g2_IOPadIOVdd_3.sg13g2_Clamp_N43N43D4R_0.gate user_project_wrapper_0.sg13g2_IOPadIOVdd_3.sg13g2_RCClampResistor_0.p2 IOVDD3 IOVDD3 sg13_hv_pmos ad=1.33p pd=7.38u as=1.33p ps=7.38u w=7u l=0.5u
X605 user_project_wrapper_0.IOVSS1 user_project_wrapper_0.IOVSS1 user_project_wrapper_0.IOVSS1 rppd l=0.5u w=0.5u
X606 VDD3 a_296625_189595# a_296731_189665# VDD3 sg13_lv_pmos ad=0.2603p pd=1.75u as=0.2603p ps=1.75u w=1.37u l=0.35u
X607 a_189672_324776# a_192745_324776# user_project_wrapper_0.IOVSS1 w_188806_323975# sg13_lv_pmos ad=0.38p pd=2.38u as=0.68p ps=4.68u w=2u l=0.13u
X608 user_project_wrapper_0.IOVSS1 a_205385_326221# a_202114_326125# user_project_wrapper_0.IOVSS1 sg13_lv_nmos ad=0.912p pd=5.18u as=0.912p ps=5.18u w=4.8u l=0.13u
X609 user_project_wrapper_0.sg13g2_IOPadIOVdd_0.sg13g2_Clamp_N43N43D4R_0.gate user_project_wrapper_0.sg13g2_IOPadIOVdd_0.sg13g2_RCClampResistor_0.p2 user_project_wrapper_0.IOVDD2 user_project_wrapper_0.IOVDD2 sg13_hv_pmos ad=1.33p pd=7.38u as=1.33p ps=7.38u w=7u l=0.5u
X610 VDD3 a_296626_197740# a_296732_197880# VDD3 sg13_lv_pmos ad=1.33p pd=7.38u as=1.33p ps=7.38u w=7u l=0.7u
X611 a_313884_211353# analog_io[23] a_311108_215937# user_project_wrapper_0.IOVSS1 sg13_lv_nmos ad=1.9p pd=10.38u as=1.9p ps=10.38u w=10u l=0.5u
X612 VDD3 a_296625_208423# a_296731_208493# VDD3 sg13_lv_pmos ad=0.2603p pd=1.75u as=0.2603p ps=1.75u w=1.37u l=0.35u
X613 VDD3 a_296625_208423# a_296731_208493# VDD3 sg13_lv_pmos ad=0.4658p pd=3.42u as=0.2603p ps=1.75u w=1.37u l=0.35u
X614 a_79038_130026# a_78220_128592# a_79025_131334# user_project_wrapper_0.VDD1 sg13_lv_pmos ad=0.95p pd=5.38u as=1.7p ps=10.68u w=5u l=0.3u
X615 a_311846_195517# user_project_wrapper_0.sg13g2_IOPadAnalog_29.padres a_309917_199879# VDD3 sg13_lv_pmos ad=0.24415p pd=1.665u as=0.24415p ps=1.665u w=1.285u l=0.35u
X616 user_project_wrapper_0.IOVSS1 a_190047_324119# a_187364_324106# w_188806_323975# sg13_lv_pmos ad=0.68p pd=4.68u as=0.38p ps=2.38u w=2u l=0.13u
X617 a_311846_195517# user_project_wrapper_0.sg13g2_IOPadAnalog_29.padres a_309917_194695# VDD3 sg13_lv_pmos ad=0.24415p pd=1.665u as=0.24415p ps=1.665u w=1.285u l=0.35u
X618 user_project_wrapper_0.IOVDD1 a_41476_217444# user_project_wrapper_0.analog_io[5] user_project_wrapper_0.IOVDD1 sg13_hv_pmos ad=2.1312p pd=7.3u as=3.9294p ps=7.84u w=6.66u l=0.6u
X619 user_project_wrapper_0.analog_io[32] a_202114_326125# user_project_wrapper_0.IOVSS1 user_project_wrapper_0.IOVSS1 sg13_lv_pmos ad=1.824p pd=9.98u as=1.824p ps=9.98u w=9.6u l=0.13u
X620 a_79025_135674# a_78824_135221# user_project_wrapper_0.VDD1 user_project_wrapper_0.VDD1 sg13_lv_pmos ad=0.95p pd=5.38u as=1.7p ps=10.68u w=5u l=0.15u
X621 VDD3 a_296625_208423# a_296731_208493# VDD3 sg13_lv_pmos ad=0.2603p pd=1.75u as=0.2603p ps=1.75u w=1.37u l=0.35u
X622 a_192309_92557# a_191751_90472# user_project_wrapper_0.IOVSS1 rppd l=10u w=1u
X623 a_309917_194695# user_project_wrapper_0.sg13g2_IOPadAnalog_29.padres a_311846_195517# VDD3 sg13_lv_pmos ad=0.24415p pd=1.665u as=0.24415p ps=1.665u w=1.285u l=0.35u
X624 a_309917_199879# a_309516_194555# VDD3 VDD3 sg13_lv_pmos ad=0.19p pd=1.38u as=0.19p ps=1.38u w=1u l=0.7u
X625 user_project_wrapper_0.IOVSS1 user_project_wrapper_0.sg13g2_IOPadIOVdd_3.sg13g2_Clamp_N43N43D4R_0.gate IOVDD3 user_project_wrapper_0.IOVSS1 sg13_hv_nmos ad=1.408p pd=5.04u as=2.596p ps=5.58u w=4.4u l=0.6u
X626 a_309917_194695# a_309516_194555# VDD3 VDD3 sg13_lv_pmos ad=0.19p pd=1.38u as=0.19p ps=1.38u w=1u l=0.7u
X627 user_project_wrapper_0.analog_io[33] a_237844_355624# user_project_wrapper_0.IOVDD4 user_project_wrapper_0.IOVDD4 sg13_hv_pmos ad=3.9294p pd=7.84u as=2.1312p ps=7.3u w=6.66u l=0.6u
X628 user_project_wrapper_0.analog_io[1] a_41476_135844# user_project_wrapper_0.IOVDD1 user_project_wrapper_0.IOVDD1 sg13_hv_pmos ad=3.9294p pd=7.84u as=2.1312p ps=7.3u w=6.66u l=0.6u
X629 user_project_wrapper_0.analog_io[27] a_182931_326125# user_project_wrapper_0.IOVSS1 user_project_wrapper_0.IOVSS1 sg13_lv_nmos ad=0.912p pd=5.18u as=0.912p ps=5.18u w=4.8u l=0.13u
X630 a_304995_198817# a_307232_196607# user_project_wrapper_0.IOVSS1 user_project_wrapper_0.IOVSS1 sg13_lv_nmos ad=0.6327p pd=3.71u as=0.6327p ps=3.71u w=3.33u l=0.2u
X631 analog_io[19] a_355624_135844# IOVDD3 IOVDD3 sg13_hv_pmos ad=3.9294p pd=7.84u as=2.1312p ps=7.3u w=6.66u l=0.6u
X632 user_project_wrapper_0.IOVDD1 user_project_wrapper_0.sg13g2_IOPadIOVdd_1.sg13g2_Clamp_N43N43D4R_0.gate user_project_wrapper_0.IOVSS1 user_project_wrapper_0.IOVSS1 sg13_hv_nmos ad=2.596p pd=5.58u as=1.408p ps=5.04u w=4.4u l=0.6u
X633 user_project_wrapper_0.IOVDD4 a_156244_355624# user_project_wrapper_0.analog_io[29] user_project_wrapper_0.IOVDD4 sg13_hv_pmos ad=2.1312p pd=7.3u as=3.9294p ps=7.84u w=6.66u l=0.6u
X634 user_project_wrapper_0.analog_io[13] a_197044_41476# user_project_wrapper_0.IOVDD2 user_project_wrapper_0.IOVDD2 sg13_hv_pmos ad=3.9294p pd=7.84u as=2.1312p ps=7.3u w=6.66u l=0.6u
X635 VDD3 user_project_wrapper_0.sg13g2_IOPadVdd_0.sg13g2_RCClampInverter_noptap_0.out user_project_wrapper_0.IOVSS1 user_project_wrapper_0.IOVSS1 sg13_hv_nmos ad=2.596p pd=5.58u as=1.408p ps=5.04u w=4.4u l=0.6u
X636 user_project_wrapper_0.VDD1 user_project_wrapper_0.sg13g2_IOPadVdd_2.sg13g2_RCClampInverter_noptap_0.out user_project_wrapper_0.IOVSS1 user_project_wrapper_0.IOVSS1 sg13_hv_nmos ad=2.596p pd=5.58u as=1.408p ps=5.04u w=4.4u l=0.6u
X637 a_304995_198817# a_304889_199957# a_304196_200821# user_project_wrapper_0.IOVSS1 sg13_lv_nmos ad=0.209p pd=1.48u as=0.209p ps=1.48u w=1.1u l=0.15u
X638 a_210621_327491# a_210417_327491# user_project_wrapper_0.IOVSS1 w_207887_327938# sg13_lv_pmos ad=0.38p pd=2.38u as=0.68p ps=4.68u w=2u l=0.13u
X639 user_project_wrapper_0.IOVDD1 a_41476_115444# user_project_wrapper_0.analog_io[0] user_project_wrapper_0.IOVDD1 sg13_hv_pmos ad=2.1312p pd=7.3u as=3.9294p ps=7.84u w=6.66u l=0.6u
X640 user_project_wrapper_0.IOVDD4 a_217444_355624# user_project_wrapper_0.analog_io[32] user_project_wrapper_0.IOVDD4 sg13_hv_pmos ad=2.1312p pd=7.3u as=3.9294p ps=7.84u w=6.66u l=0.6u
X641 user_project_wrapper_0.sg13g2_IOPadIOVdd_3.sg13g2_Clamp_N43N43D4R_0.gate user_project_wrapper_0.sg13g2_IOPadIOVdd_3.sg13g2_RCClampResistor_0.p2 IOVDD3 IOVDD3 sg13_hv_pmos ad=1.33p pd=7.38u as=1.33p ps=7.38u w=7u l=0.5u
X642 user_project_wrapper_0.analog_io[30] a_176644_355624# user_project_wrapper_0.IOVDD4 user_project_wrapper_0.IOVDD4 sg13_hv_pmos ad=3.9294p pd=7.84u as=2.1312p ps=7.3u w=6.66u l=0.6u
X643 user_project_wrapper_0.sg13g2_IOPadAnalog_16.padres user_project_wrapper_0.IOVDD4 dpantenna l=0.64u w=4.98u
X644 analog_io[23] a_355624_237844# IOVDD3 IOVDD3 sg13_hv_pmos ad=3.9294p pd=7.84u as=2.1312p ps=7.3u w=6.66u l=0.6u
X645 IOVDD3 a_355624_176644# analog_io[20] IOVDD3 sg13_hv_pmos ad=2.1312p pd=7.3u as=3.9294p ps=7.84u w=6.66u l=0.6u
X646 user_project_wrapper_0.VDD1 a_79025_129571# a_82658_129203# user_project_wrapper_0.VDD1 sg13_lv_pmos ad=0.3808p pd=2.92u as=0.2128p ps=1.5u w=1.12u l=0.13u
X647 user_project_wrapper_0.analog_io[35] a_278644_355624# user_project_wrapper_0.IOVDD4 user_project_wrapper_0.IOVDD4 sg13_hv_pmos ad=3.9294p pd=7.84u as=2.1312p ps=7.3u w=6.66u l=0.6u
X648 a_311189_185546# a_296731_189665# a_313884_185173# user_project_wrapper_0.IOVSS1 sg13_lv_nmos ad=1.9p pd=10.38u as=1.9p ps=10.38u w=10u l=0.5u
X649 user_project_wrapper_0.IOVDD2 a_237844_41476# user_project_wrapper_0.analog_io[15] user_project_wrapper_0.IOVDD2 sg13_hv_pmos ad=2.1312p pd=7.3u as=3.9294p ps=7.84u w=6.66u l=0.6u
X650 a_296731_208493# a_301186_192011# user_project_wrapper_0.IOVSS1 user_project_wrapper_0.IOVSS1 sg13_lv_nmos ad=0.912p pd=5.18u as=0.912p ps=5.18u w=4.8u l=1.06u
X651 user_project_wrapper_0.IOVSS1 user_project_wrapper_0.sg13g2_IOPadIOVdd_2.sg13g2_RCClampResistor_0.p2 user_project_wrapper_0.IOVSS1 user_project_wrapper_0.IOVSS1 sg13_hv_nmos ad=1.71p pd=9.38u as=0 ps=0 w=9u l=9.5u
X652 user_project_wrapper_0.IOVSS1 user_project_wrapper_0.sg13g2_IOPadVdd_2.sg13g2_RCClampInverter_noptap_0.out user_project_wrapper_0.VDD1 user_project_wrapper_0.IOVSS1 sg13_hv_nmos ad=1.408p pd=5.04u as=2.596p ps=5.58u w=4.4u l=0.6u
X653 user_project_wrapper_0.IOVSS1 a_278644_29676# QDLL_TOP_0.VOUT user_project_wrapper_0.IOVSS1 sg13_hv_nmos ad=1.408p pd=5.04u as=2.596p ps=5.58u w=4.4u l=0.6u
X654 a_87105_130835# a_86594_130470# user_project_wrapper_0.VDD1 user_project_wrapper_0.VDD1 sg13_lv_pmos ad=0.2128p pd=1.5u as=0.3808p ps=2.92u w=1.12u l=0.13u
X655 user_project_wrapper_0.analog_io[32] a_202114_326125# user_project_wrapper_0.IOVSS1 user_project_wrapper_0.IOVSS1 sg13_lv_nmos ad=0.912p pd=5.18u as=0.912p ps=5.18u w=4.8u l=0.13u
X656 user_project_wrapper_0.IOVDD2 a_278644_41476# QDLL_TOP_0.VOUT user_project_wrapper_0.IOVDD2 sg13_hv_pmos ad=2.1312p pd=7.3u as=3.9294p ps=7.84u w=6.66u l=0.6u
X657 VDD3 user_project_wrapper_0.sg13g2_IOPadVdd_0.sg13g2_RCClampInverter_noptap_0.out user_project_wrapper_0.IOVSS1 user_project_wrapper_0.IOVSS1 sg13_hv_nmos ad=2.596p pd=5.58u as=1.408p ps=5.04u w=4.4u l=0.6u
X658 user_project_wrapper_0.IOVDD4 user_project_wrapper_0.sg13g2_IOPadIOVdd_2.sg13g2_Clamp_N43N43D4R_0.gate user_project_wrapper_0.IOVSS1 user_project_wrapper_0.IOVSS1 sg13_hv_nmos ad=2.596p pd=5.58u as=1.408p ps=5.04u w=4.4u l=0.6u
X659 analog_io[20] a_369296_176644# user_project_wrapper_0.IOVSS1 user_project_wrapper_0.IOVSS1 sg13_hv_nmos ad=2.596p pd=5.58u as=1.408p ps=5.04u w=4.4u l=0.6u
X660 a_182931_326125# a_186202_326221# user_project_wrapper_0.IOVSS1 user_project_wrapper_0.IOVSS1 sg13_lv_nmos ad=0.912p pd=5.18u as=0.912p ps=5.18u w=4.8u l=0.13u
X661 a_296731_189665# a_296625_189595# VDD3 VDD3 sg13_lv_pmos ad=0.2603p pd=1.75u as=0.2603p ps=1.75u w=1.37u l=0.35u
X662 user_project_wrapper_0.ui_PAD[31] user_project_wrapper_0.IOVDD4 dpantenna l=27.78u w=1.26u
X663 user_project_wrapper_0.IOVSS1 user_project_wrapper_0.sg13g2_IOPadVdd_0.sg13g2_RCClampInverter_noptap_0.out VDD3 user_project_wrapper_0.IOVSS1 sg13_hv_nmos ad=1.408p pd=5.04u as=2.596p ps=5.58u w=4.4u l=0.6u
X664 a_208855_324776# a_211928_324776# user_project_wrapper_0.IOVSS1 w_207989_323975# sg13_lv_pmos ad=0.38p pd=2.38u as=0.68p ps=4.68u w=2u l=0.13u
X665 user_project_wrapper_0.IOVSS1 user_project_wrapper_0.sg13g2_IOPadVdd_1.sg13g2_RCClampInverter_noptap_0.out user_project_wrapper_0.VDD2 user_project_wrapper_0.IOVSS1 sg13_hv_nmos ad=1.408p pd=5.04u as=2.596p ps=5.58u w=4.4u l=0.6u
X666 IOVDD3 user_project_wrapper_0.sg13g2_IOPadIOVdd_3.sg13g2_Clamp_N43N43D4R_0.gate user_project_wrapper_0.IOVSS1 user_project_wrapper_0.IOVSS1 sg13_hv_nmos ad=2.596p pd=5.58u as=1.408p ps=5.04u w=4.4u l=0.6u
X667 user_project_wrapper_0.sg13g2_IOPadIOVdd_2.sg13g2_Clamp_N43N43D4R_0.gate user_project_wrapper_0.sg13g2_IOPadIOVdd_2.sg13g2_RCClampResistor_0.p2 user_project_wrapper_0.IOVDD4 user_project_wrapper_0.IOVDD4 sg13_hv_pmos ad=1.33p pd=7.38u as=1.33p ps=7.38u w=7u l=0.5u
X668 user_project_wrapper_0.IOVSS1 a_217444_29676# user_project_wrapper_0.analog_io[14] user_project_wrapper_0.IOVSS1 sg13_hv_nmos ad=1.408p pd=5.04u as=2.596p ps=5.58u w=4.4u l=0.6u
X669 user_project_wrapper_0.IOVSS1 a_369296_115444# analog_io[18] user_project_wrapper_0.IOVSS1 sg13_hv_nmos ad=1.408p pd=5.04u as=2.596p ps=5.58u w=4.4u l=0.6u
X670 user_project_wrapper_0.VDD1 a_85127_131750# a_87434_129426# user_project_wrapper_0.VDD1 sg13_lv_pmos ad=0.3808p pd=2.92u as=0.2128p ps=1.5u w=1.12u l=0.13u
X671 user_project_wrapper_0.IOVDD1 a_41476_135844# user_project_wrapper_0.analog_io[1] user_project_wrapper_0.IOVDD1 sg13_hv_pmos ad=2.1312p pd=7.3u as=3.9294p ps=7.84u w=6.66u l=0.6u
X672 a_304196_200821# a_304090_197941# a_296625_208423# user_project_wrapper_0.IOVSS1 sg13_lv_nmos ad=0.646p pd=4.48u as=0.361p ps=2.28u w=1.9u l=0.16u
X673 user_project_wrapper_0.IOVSS1 a_189016_99480# a_189148_99070# user_project_wrapper_0.IOVSS1 sg13_lv_nmos ad=0.1405p pd=1.15u as=0.2163p ps=1.87u w=0.42u l=0.18u
X674 VDD3 a_314697_196700# a_301186_192011# VDD3 sg13_lv_pmos ad=1.14p pd=6.38u as=1.14p ps=6.38u w=6u l=2.5u
X675 user_project_wrapper_0.sg13g2_IOPadVdd_0.sg13g2_RCClampInverter_noptap_0.out user_project_wrapper_0.sg13g2_IOPadVdd_0.sg13g2_RCClampResistor_0.p2 user_project_wrapper_0.IOVSS1 user_project_wrapper_0.IOVSS1 sg13_hv_nmos ad=1.71p pd=9.38u as=1.71p ps=9.38u w=9u l=0.5u
X676 user_project_wrapper_0.IOVSS1 a_29676_135844# user_project_wrapper_0.analog_io[1] user_project_wrapper_0.IOVSS1 sg13_hv_nmos ad=1.408p pd=5.04u as=2.596p ps=5.58u w=4.4u l=0.6u
X677 user_project_wrapper_0.analog_io[4] a_29676_197044# user_project_wrapper_0.IOVSS1 user_project_wrapper_0.IOVSS1 sg13_hv_nmos ad=2.596p pd=5.58u as=1.408p ps=5.04u w=4.4u l=0.6u
X678 user_project_wrapper_0.IOVSS1 user_project_wrapper_0.sg13g2_IOPadVdd_3.sg13g2_RCClampInverter_noptap_0.out user_project_wrapper_0.IOVSS1 user_project_wrapper_0.IOVSS1 sg13_hv_nmos ad=2.596p pd=5.58u as=0 ps=0 w=4.4u l=0.6u
X679 user_project_wrapper_0.IOVSS1 user_project_wrapper_0.sg13g2_IOPadIOVdd_1.sg13g2_Clamp_N43N43D4R_0.gate user_project_wrapper_0.IOVDD1 user_project_wrapper_0.IOVSS1 sg13_hv_nmos ad=1.408p pd=5.04u as=2.596p ps=5.58u w=4.4u l=0.6u
X680 a_209905_326377# a_208939_326377# user_project_wrapper_0.IOVSS1 w_207887_326203# sg13_lv_pmos ad=0.38p pd=2.38u as=0.68p ps=4.68u w=2u l=0.13u
X681 user_project_wrapper_0.analog_io[35] a_278644_369296# user_project_wrapper_0.IOVSS1 user_project_wrapper_0.IOVSS1 sg13_hv_nmos ad=2.596p pd=5.58u as=2.068p ps=9.74u w=4.4u l=0.6u
X682 a_35456_74695# a_39542_75025# user_project_wrapper_0.IOVSS1 rppd l=20u w=1u
X683 a_296731_189665# a_296625_189595# VDD3 VDD3 sg13_lv_pmos ad=0.2603p pd=1.75u as=0.2603p ps=1.75u w=1.37u l=0.35u
X684 user_project_wrapper_0.analog_io[27] a_182931_326125# user_project_wrapper_0.IOVSS1 user_project_wrapper_0.IOVSS1 sg13_lv_pmos ad=1.824p pd=9.98u as=1.824p ps=9.98u w=9.6u l=0.13u
X685 user_project_wrapper_0.IOVSS1 a_135844_369296# user_project_wrapper_0.analog_io[28] user_project_wrapper_0.IOVSS1 sg13_hv_nmos ad=1.408p pd=5.04u as=2.596p ps=5.58u w=4.4u l=0.6u
X686 user_project_wrapper_0.sg13g2_IOPadIOVdd_3.sg13g2_Clamp_N43N43D4R_0.gate user_project_wrapper_0.sg13g2_IOPadIOVdd_3.sg13g2_RCClampResistor_0.p2 IOVDD3 IOVDD3 sg13_hv_pmos ad=1.33p pd=7.38u as=1.33p ps=7.38u w=7u l=0.5u
X687 user_project_wrapper_0.analog_io[33] a_237844_355624# user_project_wrapper_0.IOVDD4 user_project_wrapper_0.IOVDD4 sg13_hv_pmos ad=3.9294p pd=7.84u as=2.1312p ps=7.3u w=6.66u l=0.6u
X688 a_187364_324106# a_190047_324119# user_project_wrapper_0.IOVSS1 user_project_wrapper_0.IOVSS1 sg13_lv_nmos ad=0.19p pd=1.38u as=0.19p ps=1.38u w=1u l=0.13u
X689 IOVDD3 a_355624_115444# analog_io[18] IOVDD3 sg13_hv_pmos ad=2.1312p pd=7.3u as=3.9294p ps=7.84u w=6.66u l=0.6u
X690 user_project_wrapper_0.IOVSS1 user_project_wrapper_0.sg13g2_IOPadIOVdd_3.sg13g2_Clamp_N43N43D4R_0.gate IOVDD3 user_project_wrapper_0.IOVSS1 sg13_hv_nmos ad=1.408p pd=5.04u as=2.596p ps=5.58u w=4.4u l=0.6u
X691 a_78655_364458# a_78325_360372# user_project_wrapper_0.IOVSS1 rppd l=20u w=1u
X692 a_296731_189665# a_296625_189595# VDD3 VDD3 sg13_lv_pmos ad=0.2603p pd=1.75u as=0.4658p ps=3.42u w=1.37u l=0.35u
X693 user_project_wrapper_0.IOVSS1 a_213870_324142# user_project_wrapper_0.analog_io[35] user_project_wrapper_0.IOVSS1 sg13_lv_pmos ad=1.824p pd=9.98u as=1.824p ps=9.98u w=9.6u l=0.13u
X694 user_project_wrapper_0.analog_io[27] a_182931_326125# user_project_wrapper_0.IOVSS1 user_project_wrapper_0.IOVSS1 sg13_lv_pmos ad=1.824p pd=9.98u as=1.824p ps=9.98u w=9.6u l=0.13u
X695 user_project_wrapper_0.analog_io[14] a_217444_41476# user_project_wrapper_0.IOVDD2 user_project_wrapper_0.IOVDD2 sg13_hv_pmos ad=3.9294p pd=7.84u as=2.1312p ps=7.3u w=6.66u l=0.6u
X696 user_project_wrapper_0.VDD1 user_project_wrapper_0.sg13g2_IOPadVdd_2.sg13g2_RCClampInverter_noptap_0.out user_project_wrapper_0.IOVSS1 user_project_wrapper_0.IOVSS1 sg13_hv_nmos ad=3.256p pd=10.28u as=1.408p ps=5.04u w=4.4u l=0.6u
X697 a_190297_325263# a_189756_325263# user_project_wrapper_0.IOVSS1 w_188704_326203# sg13_lv_pmos ad=0.68p pd=4.68u as=0.68p ps=4.68u w=2u l=0.13u
X698 a_307232_196607# a_296731_208493# a_309917_199879# VDD3 sg13_lv_pmos ad=0.24415p pd=1.665u as=0.24415p ps=1.665u w=1.285u l=0.35u
X699 user_project_wrapper_0.analog_io[15] a_190389_101343# QDLL_TOP_0.VDD QDLL_TOP_0.VDD sg13_lv_pmos ad=0.2128p pd=1.5u as=0.2128p ps=1.5u w=1.12u l=0.13u
X700 user_project_wrapper_0.IOVDD2 a_278644_41476# QDLL_TOP_0.VOUT user_project_wrapper_0.IOVDD2 sg13_hv_pmos ad=2.1312p pd=7.3u as=3.9294p ps=7.84u w=6.66u l=0.6u
X701 VDD3 a_309516_194555# a_309917_199879# VDD3 sg13_lv_pmos ad=0.19p pd=1.38u as=0.19p ps=1.38u w=1u l=0.7u
X702 user_project_wrapper_0.analog_io[16] a_258244_29676# user_project_wrapper_0.IOVSS1 user_project_wrapper_0.IOVSS1 sg13_hv_nmos ad=2.596p pd=5.58u as=2.068p ps=9.74u w=4.4u l=0.6u
X703 a_304995_198817# a_304889_199957# a_304196_200821# user_project_wrapper_0.IOVSS1 sg13_lv_nmos ad=0.374p pd=2.88u as=0.209p ps=1.48u w=1.1u l=0.15u
X704 IOVDD3 a_355624_217444# analog_io[23] IOVDD3 sg13_hv_pmos ad=2.1312p pd=7.3u as=3.9294p ps=7.84u w=6.66u l=0.6u
X705 user_project_wrapper_0.IOVDD2 a_297775_35456# user_project_wrapper_0.IOVSS1 rppd l=20u w=1u
X706 user_project_wrapper_0.IOVSS1 a_307232_196607# a_304995_198817# user_project_wrapper_0.IOVSS1 sg13_lv_nmos ad=0.6327p pd=3.71u as=0.6327p ps=3.71u w=3.33u l=0.2u
X707 user_project_wrapper_0.analog_io[5] user_project_wrapper_0.IOVDD1 dpantenna l=27.78u w=1.26u
X708 a_87673_125210# a_87627_124843# a_87571_125210# user_project_wrapper_0.IOVSS1 sg13_lv_nmos ad=0.1406p pd=1.12u as=0.1406p ps=1.12u w=0.74u l=0.13u
X709 a_309917_194695# a_309516_194555# VDD3 VDD3 sg13_lv_pmos ad=0.19p pd=1.38u as=0.19p ps=1.38u w=1u l=0.7u
X710 user_project_wrapper_0.IOVSS1 a_176644_369296# user_project_wrapper_0.analog_io[30] user_project_wrapper_0.IOVSS1 sg13_hv_nmos ad=1.408p pd=5.04u as=2.596p ps=5.58u w=4.4u l=0.6u
X711 user_project_wrapper_0.IOVDD2 a_237844_41476# user_project_wrapper_0.analog_io[15] user_project_wrapper_0.IOVDD2 sg13_hv_pmos ad=2.1312p pd=7.3u as=3.9294p ps=7.84u w=6.66u l=0.6u
X712 a_35456_300415# a_39542_300745# user_project_wrapper_0.IOVSS1 rppd l=20u w=1u
X713 a_176644_29676# user_project_wrapper_0.IOVSS1 user_project_wrapper_0.IOVSS1 rppd l=3.54u w=0.5u
X714 user_project_wrapper_0.IOVSS1 user_project_wrapper_0.sg13g2_IOPadVdd_3.sg13g2_RCClampInverter_noptap_0.out user_project_wrapper_0.IOVSS1 user_project_wrapper_0.IOVSS1 sg13_hv_nmos ad=1.408p pd=5.04u as=0 ps=0 w=4.4u l=0.6u
X715 user_project_wrapper_0.IOVDD4 user_project_wrapper_0.sg13g2_IOPadIOVdd_2.sg13g2_Clamp_N43N43D4R_0.gate user_project_wrapper_0.IOVSS1 user_project_wrapper_0.IOVSS1 sg13_hv_nmos ad=2.596p pd=5.58u as=1.408p ps=5.04u w=4.4u l=0.6u
X716 user_project_wrapper_0.IOVSS1 a_208017_326341# a_209041_325785# w_207887_326203# sg13_lv_pmos ad=0.68p pd=4.68u as=0.38p ps=2.38u w=2u l=0.13u
X717 a_35456_77995# a_39542_77665# user_project_wrapper_0.IOVSS1 rppd l=20u w=1u
X718 QDLL_TOP_0.VDD a_270178_100118# a_270512_100118# QDLL_TOP_0.VDD sg13_lv_pmos ad=0.2128p pd=1.5u as=0.2128p ps=1.5u w=1.12u l=0.13u
X719 user_project_wrapper_0.IOVDD4 user_project_wrapper_0.sg13g2_IOPadIOVdd_2.sg13g2_Clamp_N43N43D4R_0.gate user_project_wrapper_0.IOVSS1 user_project_wrapper_0.IOVSS1 sg13_hv_nmos ad=2.596p pd=5.58u as=1.408p ps=5.04u w=4.4u l=0.6u
X720 a_296731_208493# a_296625_208423# VDD3 VDD3 sg13_lv_pmos ad=0.2603p pd=1.75u as=0.4658p ps=3.42u w=1.37u l=0.35u
X721 user_project_wrapper_0.IOVSS1 a_82527_127455# a_83586_127455# user_project_wrapper_0.IOVSS1 sg13_lv_nmos ad=0.2516p pd=2.16u as=0.1406p ps=1.12u w=0.74u l=0.13u
X722 user_project_wrapper_0.IOVSS1 a_217444_29676# user_project_wrapper_0.analog_io[14] user_project_wrapper_0.IOVSS1 sg13_hv_nmos ad=1.408p pd=5.04u as=2.596p ps=5.58u w=4.4u l=0.6u
X723 user_project_wrapper_0.IOVSS1 a_213870_324142# user_project_wrapper_0.analog_io[35] user_project_wrapper_0.IOVSS1 sg13_lv_pmos ad=1.824p pd=9.98u as=1.824p ps=9.98u w=9.6u l=0.13u
X724 user_project_wrapper_0.analog_io[12] a_176644_41476# user_project_wrapper_0.IOVDD2 user_project_wrapper_0.IOVDD2 sg13_hv_pmos ad=3.9294p pd=7.84u as=2.1312p ps=7.3u w=6.66u l=0.6u
X725 user_project_wrapper_0.IOVSS1 user_project_wrapper_0.sg13g2_IOPadVdd_3.sg13g2_RCClampInverter_noptap_0.out user_project_wrapper_0.IOVSS1 user_project_wrapper_0.IOVSS1 sg13_hv_nmos ad=2.596p pd=5.58u as=0 ps=0 w=4.4u l=0.6u
X726 user_project_wrapper_0.analog_io[27] a_182931_326125# user_project_wrapper_0.IOVSS1 user_project_wrapper_0.IOVSS1 sg13_lv_pmos ad=1.824p pd=9.98u as=1.824p ps=9.98u w=9.6u l=0.13u
X727 user_project_wrapper_0.IOVSS1 user_project_wrapper_0.sg13g2_IOPadVdd_0.sg13g2_RCClampInverter_noptap_0.out VDD3 user_project_wrapper_0.IOVSS1 sg13_hv_nmos ad=1.408p pd=5.04u as=2.596p ps=5.58u w=4.4u l=0.6u
X728 user_project_wrapper_0.IOVSS1 user_project_wrapper_0.IOVSS1 user_project_wrapper_0.IOVSS1 rppd l=0.5u w=0.5u
X729 a_296731_208493# a_296625_208423# VDD3 VDD3 sg13_lv_pmos ad=0.2603p pd=1.75u as=0.2603p ps=1.75u w=1.37u l=0.35u
X730 VDD3 a_296626_197740# a_296732_200582# VDD3 sg13_lv_pmos ad=1.33p pd=7.38u as=1.33p ps=7.38u w=7u l=0.7u
X731 user_project_wrapper_0.IOVDD4 a_237844_355624# user_project_wrapper_0.analog_io[33] user_project_wrapper_0.IOVDD4 sg13_hv_pmos ad=2.1312p pd=7.3u as=3.9294p ps=7.84u w=6.66u l=0.6u
X732 user_project_wrapper_0.sg13g2_IOPadIOVdd_2.sg13g2_Clamp_N43N43D4R_0.gate user_project_wrapper_0.sg13g2_IOPadIOVdd_2.sg13g2_RCClampResistor_0.p2 user_project_wrapper_0.IOVDD4 user_project_wrapper_0.IOVDD4 sg13_hv_pmos ad=1.33p pd=7.38u as=1.33p ps=7.38u w=7u l=0.5u
X733 user_project_wrapper_0.VDD1 user_project_wrapper_0.sg13g2_IOPadVdd_2.sg13g2_RCClampInverter_noptap_0.out user_project_wrapper_0.IOVSS1 user_project_wrapper_0.IOVSS1 sg13_hv_nmos ad=2.596p pd=5.58u as=1.408p ps=5.04u w=4.4u l=0.6u
X734 a_79025_124824# a_78824_124371# user_project_wrapper_0.VDD1 user_project_wrapper_0.VDD1 sg13_lv_pmos ad=0.95p pd=5.38u as=1.7p ps=10.68u w=5u l=0.15u
X735 a_309917_194695# a_309516_194555# VDD3 VDD3 sg13_lv_pmos ad=0.19p pd=1.38u as=0.19p ps=1.38u w=1u l=0.7u
X736 a_82846_240684# user_project_wrapper_0.sg13g2_IOPadAnalog_14.padres a_82859_239376# user_project_wrapper_0.VDD1 sg13_lv_pmos ad=1.7p pd=10.68u as=0.95p ps=5.38u w=5u l=0.3u
X737 a_182931_326125# a_186202_326221# user_project_wrapper_0.IOVSS1 user_project_wrapper_0.IOVSS1 sg13_lv_pmos ad=1.824p pd=9.98u as=1.824p ps=9.98u w=9.6u l=0.13u
X738 a_190824_325263# a_190501_325263# a_190722_325785# w_188704_326203# sg13_lv_pmos ad=0.38p pd=2.38u as=0.38p ps=2.38u w=2u l=0.13u
X739 VDD3 a_296626_197740# a_296732_200582# VDD3 sg13_lv_pmos ad=2.38p pd=14.68u as=1.33p ps=7.38u w=7u l=0.7u
X740 VDD3 a_296625_189595# a_296731_189665# VDD3 sg13_lv_pmos ad=0.2603p pd=1.75u as=0.2603p ps=1.75u w=1.37u l=0.35u
X741 a_296731_208493# a_296625_208423# VDD3 VDD3 sg13_lv_pmos ad=0.2603p pd=1.75u as=0.4658p ps=3.42u w=1.37u l=0.35u
X742 user_project_wrapper_0.IOVSS1 user_project_wrapper_0.sg13g2_IOPadIOVdd_2.sg13g2_Clamp_N43N43D4R_0.gate user_project_wrapper_0.IOVDD4 user_project_wrapper_0.IOVSS1 sg13_hv_nmos ad=1.408p pd=5.04u as=2.596p ps=5.58u w=4.4u l=0.6u
X743 a_210621_327491# TOP_ROILIFNEURON_0.MEM user_project_wrapper_0.IOVSS1 rppd l=0.5u w=0.5u
X744 user_project_wrapper_0.IOVDD1 user_project_wrapper_0.sg13g2_IOPadIOVdd_1.sg13g2_Clamp_N43N43D4R_0.gate user_project_wrapper_0.IOVSS1 user_project_wrapper_0.IOVSS1 sg13_hv_nmos ad=2.596p pd=5.58u as=1.408p ps=5.04u w=4.4u l=0.6u
X745 user_project_wrapper_0.IOVSS1 user_project_wrapper_0.analog_io[14] dantenna l=1.26u w=27.78u
X746 a_208017_326341# a_208017_326341# user_project_wrapper_0.IOVSS1 w_207887_326203# sg13_lv_pmos ad=0.68p pd=4.68u as=0.68p ps=4.68u w=2u l=0.13u
X747 user_project_wrapper_0.IOVSS1 user_project_wrapper_0.sg13g2_IOPadIOVdd_2.sg13g2_Clamp_N43N43D4R_0.gate user_project_wrapper_0.IOVDD4 user_project_wrapper_0.IOVSS1 sg13_hv_nmos ad=1.408p pd=5.04u as=2.596p ps=5.58u w=4.4u l=0.6u
X748 VDD3 a_296625_189595# a_296731_189665# VDD3 sg13_lv_pmos ad=0.2603p pd=1.75u as=0.2603p ps=1.75u w=1.37u l=0.35u
X749 user_project_wrapper_0.IOVDD2 a_176644_41476# user_project_wrapper_0.analog_io[12] user_project_wrapper_0.IOVDD2 sg13_hv_pmos ad=2.1312p pd=7.3u as=3.9294p ps=7.84u w=6.66u l=0.6u
X750 user_project_wrapper_0.analog_io[32] a_202114_326125# user_project_wrapper_0.IOVSS1 user_project_wrapper_0.IOVSS1 sg13_lv_pmos ad=1.824p pd=9.98u as=1.824p ps=9.98u w=9.6u l=0.13u
X751 user_project_wrapper_0.IOVDD4 a_278644_355624# user_project_wrapper_0.analog_io[35] user_project_wrapper_0.IOVDD4 sg13_hv_pmos ad=2.1312p pd=7.3u as=3.9294p ps=7.84u w=6.66u l=0.6u
X752 user_project_wrapper_0.IOVSS1 user_project_wrapper_0.IOVSS1 user_project_wrapper_0.IOVSS1 rppd l=0.5u w=0.5u
X753 VDD3 user_project_wrapper_0.sg13g2_IOPadVdd_0.sg13g2_RCClampInverter_noptap_0.out user_project_wrapper_0.IOVSS1 user_project_wrapper_0.IOVSS1 sg13_hv_nmos ad=2.596p pd=5.58u as=1.408p ps=5.04u w=4.4u l=0.6u
X754 VDD3 user_project_wrapper_0.sg13g2_IOPadVdd_0.sg13g2_RCClampInverter_noptap_0.out user_project_wrapper_0.IOVSS1 user_project_wrapper_0.IOVSS1 sg13_hv_nmos ad=2.596p pd=5.58u as=1.408p ps=5.04u w=4.4u l=0.6u
X755 user_project_wrapper_0.analog_io[29] a_156244_369296# user_project_wrapper_0.IOVSS1 user_project_wrapper_0.IOVSS1 sg13_hv_nmos ad=2.596p pd=5.58u as=1.408p ps=5.04u w=4.4u l=0.6u
X756 IOVDD3 a_355624_135844# analog_io[19] IOVDD3 sg13_hv_pmos ad=2.1312p pd=7.3u as=3.9294p ps=7.84u w=6.66u l=0.6u
X757 analog_io[22] a_355624_197044# IOVDD3 IOVDD3 sg13_hv_pmos ad=3.9294p pd=7.84u as=2.1312p ps=7.3u w=6.66u l=0.6u
X758 a_296731_208493# a_301186_192011# user_project_wrapper_0.IOVSS1 user_project_wrapper_0.IOVSS1 sg13_lv_nmos ad=0.912p pd=5.18u as=0.912p ps=5.18u w=4.8u l=1.06u
X759 user_project_wrapper_0.IOVSS1 user_project_wrapper_0.IOVSS1 user_project_wrapper_0.IOVSS1 rhigh l=4u w=0.5u
X760 user_project_wrapper_0.sg13g2_IOPadIOVdd_0.sg13g2_Clamp_N43N43D4R_0.gate user_project_wrapper_0.sg13g2_IOPadIOVdd_0.sg13g2_RCClampResistor_0.p2 user_project_wrapper_0.IOVDD2 user_project_wrapper_0.IOVDD2 sg13_hv_pmos ad=1.33p pd=7.38u as=2.38p ps=14.68u w=7u l=0.5u
X761 IOVDD3 user_project_wrapper_0.sg13g2_IOPadIOVdd_3.sg13g2_Clamp_N43N43D4R_0.gate user_project_wrapper_0.IOVSS1 user_project_wrapper_0.IOVSS1 sg13_hv_nmos ad=2.596p pd=5.58u as=1.408p ps=5.04u w=4.4u l=0.6u
X762 IOVDD3 user_project_wrapper_0.sg13g2_IOPadIOVdd_3.sg13g2_Clamp_N43N43D4R_0.gate user_project_wrapper_0.IOVSS1 user_project_wrapper_0.IOVSS1 sg13_hv_nmos ad=2.596p pd=5.58u as=1.408p ps=5.04u w=4.4u l=0.6u
X763 user_project_wrapper_0.analog_io[4] a_29676_197044# user_project_wrapper_0.IOVSS1 user_project_wrapper_0.IOVSS1 sg13_hv_nmos ad=2.596p pd=5.58u as=1.408p ps=5.04u w=4.4u l=0.6u
X764 user_project_wrapper_0.analog_io[16] a_258244_41476# user_project_wrapper_0.IOVDD2 user_project_wrapper_0.IOVDD2 sg13_hv_pmos ad=3.9294p pd=7.84u as=2.1312p ps=7.3u w=6.66u l=0.6u
X765 user_project_wrapper_0.IOVSS1 user_project_wrapper_0.sg13g2_IOPadIOVdd_1.sg13g2_RCClampResistor_0.p2 user_project_wrapper_0.IOVSS1 user_project_wrapper_0.IOVSS1 sg13_hv_nmos ad=1.71p pd=9.38u as=0 ps=0 w=9u l=9.5u
X766 user_project_wrapper_0.IOVSS1 a_301186_192011# a_296731_208493# user_project_wrapper_0.IOVSS1 sg13_lv_nmos ad=0.912p pd=5.18u as=0.912p ps=5.18u w=4.8u l=1.06u
X767 user_project_wrapper_0.IOVSS1 a_29676_217444# user_project_wrapper_0.IOVSS1 rppd l=3.54u w=0.5u
X768 a_210417_327491# a_210007_327491# user_project_wrapper_0.IOVSS1 w_207887_327938# sg13_lv_pmos ad=0.68p pd=4.68u as=0.68p ps=4.68u w=2u l=0.13u
X769 user_project_wrapper_0.analog_io[14] a_217444_41476# user_project_wrapper_0.IOVDD2 user_project_wrapper_0.IOVDD2 sg13_hv_pmos ad=3.9294p pd=7.84u as=3.1302p ps=14.26u w=6.66u l=0.6u
X770 VDD3 a_296625_208423# a_296731_208493# VDD3 sg13_lv_pmos ad=0.2603p pd=1.75u as=0.2603p ps=1.75u w=1.37u l=0.35u
X771 user_project_wrapper_0.IOVDD1 user_project_wrapper_0.sg13g2_IOPadIOVdd_1.sg13g2_Clamp_N43N43D4R_0.gate user_project_wrapper_0.IOVSS1 user_project_wrapper_0.IOVSS1 sg13_hv_nmos ad=2.596p pd=5.58u as=1.408p ps=5.04u w=4.4u l=0.6u
X772 VDD3 a_309516_194555# a_309917_199879# VDD3 sg13_lv_pmos ad=0.19p pd=1.38u as=0.19p ps=1.38u w=1u l=0.7u
X773 user_project_wrapper_0.IOVSS1 user_project_wrapper_0.analog_io[4] dantenna l=27.78u w=1.26u
X774 user_project_wrapper_0.IOVSS1 user_project_wrapper_0.sg13g2_IOPadVdd_0.sg13g2_RCClampInverter_noptap_0.out VDD3 user_project_wrapper_0.IOVSS1 sg13_hv_nmos ad=1.408p pd=5.04u as=2.596p ps=5.58u w=4.4u l=0.6u
X775 VDD3 a_296625_208423# a_296731_208493# VDD3 sg13_lv_pmos ad=0.2603p pd=1.75u as=0.2603p ps=1.75u w=1.37u l=0.35u
X776 a_208103_324155# a_208171_324119# user_project_wrapper_0.IOVSS1 w_207989_323975# sg13_lv_pmos ad=0.38p pd=2.38u as=0.38p ps=2.38u w=2u l=0.13u
X777 user_project_wrapper_0.IOVDD4 a_156244_355624# user_project_wrapper_0.analog_io[29] user_project_wrapper_0.IOVDD4 sg13_hv_pmos ad=2.1312p pd=7.3u as=3.9294p ps=7.84u w=6.66u l=0.6u
X778 user_project_wrapper_0.analog_io[13] a_197044_29676# user_project_wrapper_0.IOVSS1 user_project_wrapper_0.IOVSS1 sg13_hv_nmos ad=2.596p pd=5.58u as=1.408p ps=5.04u w=4.4u l=0.6u
X779 a_303385_39542# a_303055_35456# user_project_wrapper_0.IOVSS1 rppd l=20u w=1u
X780 user_project_wrapper_0.IOVSS1 IOVDD3 dpantenna l=1.26u w=27.78u
X781 a_304995_198817# a_304889_198885# a_304196_197873# user_project_wrapper_0.IOVSS1 sg13_lv_nmos ad=0.374p pd=2.88u as=0.209p ps=1.48u w=1.1u l=0.15u
X782 user_project_wrapper_0.IOVSS1 user_project_wrapper_0.sg13g2_IOPadIOVdd_1.sg13g2_RCClampResistor_0.p2 user_project_wrapper_0.IOVSS1 user_project_wrapper_0.IOVSS1 sg13_hv_nmos ad=1.71p pd=9.38u as=0 ps=0 w=9u l=9.5u
X783 analog_io[23] a_369296_237844# user_project_wrapper_0.IOVSS1 user_project_wrapper_0.IOVSS1 sg13_hv_nmos ad=2.596p pd=5.58u as=1.408p ps=5.04u w=4.4u l=0.6u
X784 VDD3 a_311108_179669# analog_io[20] user_project_wrapper_0.IOVSS1 sg13_lv_nmos ad=3.4p pd=20.68u as=3.4p ps=20.68u w=10u l=0.15u
X785 IOVDD3 a_355624_217444# analog_io[23] IOVDD3 sg13_hv_pmos ad=2.1312p pd=7.3u as=3.9294p ps=7.84u w=6.66u l=0.6u
X786 user_project_wrapper_0.analog_io[7] a_41476_258244# user_project_wrapper_0.IOVDD1 user_project_wrapper_0.IOVDD1 sg13_hv_pmos ad=3.9294p pd=7.84u as=2.1312p ps=7.3u w=6.66u l=0.6u
X787 user_project_wrapper_0.IOVSS1 user_project_wrapper_0.sg13g2_IOPadVdd_0.sg13g2_RCClampInverter_noptap_0.out VDD3 user_project_wrapper_0.IOVSS1 sg13_hv_nmos ad=1.408p pd=5.04u as=2.596p ps=5.58u w=4.4u l=0.6u
X788 analog_io[19] a_355624_135844# IOVDD3 IOVDD3 sg13_hv_pmos ad=3.9294p pd=7.84u as=3.1302p ps=14.26u w=6.66u l=0.6u
X789 a_86594_130470# a_85127_131750# user_project_wrapper_0.VDD1 user_project_wrapper_0.VDD1 sg13_lv_pmos ad=0.3808p pd=2.92u as=0.3808p ps=2.92u w=1.12u l=0.13u
X790 user_project_wrapper_0.IOVDD4 user_project_wrapper_0.sg13g2_IOPadIOVdd_2.sg13g2_Clamp_N43N43D4R_0.gate user_project_wrapper_0.IOVSS1 user_project_wrapper_0.IOVSS1 sg13_hv_nmos ad=2.596p pd=5.58u as=1.408p ps=5.04u w=4.4u l=0.6u
X791 a_182931_326125# a_186202_326221# user_project_wrapper_0.IOVSS1 user_project_wrapper_0.IOVSS1 sg13_lv_nmos ad=0.912p pd=5.18u as=0.912p ps=5.18u w=4.8u l=0.13u
X792 user_project_wrapper_0.IOVSS1 user_project_wrapper_0.sg13g2_IOPadIOVdd_1.sg13g2_Clamp_N43N43D4R_0.gate user_project_wrapper_0.IOVDD1 user_project_wrapper_0.IOVSS1 sg13_hv_nmos ad=1.408p pd=5.04u as=2.596p ps=5.58u w=4.4u l=0.6u
X793 a_302725_39542# a_303055_35456# user_project_wrapper_0.IOVSS1 rppd l=20u w=1u
X794 VDD3 a_296626_197740# a_296732_197880# VDD3 sg13_lv_pmos ad=2.38p pd=14.68u as=1.33p ps=7.38u w=7u l=0.7u
X795 user_project_wrapper_0.IOVSS1 a_213376_328627# a_213462_327536# user_project_wrapper_0.IOVSS1 sg13_lv_pmos ad=1.824p pd=9.98u as=1.824p ps=9.98u w=9.6u l=0.13u
X796 user_project_wrapper_0.IOVSS1 a_278644_29676# QDLL_TOP_0.VOUT user_project_wrapper_0.IOVSS1 sg13_hv_nmos ad=1.408p pd=5.04u as=2.596p ps=5.58u w=4.4u l=0.6u
X797 user_project_wrapper_0.IOVDD1 a_41476_115444# user_project_wrapper_0.IOVDD1 rppd l=12.9u w=0.5u
X798 user_project_wrapper_0.analog_io[6] a_29676_237844# user_project_wrapper_0.IOVSS1 user_project_wrapper_0.IOVSS1 sg13_hv_nmos ad=2.596p pd=5.58u as=1.408p ps=5.04u w=4.4u l=0.6u
X799 VDD3 a_296625_208423# a_296731_208493# VDD3 sg13_lv_pmos ad=0.2603p pd=1.75u as=0.2603p ps=1.75u w=1.37u l=0.35u
X800 user_project_wrapper_0.analog_io[15] user_project_wrapper_0.IOVDD2 dpantenna l=1.26u w=27.78u
X801 user_project_wrapper_0.sg13g2_IOPadAnalog_9.padres user_project_wrapper_0.IOVDD1 dpantenna l=4.98u w=0.64u
X802 analog_io[23] a_369296_217444# user_project_wrapper_0.IOVSS1 user_project_wrapper_0.IOVSS1 sg13_hv_nmos ad=2.596p pd=5.58u as=1.408p ps=5.04u w=4.4u l=0.6u
X803 user_project_wrapper_0.IOVSS1 user_project_wrapper_0.sg13g2_IOPadAnalog_25.padres dantenna l=0.64u w=3.1u
X804 user_project_wrapper_0.IOVSS1 a_369296_156244# analog_io[20] user_project_wrapper_0.IOVSS1 sg13_hv_nmos ad=1.408p pd=5.04u as=2.596p ps=5.58u w=4.4u l=0.6u
X805 user_project_wrapper_0.IOVSS1 a_213462_327536# a_213870_324142# user_project_wrapper_0.IOVSS1 sg13_lv_pmos ad=1.824p pd=9.98u as=1.824p ps=9.98u w=9.6u l=0.13u
X806 user_project_wrapper_0.analog_io[27] a_182931_326125# user_project_wrapper_0.IOVSS1 user_project_wrapper_0.IOVSS1 sg13_lv_pmos ad=1.824p pd=9.98u as=3.264p ps=19.88u w=9.6u l=0.13u
X807 a_208469_329327# a_208367_329719# a_208367_328605# user_project_wrapper_0.IOVSS1 sg13_lv_nmos ad=0.19p pd=1.38u as=0.19p ps=1.38u w=1u l=0.13u
X808 user_project_wrapper_0.IOVSS1 user_project_wrapper_0.sg13g2_IOPadAnalog_19.padres a_189858_329719# user_project_wrapper_0.IOVSS1 sg13_lv_nmos ad=0.34p pd=2.68u as=0.19p ps=1.38u w=1u l=0.13u
X809 user_project_wrapper_0.IOVSS1 user_project_wrapper_0.sg13g2_IOPadVdd_0.sg13g2_RCClampInverter_noptap_0.out VDD3 user_project_wrapper_0.IOVSS1 sg13_hv_nmos ad=1.408p pd=5.04u as=2.596p ps=5.58u w=4.4u l=0.6u
X810 user_project_wrapper_0.IOVDD2 user_project_wrapper_0.sg13g2_IOPadIOVdd_0.sg13g2_Clamp_N43N43D4R_0.gate user_project_wrapper_0.IOVSS1 user_project_wrapper_0.IOVSS1 sg13_hv_nmos ad=2.596p pd=5.58u as=1.408p ps=5.04u w=4.4u l=0.6u
X811 a_313884_211353# analog_io[23] a_311108_215937# user_project_wrapper_0.IOVSS1 sg13_lv_nmos ad=1.9p pd=10.38u as=1.9p ps=10.38u w=10u l=0.5u
X812 user_project_wrapper_0.IOVDD4 a_156244_355624# user_project_wrapper_0.analog_io[29] user_project_wrapper_0.IOVDD4 sg13_hv_pmos ad=3.1302p pd=14.26u as=3.9294p ps=7.84u w=6.66u l=0.6u
X813 VDD3 user_project_wrapper_0.sg13g2_IOPadVdd_0.sg13g2_RCClampInverter_noptap_0.out user_project_wrapper_0.IOVSS1 user_project_wrapper_0.IOVSS1 sg13_hv_nmos ad=2.596p pd=5.58u as=1.408p ps=5.04u w=4.4u l=0.6u
X814 a_117145_39542# a_117475_35456# user_project_wrapper_0.IOVSS1 rppd l=20u w=1u
X815 user_project_wrapper_0.IOVSS1 user_project_wrapper_0.sg13g2_IOPadVdd_3.sg13g2_RCClampInverter_noptap_0.out user_project_wrapper_0.IOVSS1 user_project_wrapper_0.IOVSS1 sg13_hv_nmos ad=2.596p pd=5.58u as=0 ps=0 w=4.4u l=0.6u
X816 user_project_wrapper_0.IOVSS1 user_project_wrapper_0.sg13g2_IOPadIOVdd_2.sg13g2_Clamp_N43N43D4R_0.gate user_project_wrapper_0.IOVDD4 user_project_wrapper_0.IOVSS1 sg13_hv_nmos ad=1.408p pd=5.04u as=2.596p ps=5.58u w=4.4u l=0.6u
X817 user_project_wrapper_0.IOVSS1 a_182931_326125# user_project_wrapper_0.analog_io[27] user_project_wrapper_0.IOVSS1 sg13_lv_nmos ad=0.912p pd=5.18u as=0.912p ps=5.18u w=4.8u l=0.13u
X818 user_project_wrapper_0.IOVSS1 user_project_wrapper_0.analog_io[28] dantenna l=1.26u w=27.78u
X819 VDD3 a_309516_194555# a_309917_194695# VDD3 sg13_lv_pmos ad=0.19p pd=1.38u as=0.19p ps=1.38u w=1u l=0.7u
X820 a_309917_194695# a_309516_194555# VDD3 VDD3 sg13_lv_pmos ad=0.19p pd=1.38u as=0.19p ps=1.38u w=1u l=0.7u
X821 user_project_wrapper_0.sg13g2_IOPadIOVdd_3.sg13g2_Clamp_N43N43D4R_0.gate user_project_wrapper_0.sg13g2_IOPadIOVdd_3.sg13g2_RCClampResistor_0.p2 IOVDD3 IOVDD3 sg13_hv_pmos ad=1.33p pd=7.38u as=1.33p ps=7.38u w=7u l=0.5u
X822 user_project_wrapper_0.VDD1 user_project_wrapper_0.sg13g2_IOPadVdd_2.sg13g2_RCClampInverter_noptap_0.out user_project_wrapper_0.IOVSS1 user_project_wrapper_0.IOVSS1 sg13_hv_nmos ad=3.256p pd=10.28u as=1.408p ps=5.04u w=4.4u l=0.6u
X823 user_project_wrapper_0.VDD1 a_78824_135221# a_79025_135674# user_project_wrapper_0.VDD1 sg13_lv_pmos ad=1.7p pd=10.68u as=0.95p ps=5.38u w=5u l=0.15u
X824 IOVDD3 user_project_wrapper_0.sg13g2_IOPadIOVdd_3.sg13g2_Clamp_N43N43D4R_0.gate user_project_wrapper_0.IOVSS1 user_project_wrapper_0.IOVSS1 sg13_hv_nmos ad=2.596p pd=5.58u as=1.408p ps=5.04u w=4.4u l=0.6u
X825 IOVDD3 user_project_wrapper_0.sg13g2_IOPadIOVdd_3.sg13g2_Clamp_N43N43D4R_0.gate user_project_wrapper_0.IOVSS1 user_project_wrapper_0.IOVSS1 sg13_hv_nmos ad=2.596p pd=5.58u as=1.408p ps=5.04u w=4.4u l=0.6u
X826 QDLL_TOP_0.VOUT a_278644_41476# user_project_wrapper_0.IOVDD2 user_project_wrapper_0.IOVDD2 sg13_hv_pmos ad=3.9294p pd=7.84u as=2.1312p ps=7.3u w=6.66u l=0.6u
X827 a_304196_197873# a_304090_197941# a_296625_189595# user_project_wrapper_0.IOVSS1 sg13_lv_nmos ad=0.361p pd=2.28u as=0.361p ps=2.28u w=1.9u l=0.16u
X828 user_project_wrapper_0.IOVSS1 a_369296_237844# analog_io[23] user_project_wrapper_0.IOVSS1 sg13_hv_nmos ad=1.408p pd=5.04u as=2.596p ps=5.58u w=4.4u l=0.6u
X829 a_360372_300745# a_364458_301075# user_project_wrapper_0.IOVSS1 rppd l=20u w=1u
X830 user_project_wrapper_0.IOVSS1 user_project_wrapper_0.sg13g2_IOPadIOVdd_2.sg13g2_Clamp_N43N43D4R_0.gate user_project_wrapper_0.IOVDD4 user_project_wrapper_0.IOVSS1 sg13_hv_nmos ad=1.408p pd=5.04u as=2.596p ps=5.58u w=4.4u l=0.6u
X831 user_project_wrapper_0.IOVDD2 user_project_wrapper_0.sg13g2_IOPadIOVdd_0.sg13g2_Clamp_N43N43D4R_0.gate user_project_wrapper_0.IOVSS1 user_project_wrapper_0.IOVSS1 sg13_hv_nmos ad=2.596p pd=5.58u as=1.408p ps=5.04u w=4.4u l=0.6u
X832 user_project_wrapper_0.analog_io[30] user_project_wrapper_0.sg13g2_IOPadAnalog_18.padres user_project_wrapper_0.IOVSS1 rppd l=2u w=1u
X833 a_117145_39542# a_116815_35456# user_project_wrapper_0.IOVSS1 rppd l=20u w=1u
X834 a_296731_189665# a_296625_189595# VDD3 VDD3 sg13_lv_pmos ad=0.2603p pd=1.75u as=0.2603p ps=1.75u w=1.37u l=0.35u
X835 analog_io[20] a_369296_156244# user_project_wrapper_0.IOVSS1 user_project_wrapper_0.IOVSS1 sg13_hv_nmos ad=2.596p pd=5.58u as=1.408p ps=5.04u w=4.4u l=0.6u
X836 user_project_wrapper_0.IOVSS1 user_project_wrapper_0.sg13g2_IOPadOut4mA$1_0.c2p a_58170_179249# user_project_wrapper_0.IOVSS1 sg13_hv_nmos ad=0.361p pd=2.28u as=0.646p ps=4.48u w=1.9u l=0.45u
X837 user_project_wrapper_0.analog_io[33] a_237844_355624# user_project_wrapper_0.IOVDD4 user_project_wrapper_0.IOVDD4 sg13_hv_pmos ad=3.9294p pd=7.84u as=3.1302p ps=14.26u w=6.66u l=0.6u
X838 user_project_wrapper_0.IOVSS1 user_project_wrapper_0.sg13g2_IOPadIOVdd_0.sg13g2_Clamp_N43N43D4R_0.gate user_project_wrapper_0.IOVDD2 user_project_wrapper_0.IOVSS1 sg13_hv_nmos ad=1.408p pd=5.04u as=2.596p ps=5.58u w=4.4u l=0.6u
X839 a_209018_330987# a_207985_330987# user_project_wrapper_0.IOVSS1 rhigh l=4u w=0.5u
X840 a_296732_200582# a_296626_197740# VDD3 VDD3 sg13_lv_pmos ad=1.33p pd=7.38u as=2.38p ps=14.68u w=7u l=0.7u
X841 user_project_wrapper_0.VDD1 a_82527_127455# a_83492_127455# user_project_wrapper_0.VDD1 sg13_lv_pmos ad=0.3808p pd=2.92u as=0.2128p ps=1.5u w=1.12u l=0.13u
X842 a_309917_199879# user_project_wrapper_0.sg13g2_IOPadAnalog_29.padres a_311846_195517# VDD3 sg13_lv_pmos ad=0.24415p pd=1.665u as=0.24415p ps=1.665u w=1.285u l=0.35u
X843 a_296626_197740# a_296626_197740# VDD3 VDD3 sg13_lv_pmos ad=0.266p pd=1.78u as=0.476p ps=3.48u w=1.4u l=0.35u
X844 a_35456_303715# a_39542_304045# user_project_wrapper_0.IOVSS1 rppd l=20u w=1u
X845 user_project_wrapper_0.IOVSS1 a_202114_326125# user_project_wrapper_0.analog_io[32] user_project_wrapper_0.IOVSS1 sg13_lv_nmos ad=0.912p pd=5.18u as=0.912p ps=5.18u w=4.8u l=0.13u
X846 user_project_wrapper_0.IOVDD4 user_project_wrapper_0.sg13g2_IOPadIOVdd_2.sg13g2_Clamp_N43N43D4R_0.gate user_project_wrapper_0.IOVSS1 user_project_wrapper_0.IOVSS1 sg13_hv_nmos ad=2.596p pd=5.58u as=1.408p ps=5.04u w=4.4u l=0.6u
X847 user_project_wrapper_0.IOVDD4 user_project_wrapper_0.sg13g2_IOPadIOVdd_2.sg13g2_RCClampResistor_0.p2 user_project_wrapper_0.sg13g2_IOPadIOVdd_2.sg13g2_Clamp_N43N43D4R_0.gate user_project_wrapper_0.IOVDD4 sg13_hv_pmos ad=1.33p pd=7.38u as=1.33p ps=7.38u w=7u l=0.5u
X848 user_project_wrapper_0.IOVSS1 a_278644_29676# QDLL_TOP_0.VOUT user_project_wrapper_0.IOVSS1 sg13_hv_nmos ad=1.408p pd=5.04u as=2.596p ps=5.58u w=4.4u l=0.6u
X849 a_311189_185546# a_296731_189665# a_313884_185173# user_project_wrapper_0.IOVSS1 sg13_lv_nmos ad=1.9p pd=10.38u as=1.9p ps=10.38u w=10u l=0.5u
X850 a_309917_194695# user_project_wrapper_0.sg13g2_IOPadAnalog_29.padres a_311846_195517# VDD3 sg13_lv_pmos ad=0.24415p pd=1.665u as=0.24415p ps=1.665u w=1.285u l=0.35u
X851 a_296731_189665# a_296625_189595# VDD3 VDD3 sg13_lv_pmos ad=0.2603p pd=1.75u as=0.4658p ps=3.42u w=1.37u l=0.35u
X852 a_188834_327918# a_188834_327918# user_project_wrapper_0.IOVSS1 w_188704_327938# sg13_lv_pmos ad=0.68p pd=4.68u as=0.68p ps=4.68u w=2u l=0.13u
X853 a_311846_195517# user_project_wrapper_0.sg13g2_IOPadAnalog_29.padres a_309917_194695# VDD3 sg13_lv_pmos ad=0.24415p pd=1.665u as=0.24415p ps=1.665u w=1.285u l=0.35u
X854 user_project_wrapper_0.IOVSS1 a_213870_324142# user_project_wrapper_0.analog_io[35] user_project_wrapper_0.IOVSS1 sg13_lv_pmos ad=1.824p pd=9.98u as=1.824p ps=9.98u w=9.6u l=0.13u
X855 a_296731_189665# a_296625_189595# VDD3 VDD3 sg13_lv_pmos ad=0.2603p pd=1.75u as=0.2603p ps=1.75u w=1.37u l=0.35u
X856 user_project_wrapper_0.IOVDD1 user_project_wrapper_0.sg13g2_IOPadIOVdd_1.sg13g2_Clamp_N43N43D4R_0.gate user_project_wrapper_0.IOVSS1 user_project_wrapper_0.IOVSS1 sg13_hv_nmos ad=3.256p pd=10.28u as=1.408p ps=5.04u w=4.4u l=0.6u
X857 user_project_wrapper_0.IOVSS1 a_200038_338690# user_project_wrapper_0.sg13g2_IOPadIn$1_2.p2c user_project_wrapper_0.IOVSS1 sg13_lv_pmos ad=1.615p pd=10.18u as=1.615p ps=10.18u w=4.75u l=0.13u
X858 user_project_wrapper_0.analog_io[27] a_182931_326125# user_project_wrapper_0.IOVSS1 user_project_wrapper_0.IOVSS1 sg13_lv_pmos ad=1.824p pd=9.98u as=1.824p ps=9.98u w=9.6u l=0.13u
X859 user_project_wrapper_0.IOVSS1 a_237844_29676# user_project_wrapper_0.analog_io[15] user_project_wrapper_0.IOVSS1 sg13_hv_nmos ad=1.408p pd=5.04u as=2.596p ps=5.58u w=4.4u l=0.6u
X860 VDD3 a_296625_189595# a_296731_189665# VDD3 sg13_lv_pmos ad=0.4658p pd=3.42u as=0.2603p ps=1.75u w=1.37u l=0.35u
X861 user_project_wrapper_0.analog_io[1] a_41476_135844# user_project_wrapper_0.IOVDD1 user_project_wrapper_0.IOVDD1 sg13_hv_pmos ad=3.9294p pd=7.84u as=2.1312p ps=7.3u w=6.66u l=0.6u
X862 a_296731_208493# a_296625_208423# VDD3 VDD3 sg13_lv_pmos ad=0.2603p pd=1.75u as=0.2603p ps=1.75u w=1.37u l=0.35u
X863 user_project_wrapper_0.IOVDD2 a_237844_41476# user_project_wrapper_0.analog_io[15] user_project_wrapper_0.IOVDD2 sg13_hv_pmos ad=2.1312p pd=7.3u as=3.9294p ps=7.84u w=6.66u l=0.6u
X864 user_project_wrapper_0.IOVSS1 a_29676_115444# user_project_wrapper_0.analog_io[0] user_project_wrapper_0.IOVSS1 sg13_hv_nmos ad=1.408p pd=5.04u as=2.596p ps=5.58u w=4.4u l=0.6u
X865 user_project_wrapper_0.sg13g2_IOPadIOVdd_3.sg13g2_Clamp_N43N43D4R_0.gate user_project_wrapper_0.sg13g2_IOPadIOVdd_3.sg13g2_RCClampResistor_0.p2 IOVDD3 IOVDD3 sg13_hv_pmos ad=1.33p pd=7.38u as=1.33p ps=7.38u w=7u l=0.5u
X866 user_project_wrapper_0.sg13g2_IOPadVdd_3.sg13g2_RCClampInverter_noptap_0.out user_project_wrapper_0.sg13g2_IOPadVdd_3.sg13g2_RCClampResistor_0.p2 user_project_wrapper_0.IOVSS1 user_project_wrapper_0.IOVSS1 sg13_hv_pmos ad=1.33p pd=7.38u as=1.33p ps=7.38u w=7u l=0.5u
X867 a_355624_278644# IOVDD3 IOVDD3 rppd l=12.9u w=0.5u
X868 user_project_wrapper_0.VDD1 user_project_wrapper_0.sg13g2_IOPadVdd_2.sg13g2_RCClampResistor_0.p2 user_project_wrapper_0.sg13g2_IOPadVdd_2.sg13g2_RCClampInverter_noptap_0.out user_project_wrapper_0.VDD1 sg13_hv_pmos ad=1.33p pd=7.38u as=1.33p ps=7.38u w=7u l=0.5u
X869 a_309516_194555# a_309516_194555# VDD3 VDD3 sg13_lv_pmos ad=0.19p pd=1.38u as=0.34p ps=2.68u w=1u l=0.7u
X870 user_project_wrapper_0.IOVDD2 user_project_wrapper_0.sg13g2_IOPadIOVdd_0.sg13g2_Clamp_N43N43D4R_0.gate user_project_wrapper_0.IOVSS1 user_project_wrapper_0.IOVSS1 sg13_hv_nmos ad=2.596p pd=5.58u as=1.408p ps=5.04u w=4.4u l=0.6u
X871 a_182931_326125# a_186202_326221# user_project_wrapper_0.IOVSS1 user_project_wrapper_0.IOVSS1 sg13_lv_pmos ad=1.824p pd=9.98u as=1.824p ps=9.98u w=9.6u l=0.13u
X872 a_296731_189665# a_301186_192011# user_project_wrapper_0.IOVSS1 user_project_wrapper_0.IOVSS1 sg13_lv_nmos ad=0.912p pd=5.18u as=0.912p ps=5.18u w=4.8u l=1.06u
X873 user_project_wrapper_0.analog_io[5] user_project_wrapper_0.sg13g2_IOPadAnalog_15.padres user_project_wrapper_0.IOVSS1 rppd l=2u w=1u
X874 user_project_wrapper_0.analog_io[35] a_278644_369296# user_project_wrapper_0.IOVSS1 user_project_wrapper_0.IOVSS1 sg13_hv_nmos ad=2.596p pd=5.58u as=1.408p ps=5.04u w=4.4u l=0.6u
X875 user_project_wrapper_0.IOVSS1 QDLL_TOP_0.VOUT dantenna l=1.26u w=27.78u
X876 user_project_wrapper_0.analog_io[27] a_115444_369296# user_project_wrapper_0.IOVSS1 user_project_wrapper_0.IOVSS1 sg13_hv_nmos ad=2.596p pd=5.58u as=1.408p ps=5.04u w=4.4u l=0.6u
X877 user_project_wrapper_0.sg13g2_IOPadIn$1_0.sg13g2_LevelDown_noptap$1_0.sg13g2_SecondaryProtection$1$1_0.core user_project_wrapper_0.IOVDD1 dpantenna l=4.98u w=0.64u
X878 a_93461_128591# a_93208_127531# user_project_wrapper_0.VDD1 user_project_wrapper_0.VDD1 sg13_lv_pmos ad=0.2128p pd=1.5u as=0.3808p ps=2.92u w=1.12u l=0.13u
X879 user_project_wrapper_0.IOVSS1 a_301186_192011# a_296731_208493# user_project_wrapper_0.IOVSS1 sg13_lv_nmos ad=0.912p pd=5.18u as=0.912p ps=5.18u w=4.8u l=1.06u
X880 user_project_wrapper_0.IOVSS1 a_190389_99046# user_project_wrapper_0.analog_io[14] user_project_wrapper_0.IOVSS1 sg13_lv_nmos ad=0.1406p pd=1.12u as=0.1406p ps=1.12u w=0.74u l=0.13u
X881 IOVDD3 user_project_wrapper_0.sg13g2_IOPadIOVdd_3.sg13g2_Clamp_N43N43D4R_0.gate user_project_wrapper_0.IOVSS1 user_project_wrapper_0.IOVSS1 sg13_hv_nmos ad=2.596p pd=5.58u as=1.408p ps=5.04u w=4.4u l=0.6u
X882 user_project_wrapper_0.IOVSS1 user_project_wrapper_0.sg13g2_IOPadIOVdd_2.sg13g2_Clamp_N43N43D4R_0.gate user_project_wrapper_0.IOVDD4 user_project_wrapper_0.IOVSS1 sg13_hv_nmos ad=1.408p pd=5.04u as=2.596p ps=5.58u w=4.4u l=0.6u
X883 user_project_wrapper_0.IOVSS1 user_project_wrapper_0.sg13g2_IOPadIOVdd_0.sg13g2_Clamp_N43N43D4R_0.gate user_project_wrapper_0.IOVDD2 user_project_wrapper_0.IOVSS1 sg13_hv_nmos ad=1.408p pd=5.04u as=2.596p ps=5.58u w=4.4u l=0.6u
X884 user_project_wrapper_0.IOVSS1 a_369296_156244# analog_io[20] user_project_wrapper_0.IOVSS1 sg13_hv_nmos ad=2.068p pd=9.74u as=2.596p ps=5.58u w=4.4u l=0.6u
X885 user_project_wrapper_0.analog_io[33] a_237844_355624# user_project_wrapper_0.IOVDD4 user_project_wrapper_0.IOVDD4 sg13_hv_pmos ad=3.9294p pd=7.84u as=2.1312p ps=7.3u w=6.66u l=0.6u
X886 user_project_wrapper_0.IOVSS1 user_project_wrapper_0.sg13g2_IOPadIOVdd_2.sg13g2_Clamp_N43N43D4R_0.gate user_project_wrapper_0.IOVDD4 user_project_wrapper_0.IOVSS1 sg13_hv_nmos ad=1.408p pd=5.04u as=2.596p ps=5.58u w=4.4u l=0.6u
X887 QDLL_TOP_0.VDD a_189729_99046# a_190389_99046# QDLL_TOP_0.VDD sg13_lv_pmos ad=0.3808p pd=2.92u as=0.2184p ps=1.51u w=1.12u l=0.13u
X888 a_296731_208493# a_301186_192011# user_project_wrapper_0.IOVSS1 user_project_wrapper_0.IOVSS1 sg13_lv_nmos ad=0.912p pd=5.18u as=1.632p ps=10.28u w=4.8u l=1.06u
X889 user_project_wrapper_0.IOVSS1 user_project_wrapper_0.sg13g2_IOPadAnalog_6.padres dantenna l=3.1u w=0.64u
X890 VDD3 a_309516_194555# a_309917_199879# VDD3 sg13_lv_pmos ad=0.19p pd=1.38u as=0.19p ps=1.38u w=1u l=0.7u
X891 a_304995_198817# a_307232_196607# user_project_wrapper_0.IOVSS1 user_project_wrapper_0.IOVSS1 sg13_lv_nmos ad=0.6327p pd=3.71u as=0.6327p ps=3.71u w=3.33u l=0.2u
X892 a_296731_208493# a_296625_208423# VDD3 VDD3 sg13_lv_pmos ad=0.2603p pd=1.75u as=0.2603p ps=1.75u w=1.37u l=0.35u
X893 user_project_wrapper_0.analog_io[13] user_project_wrapper_0.IOVSS1 cap_cmim l=20u w=60u
X894 user_project_wrapper_0.sg13g2_IOPadVdd_1.sg13g2_RCClampInverter_noptap_0.out user_project_wrapper_0.sg13g2_IOPadVdd_1.sg13g2_RCClampResistor_0.p2 user_project_wrapper_0.VDD2 user_project_wrapper_0.VDD2 sg13_hv_pmos ad=1.33p pd=7.38u as=1.33p ps=7.38u w=7u l=0.5u
X895 user_project_wrapper_0.IOVDD4 a_115444_355624# user_project_wrapper_0.analog_io[27] user_project_wrapper_0.IOVDD4 sg13_hv_pmos ad=2.1312p pd=7.3u as=3.9294p ps=7.84u w=6.66u l=0.6u
X896 user_project_wrapper_0.IOVSS1 analog_io[22] dantenna l=27.78u w=1.26u
X897 a_182931_326125# a_186202_326221# user_project_wrapper_0.IOVSS1 user_project_wrapper_0.IOVSS1 sg13_lv_pmos ad=1.824p pd=9.98u as=1.824p ps=9.98u w=9.6u l=0.13u
X898 user_project_wrapper_0.IOVSS1 user_project_wrapper_0.sg13g2_IOPadVdd_2.sg13g2_RCClampInverter_noptap_0.out user_project_wrapper_0.VDD1 user_project_wrapper_0.IOVSS1 sg13_hv_nmos ad=1.408p pd=5.04u as=2.596p ps=5.58u w=4.4u l=0.6u
X899 user_project_wrapper_0.analog_io[6] a_41476_237844# user_project_wrapper_0.IOVDD1 user_project_wrapper_0.IOVDD1 sg13_hv_pmos ad=3.9294p pd=7.84u as=2.1312p ps=7.3u w=6.66u l=0.6u
X900 user_project_wrapper_0.IOVSS1 a_176644_29676# user_project_wrapper_0.analog_io[12] user_project_wrapper_0.IOVSS1 sg13_hv_nmos ad=1.408p pd=5.04u as=2.596p ps=5.58u w=4.4u l=0.6u
X901 user_project_wrapper_0.IOVDD1 a_41476_197044# user_project_wrapper_0.analog_io[4] user_project_wrapper_0.IOVDD1 sg13_hv_pmos ad=2.1312p pd=7.3u as=3.9294p ps=7.84u w=6.66u l=0.6u
X902 user_project_wrapper_0.analog_io[7] a_41476_258244# user_project_wrapper_0.IOVDD1 user_project_wrapper_0.IOVDD1 sg13_hv_pmos ad=3.9294p pd=7.84u as=2.1312p ps=7.3u w=6.66u l=0.6u
X903 user_project_wrapper_0.IOVSS1 user_project_wrapper_0.sg13g2_IOPadVdd_1.sg13g2_RCClampInverter_noptap_0.out user_project_wrapper_0.VDD2 user_project_wrapper_0.IOVSS1 sg13_hv_nmos ad=1.408p pd=5.04u as=2.596p ps=5.58u w=4.4u l=0.6u
X904 IOVDD3 user_project_wrapper_0.sg13g2_IOPadIOVdd_3.sg13g2_Clamp_N43N43D4R_0.gate user_project_wrapper_0.IOVSS1 user_project_wrapper_0.IOVSS1 sg13_hv_nmos ad=2.596p pd=5.58u as=1.408p ps=5.04u w=4.4u l=0.6u
X905 QDLL_TOP_0.VOUT a_278644_41476# user_project_wrapper_0.IOVDD2 user_project_wrapper_0.IOVDD2 sg13_hv_pmos ad=3.9294p pd=7.84u as=3.1302p ps=14.26u w=6.66u l=0.6u
X906 user_project_wrapper_0.IOVDD1 a_57810_179517# a_58170_179249# user_project_wrapper_0.IOVDD1 sg13_hv_pmos ad=57f pd=0.68u as=0.102p ps=1.28u w=0.3u l=0.45u
X907 user_project_wrapper_0.IOVSS1 user_project_wrapper_0.sg13g2_IOPadIOVdd_1.sg13g2_Clamp_N43N43D4R_0.gate user_project_wrapper_0.IOVDD1 user_project_wrapper_0.IOVSS1 sg13_hv_nmos ad=1.408p pd=5.04u as=2.596p ps=5.58u w=4.4u l=0.6u
X908 a_296732_197880# a_296626_197740# VDD3 VDD3 sg13_lv_pmos ad=1.33p pd=7.38u as=2.38p ps=14.68u w=7u l=0.7u
X909 user_project_wrapper_0.analog_io[27] a_115444_355624# user_project_wrapper_0.IOVDD4 user_project_wrapper_0.IOVDD4 sg13_hv_pmos ad=3.9294p pd=7.84u as=2.1312p ps=7.3u w=6.66u l=0.6u
X910 user_project_wrapper_0.analog_io[16] a_258244_29676# user_project_wrapper_0.IOVSS1 user_project_wrapper_0.IOVSS1 sg13_hv_nmos ad=2.596p pd=5.58u as=1.408p ps=5.04u w=4.4u l=0.6u
X911 user_project_wrapper_0.IOVSS1 a_188834_327918# a_189286_325785# w_188704_326203# sg13_lv_pmos ad=0.68p pd=4.68u as=0.38p ps=2.38u w=2u l=0.13u
X912 user_project_wrapper_0.IOVSS1 user_project_wrapper_0.sg13g2_IOPadVdd_2.sg13g2_RCClampResistor_0.p2 user_project_wrapper_0.sg13g2_IOPadVdd_2.sg13g2_RCClampInverter_noptap_0.out user_project_wrapper_0.IOVSS1 sg13_hv_nmos ad=1.71p pd=9.38u as=1.71p ps=9.38u w=9u l=0.5u
X913 user_project_wrapper_0.IOVDD4 user_project_wrapper_0.sg13g2_IOPadIOVdd_2.sg13g2_RCClampResistor_0.p2 user_project_wrapper_0.sg13g2_IOPadIOVdd_2.sg13g2_Clamp_N43N43D4R_0.gate user_project_wrapper_0.IOVDD4 sg13_hv_pmos ad=1.33p pd=7.38u as=1.33p ps=7.38u w=7u l=0.5u
X914 user_project_wrapper_0.IOVDD2 user_project_wrapper_0.sg13g2_IOPadIOVdd_0.sg13g2_Clamp_N43N43D4R_0.gate user_project_wrapper_0.IOVSS1 user_project_wrapper_0.IOVSS1 sg13_hv_nmos ad=2.596p pd=5.58u as=1.408p ps=5.04u w=4.4u l=0.6u
X915 user_project_wrapper_0.analog_io[14] a_217444_29676# user_project_wrapper_0.IOVSS1 user_project_wrapper_0.IOVSS1 sg13_hv_nmos ad=2.596p pd=5.58u as=2.068p ps=9.74u w=4.4u l=0.6u
X916 VDD3 a_296625_189595# a_296731_189665# VDD3 sg13_lv_pmos ad=0.2603p pd=1.75u as=0.2603p ps=1.75u w=1.37u l=0.35u
X917 user_project_wrapper_0.IOVSS1 a_307232_196607# a_304995_198817# user_project_wrapper_0.IOVSS1 sg13_lv_nmos ad=0.6327p pd=3.71u as=0.6327p ps=3.71u w=3.33u l=0.2u
X918 user_project_wrapper_0.IOVSS1 user_project_wrapper_0.sg13g2_IOPadIOVdd_3.sg13g2_Clamp_N43N43D4R_0.gate IOVDD3 user_project_wrapper_0.IOVSS1 sg13_hv_nmos ad=1.408p pd=5.04u as=2.596p ps=5.58u w=4.4u l=0.6u
X919 user_project_wrapper_0.analog_io[32] a_217444_355624# user_project_wrapper_0.IOVDD4 user_project_wrapper_0.IOVDD4 sg13_hv_pmos ad=3.9294p pd=7.84u as=2.1312p ps=7.3u w=6.66u l=0.6u
X920 user_project_wrapper_0.IOVSS1 user_project_wrapper_0.sg13g2_IOPadIOVdd_3.sg13g2_Clamp_N43N43D4R_0.gate dantenna l=0.48u w=0.48u
X921 user_project_wrapper_0.analog_io[14] a_217444_41476# user_project_wrapper_0.IOVDD2 user_project_wrapper_0.IOVDD2 sg13_hv_pmos ad=3.9294p pd=7.84u as=2.1312p ps=7.3u w=6.66u l=0.6u
X922 user_project_wrapper_0.IOVSS1 user_project_wrapper_0.sg13g2_IOPadIOVdd_0.sg13g2_RCClampResistor_0.p2 user_project_wrapper_0.IOVSS1 user_project_wrapper_0.IOVSS1 sg13_hv_nmos ad=1.71p pd=9.38u as=0 ps=0 w=9u l=9.5u
X923 IOVDD3 a_355624_258244# analog_io[25] IOVDD3 sg13_hv_pmos ad=3.1302p pd=14.26u as=3.9294p ps=7.84u w=6.66u l=0.6u
X924 user_project_wrapper_0.sg13g2_IOPadIOVdd_3.sg13g2_Clamp_N43N43D4R_0.gate user_project_wrapper_0.sg13g2_IOPadIOVdd_3.sg13g2_RCClampResistor_0.p2 IOVDD3 IOVDD3 sg13_hv_pmos ad=1.33p pd=7.38u as=1.33p ps=7.38u w=7u l=0.5u
X925 VDD3 user_project_wrapper_0.sg13g2_IOPadVdd_0.sg13g2_RCClampInverter_noptap_0.out user_project_wrapper_0.IOVSS1 user_project_wrapper_0.IOVSS1 sg13_hv_nmos ad=2.596p pd=5.58u as=1.408p ps=5.04u w=4.4u l=0.6u
X926 user_project_wrapper_0.VDD1 user_project_wrapper_0.sg13g2_IOPadVdd_2.sg13g2_RCClampResistor_0.p2 user_project_wrapper_0.sg13g2_IOPadVdd_2.sg13g2_RCClampInverter_noptap_0.out user_project_wrapper_0.VDD1 sg13_hv_pmos ad=1.33p pd=7.38u as=1.33p ps=7.38u w=7u l=0.5u
X927 user_project_wrapper_0.VDD1 a_91911_129060# a_92512_129426# user_project_wrapper_0.VDD1 sg13_lv_pmos ad=0.3808p pd=2.92u as=0.2128p ps=1.5u w=1.12u l=0.13u
X928 a_191438_328605# a_191234_328605# user_project_wrapper_0.IOVSS1 user_project_wrapper_0.IOVSS1 sg13_lv_nmos ad=0.34p pd=2.68u as=0.19p ps=1.38u w=1u l=0.13u
X929 a_309917_194695# a_309516_194555# VDD3 VDD3 sg13_lv_pmos ad=0.19p pd=1.38u as=0.19p ps=1.38u w=1u l=0.7u
X930 user_project_wrapper_0.analog_io[29] a_156244_355624# user_project_wrapper_0.IOVDD4 user_project_wrapper_0.IOVDD4 sg13_hv_pmos ad=3.9294p pd=7.84u as=2.1312p ps=7.3u w=6.66u l=0.6u
X931 VDD3 a_309516_194555# a_309917_194695# VDD3 sg13_lv_pmos ad=0.19p pd=1.38u as=0.19p ps=1.38u w=1u l=0.7u
X932 user_project_wrapper_0.sg13g2_IOPadAnalog_25.padres analog_io[23] user_project_wrapper_0.IOVSS1 rppd l=2u w=1u
X933 user_project_wrapper_0.VDD2 user_project_wrapper_0.sg13g2_IOPadVdd_1.sg13g2_RCClampResistor_0.p2 user_project_wrapper_0.sg13g2_IOPadVdd_1.sg13g2_RCClampInverter_noptap_0.out user_project_wrapper_0.VDD2 sg13_hv_pmos ad=1.33p pd=7.38u as=1.33p ps=7.38u w=7u l=0.5u
X934 user_project_wrapper_0.IOVSS1 a_369296_197044# analog_io[22] user_project_wrapper_0.IOVSS1 sg13_hv_nmos ad=1.408p pd=5.04u as=2.596p ps=5.58u w=4.4u l=0.6u
X935 analog_io[25] a_369296_258244# user_project_wrapper_0.IOVSS1 user_project_wrapper_0.IOVSS1 sg13_hv_nmos ad=2.596p pd=5.58u as=1.408p ps=5.04u w=4.4u l=0.6u
X936 VDD3 a_296625_189595# a_296731_189665# VDD3 sg13_lv_pmos ad=0.2603p pd=1.75u as=0.2603p ps=1.75u w=1.37u l=0.35u
X937 user_project_wrapper_0.analog_io[10] a_135844_41476# user_project_wrapper_0.IOVDD2 user_project_wrapper_0.IOVDD2 sg13_hv_pmos ad=3.9294p pd=7.84u as=2.1312p ps=7.3u w=6.66u l=0.6u
X938 a_85435_125173# a_85257_125209# user_project_wrapper_0.VDD1 user_project_wrapper_0.VDD1 sg13_lv_pmos ad=0.2128p pd=1.5u as=0.3808p ps=2.92u w=1.12u l=0.13u
X939 user_project_wrapper_0.IOVSS1 a_369296_217444# analog_io[23] user_project_wrapper_0.IOVSS1 sg13_hv_nmos ad=1.408p pd=5.04u as=2.596p ps=5.58u w=4.4u l=0.6u
X940 user_project_wrapper_0.IOVDD1 a_41476_237844# user_project_wrapper_0.analog_io[6] user_project_wrapper_0.IOVDD1 sg13_hv_pmos ad=3.1302p pd=14.26u as=3.9294p ps=7.84u w=6.66u l=0.6u
X941 user_project_wrapper_0.IOVDD2 a_237844_41476# user_project_wrapper_0.analog_io[15] user_project_wrapper_0.IOVDD2 sg13_hv_pmos ad=2.1312p pd=7.3u as=3.9294p ps=7.84u w=6.66u l=0.6u
X942 user_project_wrapper_0.IOVSS1 a_213462_327536# a_213870_324142# user_project_wrapper_0.IOVSS1 sg13_lv_pmos ad=1.824p pd=9.98u as=1.824p ps=9.98u w=9.6u l=0.13u
X943 analog_io[19] a_355624_135844# IOVDD3 IOVDD3 sg13_hv_pmos ad=3.9294p pd=7.84u as=2.1312p ps=7.3u w=6.66u l=0.6u
X944 a_189756_329719# a_188920_324155# user_project_wrapper_0.IOVSS1 user_project_wrapper_0.IOVSS1 sg13_lv_nmos ad=0.19p pd=1.38u as=0.34p ps=2.68u w=1u l=0.13u
X945 user_project_wrapper_0.IOVSS1 user_project_wrapper_0.sg13g2_IOPadVdd_1.sg13g2_RCClampInverter_noptap_0.out user_project_wrapper_0.VDD2 user_project_wrapper_0.IOVSS1 sg13_hv_nmos ad=1.408p pd=5.04u as=2.596p ps=5.58u w=4.4u l=0.6u
X946 user_project_wrapper_0.IOVSS1 user_project_wrapper_0.sg13g2_IOPadVdd_3.sg13g2_RCClampInverter_noptap_0.out user_project_wrapper_0.IOVSS1 user_project_wrapper_0.IOVSS1 sg13_hv_nmos ad=1.408p pd=5.04u as=0 ps=0 w=4.4u l=0.6u
X947 a_209041_328013# a_208939_328605# a_208939_327491# w_207887_327938# sg13_lv_pmos ad=0.38p pd=2.38u as=0.38p ps=2.38u w=2u l=0.13u
X948 VDD3 a_296625_208423# a_296731_208493# VDD3 sg13_lv_pmos ad=0.2603p pd=1.75u as=0.2603p ps=1.75u w=1.37u l=0.35u
X949 user_project_wrapper_0.IOVSS1 a_194687_324142# user_project_wrapper_0.analog_io[30] user_project_wrapper_0.IOVSS1 sg13_lv_pmos ad=1.824p pd=9.98u as=1.824p ps=9.98u w=9.6u l=0.13u
X950 VDD3 a_296625_189595# a_296731_189665# VDD3 sg13_lv_pmos ad=0.2603p pd=1.75u as=0.2603p ps=1.75u w=1.37u l=0.35u
X951 user_project_wrapper_0.IOVSS1 a_29676_217444# user_project_wrapper_0.analog_io[5] user_project_wrapper_0.IOVSS1 sg13_hv_nmos ad=1.408p pd=5.04u as=2.596p ps=5.58u w=4.4u l=0.6u
X952 user_project_wrapper_0.IOVSS1 a_182931_326125# user_project_wrapper_0.analog_io[27] user_project_wrapper_0.IOVSS1 sg13_lv_nmos ad=0.912p pd=5.18u as=0.912p ps=5.18u w=4.8u l=0.13u
X953 IOVDD3 a_355624_197044# analog_io[22] IOVDD3 sg13_hv_pmos ad=2.1312p pd=7.3u as=3.9294p ps=7.84u w=6.66u l=0.6u
X954 analog_io[25] a_355624_258244# IOVDD3 IOVDD3 sg13_hv_pmos ad=3.9294p pd=7.84u as=2.1312p ps=7.3u w=6.66u l=0.6u
X955 a_91090_129060# a_90579_129060# user_project_wrapper_0.IOVSS1 user_project_wrapper_0.IOVSS1 sg13_lv_nmos ad=0.1406p pd=1.12u as=0.2516p ps=2.16u w=0.74u l=0.13u
X956 user_project_wrapper_0.analog_io[1] a_29676_135844# user_project_wrapper_0.IOVSS1 user_project_wrapper_0.IOVSS1 sg13_hv_nmos ad=2.596p pd=5.58u as=2.068p ps=9.74u w=4.4u l=0.6u
X957 a_296731_189665# a_296625_189595# VDD3 VDD3 sg13_lv_pmos ad=0.2603p pd=1.75u as=0.2603p ps=1.75u w=1.37u l=0.35u
X958 user_project_wrapper_0.IOVDD4 user_project_wrapper_0.sg13g2_IOPadIOVdd_2.sg13g2_RCClampResistor_0.p2 user_project_wrapper_0.sg13g2_IOPadIOVdd_2.sg13g2_Clamp_N43N43D4R_0.gate user_project_wrapper_0.IOVDD4 sg13_hv_pmos ad=1.33p pd=7.38u as=1.33p ps=7.38u w=7u l=0.5u
X959 user_project_wrapper_0.IOVDD2 user_project_wrapper_0.sg13g2_IOPadIOVdd_0.sg13g2_Clamp_N43N43D4R_0.gate user_project_wrapper_0.IOVSS1 user_project_wrapper_0.IOVSS1 sg13_hv_nmos ad=2.596p pd=5.58u as=1.408p ps=5.04u w=4.4u l=0.6u
X960 VDD3 a_296625_189595# a_296731_189665# VDD3 sg13_lv_pmos ad=0.2603p pd=1.75u as=0.2603p ps=1.75u w=1.37u l=0.35u
X961 IOVDD3 user_project_wrapper_0.sg13g2_IOPadIOVdd_3.sg13g2_Clamp_N43N43D4R_0.gate user_project_wrapper_0.IOVSS1 user_project_wrapper_0.IOVSS1 sg13_hv_nmos ad=2.596p pd=5.58u as=1.408p ps=5.04u w=4.4u l=0.6u
X962 user_project_wrapper_0.IOVDD4 a_156244_355624# user_project_wrapper_0.analog_io[29] user_project_wrapper_0.IOVDD4 sg13_hv_pmos ad=2.1312p pd=7.3u as=3.9294p ps=7.84u w=6.66u l=0.6u
X963 a_186202_326221# a_187018_328627# user_project_wrapper_0.IOVSS1 user_project_wrapper_0.IOVSS1 sg13_lv_nmos ad=0.912p pd=5.18u as=0.912p ps=5.18u w=4.8u l=0.13u
X964 user_project_wrapper_0.analog_io[0] a_41476_115444# user_project_wrapper_0.IOVDD1 user_project_wrapper_0.IOVDD1 sg13_hv_pmos ad=3.9294p pd=7.84u as=2.1312p ps=7.3u w=6.66u l=0.6u
X965 user_project_wrapper_0.IOVSS1 user_project_wrapper_0.sg13g2_IOPadVdd_3.sg13g2_RCClampResistor_0.p2 user_project_wrapper_0.sg13g2_IOPadVdd_3.sg13g2_RCClampInverter_noptap_0.out user_project_wrapper_0.IOVSS1 sg13_hv_nmos ad=1.71p pd=9.38u as=1.71p ps=9.38u w=9u l=0.5u
X966 analog_io[23] a_369296_217444# user_project_wrapper_0.IOVSS1 user_project_wrapper_0.IOVSS1 sg13_hv_nmos ad=2.596p pd=5.58u as=1.408p ps=5.04u w=4.4u l=0.6u
X967 user_project_wrapper_0.IOVSS1 user_project_wrapper_0.sg13g2_IOPadIOVdd_2.sg13g2_Clamp_N43N43D4R_0.gate user_project_wrapper_0.IOVDD4 user_project_wrapper_0.IOVSS1 sg13_hv_nmos ad=1.408p pd=5.04u as=2.596p ps=5.58u w=4.4u l=0.6u
X968 user_project_wrapper_0.IOVSS1 user_project_wrapper_0.sg13g2_IOPadIOVdd_0.sg13g2_Clamp_N43N43D4R_0.gate user_project_wrapper_0.IOVDD2 user_project_wrapper_0.IOVSS1 sg13_hv_nmos ad=1.408p pd=5.04u as=2.596p ps=5.58u w=4.4u l=0.6u
X969 a_296732_200582# a_296626_197740# VDD3 VDD3 sg13_lv_pmos ad=1.33p pd=7.38u as=1.33p ps=7.38u w=7u l=0.7u
X970 user_project_wrapper_0.sg13g2_IOPadIOVdd_3.sg13g2_Clamp_N43N43D4R_0.gate user_project_wrapper_0.sg13g2_IOPadIOVdd_3.sg13g2_RCClampResistor_0.p2 IOVDD3 IOVDD3 sg13_hv_pmos ad=1.33p pd=7.38u as=1.33p ps=7.38u w=7u l=0.5u
X971 user_project_wrapper_0.IOVSS1 user_project_wrapper_0.sg13g2_IOPadAnalog_22.padres a_208469_327099# user_project_wrapper_0.IOVSS1 sg13_lv_nmos ad=0.34p pd=2.68u as=0.19p ps=1.38u w=1u l=0.13u
X972 user_project_wrapper_0.IOVSS1 a_213462_327536# a_213870_324142# user_project_wrapper_0.IOVSS1 sg13_lv_pmos ad=1.824p pd=9.98u as=1.824p ps=9.98u w=9.6u l=0.13u
X973 user_project_wrapper_0.analog_io[14] a_217444_41476# user_project_wrapper_0.IOVDD2 user_project_wrapper_0.IOVDD2 sg13_hv_pmos ad=3.9294p pd=7.84u as=2.1312p ps=7.3u w=6.66u l=0.6u
X974 user_project_wrapper_0.analog_io[27] a_182931_326125# user_project_wrapper_0.IOVSS1 user_project_wrapper_0.IOVSS1 sg13_lv_pmos ad=1.824p pd=9.98u as=3.264p ps=19.88u w=9.6u l=0.13u
X975 a_35456_74695# a_39542_74365# user_project_wrapper_0.IOVSS1 rppd l=20u w=1u
X976 user_project_wrapper_0.VDD1 user_project_wrapper_0.sg13g2_IOPadVdd_2.sg13g2_RCClampResistor_0.p2 user_project_wrapper_0.sg13g2_IOPadVdd_2.sg13g2_RCClampInverter_noptap_0.out user_project_wrapper_0.VDD1 sg13_hv_pmos ad=1.33p pd=7.38u as=1.33p ps=7.38u w=7u l=0.5u
X977 VDD3 a_296625_208423# a_296731_208493# VDD3 sg13_lv_pmos ad=0.2603p pd=1.75u as=0.2603p ps=1.75u w=1.37u l=0.35u
X978 a_190722_328013# a_189756_327491# user_project_wrapper_0.IOVSS1 w_188704_327938# sg13_lv_pmos ad=0.38p pd=2.38u as=0.68p ps=4.68u w=2u l=0.13u
X979 a_79025_136081# a_79038_134832# user_project_wrapper_0.IOVSS1 user_project_wrapper_0.IOVSS1 sg13_lv_nmos ad=0.1428p pd=1.52u as=0.1428p ps=1.52u w=0.42u l=0.56u
X980 a_84707_131750# a_79025_131741# user_project_wrapper_0.IOVSS1 user_project_wrapper_0.IOVSS1 sg13_lv_nmos ad=0.2516p pd=2.16u as=0.2516p ps=2.16u w=0.74u l=0.13u
X981 user_project_wrapper_0.sg13g2_IOPadIOVdd_3.sg13g2_Clamp_N43N43D4R_0.gate user_project_wrapper_0.sg13g2_IOPadIOVdd_3.sg13g2_RCClampResistor_0.p2 IOVDD3 IOVDD3 sg13_hv_pmos ad=1.33p pd=7.38u as=1.33p ps=7.38u w=7u l=0.5u
X982 user_project_wrapper_0.IOVSS1 a_213870_324142# user_project_wrapper_0.analog_io[35] user_project_wrapper_0.IOVSS1 sg13_lv_pmos ad=1.824p pd=9.98u as=1.824p ps=9.98u w=9.6u l=0.13u
X983 user_project_wrapper_0.IOVSS1 a_278644_369296# user_project_wrapper_0.analog_io[35] user_project_wrapper_0.IOVSS1 sg13_hv_nmos ad=1.408p pd=5.04u as=2.596p ps=5.58u w=4.4u l=0.6u
X984 user_project_wrapper_0.analog_io[27] a_182931_326125# user_project_wrapper_0.IOVSS1 user_project_wrapper_0.IOVSS1 sg13_lv_pmos ad=1.824p pd=9.98u as=1.824p ps=9.98u w=9.6u l=0.13u
X985 user_project_wrapper_0.IOVSS1 a_202114_326125# user_project_wrapper_0.analog_io[32] user_project_wrapper_0.IOVSS1 sg13_lv_nmos ad=0.912p pd=5.18u as=0.912p ps=5.18u w=4.8u l=0.13u
X986 user_project_wrapper_0.IOVSS1 a_115444_369296# user_project_wrapper_0.analog_io[27] user_project_wrapper_0.IOVSS1 sg13_hv_nmos ad=1.408p pd=5.04u as=2.596p ps=5.58u w=4.4u l=0.6u
X987 a_313884_211353# analog_io[23] a_311108_215937# user_project_wrapper_0.IOVSS1 sg13_lv_nmos ad=1.9p pd=10.38u as=1.9p ps=10.38u w=10u l=0.5u
X988 a_296731_189665# a_301186_192011# user_project_wrapper_0.IOVSS1 user_project_wrapper_0.IOVSS1 sg13_lv_nmos ad=0.912p pd=5.18u as=0.912p ps=5.18u w=4.8u l=1.06u
X989 a_82974_125209# user_project_wrapper_0.sg13g2_IOPadIn$1_0.p2c a_82872_125209# user_project_wrapper_0.IOVSS1 sg13_lv_nmos ad=0.1406p pd=1.12u as=0.1406p ps=1.12u w=0.74u l=0.13u
X990 user_project_wrapper_0.IOVSS1 a_369296_135844# analog_io[19] user_project_wrapper_0.IOVSS1 sg13_hv_nmos ad=1.408p pd=5.04u as=2.596p ps=5.58u w=4.4u l=0.6u
X991 analog_io[22] a_369296_197044# user_project_wrapper_0.IOVSS1 user_project_wrapper_0.IOVSS1 sg13_hv_nmos ad=2.596p pd=5.58u as=1.408p ps=5.04u w=4.4u l=0.6u
X992 user_project_wrapper_0.IOVDD1 a_41476_135844# user_project_wrapper_0.analog_io[1] user_project_wrapper_0.IOVDD1 sg13_hv_pmos ad=2.1312p pd=7.3u as=3.9294p ps=7.84u w=6.66u l=0.6u
X993 user_project_wrapper_0.analog_io[4] a_41476_197044# user_project_wrapper_0.IOVDD1 user_project_wrapper_0.IOVDD1 sg13_hv_pmos ad=3.9294p pd=7.84u as=2.1312p ps=7.3u w=6.66u l=0.6u
X994 user_project_wrapper_0.IOVSS1 user_project_wrapper_0.sg13g2_IOPadIOVdd_3.sg13g2_Clamp_N43N43D4R_0.gate IOVDD3 user_project_wrapper_0.IOVSS1 sg13_hv_nmos ad=1.408p pd=5.04u as=2.596p ps=5.58u w=4.4u l=0.6u
X995 a_210621_328605# a_210417_328605# user_project_wrapper_0.IOVSS1 user_project_wrapper_0.IOVSS1 sg13_lv_nmos ad=0.34p pd=2.68u as=0.19p ps=1.38u w=1u l=0.13u
X996 user_project_wrapper_0.IOVSS1 user_project_wrapper_0.sg13g2_IOPadIOVdd_3.sg13g2_Clamp_N43N43D4R_0.gate IOVDD3 user_project_wrapper_0.IOVSS1 sg13_hv_nmos ad=1.408p pd=5.04u as=2.596p ps=5.58u w=4.4u l=0.6u
X997 user_project_wrapper_0.analog_io[35] a_213870_324142# user_project_wrapper_0.IOVSS1 user_project_wrapper_0.IOVSS1 sg13_lv_nmos ad=0.912p pd=5.18u as=0.912p ps=5.18u w=4.8u l=0.13u
X998 user_project_wrapper_0.IOVSS1 user_project_wrapper_0.sg13g2_IOPadIOVdd_1.sg13g2_Clamp_N43N43D4R_0.gate user_project_wrapper_0.IOVDD1 user_project_wrapper_0.IOVSS1 sg13_hv_nmos ad=1.408p pd=5.04u as=2.596p ps=5.58u w=4.4u l=0.6u
X999 user_project_wrapper_0.IOVSS1 a_182931_326125# user_project_wrapper_0.analog_io[27] user_project_wrapper_0.IOVSS1 sg13_lv_nmos ad=0.912p pd=5.18u as=0.912p ps=5.18u w=4.8u l=0.13u
X1000 user_project_wrapper_0.IOVSS1 user_project_wrapper_0.sg13g2_IOPadVdd_0.sg13g2_RCClampInverter_noptap_0.out VDD3 user_project_wrapper_0.IOVSS1 sg13_hv_nmos ad=1.408p pd=5.04u as=2.596p ps=5.58u w=4.4u l=0.6u
X1001 a_79038_134366# a_78219_134797# a_79025_135674# user_project_wrapper_0.VDD1 sg13_lv_pmos ad=0.95p pd=5.38u as=1.7p ps=10.68u w=5u l=0.3u
X1002 user_project_wrapper_0.IOVDD4 user_project_wrapper_0.sg13g2_IOPadIOVdd_2.sg13g2_Clamp_N43N43D4R_0.gate user_project_wrapper_0.IOVSS1 user_project_wrapper_0.IOVSS1 sg13_hv_nmos ad=2.596p pd=5.58u as=1.408p ps=5.04u w=4.4u l=0.6u
X1003 user_project_wrapper_0.VDD2 user_project_wrapper_0.sg13g2_IOPadVdd_1.sg13g2_RCClampInverter_noptap_0.out user_project_wrapper_0.IOVSS1 user_project_wrapper_0.IOVSS1 sg13_hv_nmos ad=3.256p pd=10.28u as=1.408p ps=5.04u w=4.4u l=0.6u
X1004 a_296731_208493# a_301186_192011# user_project_wrapper_0.IOVSS1 user_project_wrapper_0.IOVSS1 sg13_lv_nmos ad=0.912p pd=5.18u as=0.912p ps=5.18u w=4.8u l=1.06u
X1005 user_project_wrapper_0.VDD1 user_project_wrapper_0.sg13g2_IOPadVdd_2.sg13g2_RCClampInverter_noptap_0.out user_project_wrapper_0.IOVSS1 user_project_wrapper_0.IOVSS1 sg13_hv_nmos ad=2.596p pd=5.58u as=1.408p ps=5.04u w=4.4u l=0.6u
X1006 user_project_wrapper_0.analog_io[6] a_41476_237844# user_project_wrapper_0.IOVDD1 user_project_wrapper_0.IOVDD1 sg13_hv_pmos ad=3.9294p pd=7.84u as=3.1302p ps=14.26u w=6.66u l=0.6u
X1007 user_project_wrapper_0.IOVSS1 user_project_wrapper_0.analog_io[6] dantenna l=27.78u w=1.26u
X1008 a_304196_200821# a_304090_197941# a_296625_208423# user_project_wrapper_0.IOVSS1 sg13_lv_nmos ad=0.361p pd=2.28u as=0.361p ps=2.28u w=1.9u l=0.16u
X1009 user_project_wrapper_0.IOVSS1 user_project_wrapper_0.IOVSS1 user_project_wrapper_0.IOVSS1 rppd l=0.5u w=0.5u
X1010 user_project_wrapper_0.IOVDD4 user_project_wrapper_0.sg13g2_IOPadIOVdd_2.sg13g2_Clamp_N43N43D4R_0.gate user_project_wrapper_0.IOVSS1 user_project_wrapper_0.IOVSS1 sg13_hv_nmos ad=2.596p pd=5.58u as=1.408p ps=5.04u w=4.4u l=0.6u
X1011 a_301423_202742# a_296731_208493# cap_cmim l=21.4u w=21.4u
X1012 analog_io[20] a_355624_176644# IOVDD3 IOVDD3 sg13_hv_pmos ad=3.9294p pd=7.84u as=2.1312p ps=7.3u w=6.66u l=0.6u
X1013 user_project_wrapper_0.IOVSS1 a_237844_29676# user_project_wrapper_0.analog_io[15] user_project_wrapper_0.IOVSS1 sg13_hv_nmos ad=1.408p pd=5.04u as=2.596p ps=5.58u w=4.4u l=0.6u
X1014 user_project_wrapper_0.IOVSS1 user_project_wrapper_0.ui_PAD[2] dantenna l=1.26u w=27.78u
X1015 user_project_wrapper_0.IOVSS1 user_project_wrapper_0.sg13g2_IOPadIOVdd_0.sg13g2_RCClampResistor_0.p2 user_project_wrapper_0.IOVSS1 user_project_wrapper_0.IOVSS1 sg13_hv_nmos ad=1.71p pd=9.38u as=0 ps=0 w=9u l=9.5u
X1016 user_project_wrapper_0.IOVSS1 a_369296_217444# analog_io[23] user_project_wrapper_0.IOVSS1 sg13_hv_nmos ad=1.408p pd=5.04u as=2.596p ps=5.58u w=4.4u l=0.6u
X1017 user_project_wrapper_0.IOVSS1 user_project_wrapper_0.sg13g2_IOPadVdd_1.sg13g2_RCClampInverter_noptap_0.out user_project_wrapper_0.VDD2 user_project_wrapper_0.IOVSS1 sg13_hv_nmos ad=1.408p pd=5.04u as=2.596p ps=5.58u w=4.4u l=0.6u
X1018 user_project_wrapper_0.IOVSS1 a_194687_324142# user_project_wrapper_0.analog_io[30] user_project_wrapper_0.IOVSS1 sg13_lv_nmos ad=0.912p pd=5.18u as=0.912p ps=5.18u w=4.8u l=0.13u
X1019 a_296731_208493# a_296625_208423# VDD3 VDD3 sg13_lv_pmos ad=0.2603p pd=1.75u as=0.4658p ps=3.42u w=1.37u l=0.35u
X1020 user_project_wrapper_0.IOVSS1 user_project_wrapper_0.IOVSS1 user_project_wrapper_0.IOVSS1 rppd l=0.5u w=0.5u
X1021 a_311189_185546# a_296731_189665# a_313884_185173# user_project_wrapper_0.IOVSS1 sg13_lv_nmos ad=1.9p pd=10.38u as=1.9p ps=10.38u w=10u l=0.5u
X1022 a_189184_329719# a_188920_324155# user_project_wrapper_0.IOVSS1 user_project_wrapper_0.IOVSS1 sg13_lv_nmos ad=0.19p pd=1.38u as=0.34p ps=2.68u w=1u l=0.13u
X1023 VDD3 a_309516_194555# a_309917_194695# VDD3 sg13_lv_pmos ad=0.19p pd=1.38u as=0.19p ps=1.38u w=1u l=0.7u
X1024 user_project_wrapper_0.IOVSS1 user_project_wrapper_0.sg13g2_IOPadIOVdd_2.sg13g2_Clamp_N43N43D4R_0.gate user_project_wrapper_0.IOVDD4 user_project_wrapper_0.IOVSS1 sg13_hv_nmos ad=1.408p pd=5.04u as=2.596p ps=5.58u w=4.4u l=0.6u
X1025 user_project_wrapper_0.IOVSS1 a_202114_326125# user_project_wrapper_0.analog_io[32] user_project_wrapper_0.IOVSS1 sg13_lv_nmos ad=0.912p pd=5.18u as=0.912p ps=5.18u w=4.8u l=0.13u
X1026 analog_io[26] a_355624_278644# IOVDD3 IOVDD3 sg13_hv_pmos ad=3.9294p pd=7.84u as=2.1312p ps=7.3u w=6.66u l=0.6u
X1027 a_208939_325263# a_208103_324155# user_project_wrapper_0.IOVSS1 user_project_wrapper_0.IOVSS1 sg13_lv_nmos ad=0.19p pd=1.38u as=0.34p ps=2.68u w=1u l=0.13u
X1028 user_project_wrapper_0.IOVSS1 user_project_wrapper_0.IOVSS1 dantenna l=27.78u w=1.26u
X1029 a_296731_189665# a_296625_189595# VDD3 VDD3 sg13_lv_pmos ad=0.2603p pd=1.75u as=0.2603p ps=1.75u w=1.37u l=0.35u
X1030 VDD3 user_project_wrapper_0.sg13g2_IOPadVdd_0.sg13g2_RCClampInverter_noptap_0.out user_project_wrapper_0.IOVSS1 user_project_wrapper_0.IOVSS1 sg13_hv_nmos ad=2.596p pd=5.58u as=1.408p ps=5.04u w=4.4u l=0.6u
X1031 user_project_wrapper_0.IOVSS1 user_project_wrapper_0.IOVSS1 user_project_wrapper_0.IOVSS1 rhigh l=4u w=0.5u
X1032 user_project_wrapper_0.IOVDD4 a_217444_355624# user_project_wrapper_0.analog_io[32] user_project_wrapper_0.IOVDD4 sg13_hv_pmos ad=2.1312p pd=7.3u as=3.9294p ps=7.84u w=6.66u l=0.6u
X1033 user_project_wrapper_0.analog_io[30] a_176644_355624# user_project_wrapper_0.IOVDD4 user_project_wrapper_0.IOVDD4 sg13_hv_pmos ad=3.9294p pd=7.84u as=2.1312p ps=7.3u w=6.66u l=0.6u
X1034 a_182931_326125# a_186202_326221# user_project_wrapper_0.IOVSS1 user_project_wrapper_0.IOVSS1 sg13_lv_pmos ad=1.824p pd=9.98u as=1.824p ps=9.98u w=9.6u l=0.13u
X1035 a_296732_197880# a_296626_197740# VDD3 VDD3 sg13_lv_pmos ad=1.33p pd=7.38u as=1.33p ps=7.38u w=7u l=0.7u
X1036 user_project_wrapper_0.analog_io[33] a_237844_355624# user_project_wrapper_0.IOVDD4 user_project_wrapper_0.IOVDD4 sg13_hv_pmos ad=3.9294p pd=7.84u as=2.1312p ps=7.3u w=6.66u l=0.6u
X1037 user_project_wrapper_0.IOVSS1 user_project_wrapper_0.sg13g2_IOPadIOVdd_0.sg13g2_Clamp_N43N43D4R_0.gate user_project_wrapper_0.IOVDD2 user_project_wrapper_0.IOVSS1 sg13_hv_nmos ad=1.408p pd=5.04u as=2.596p ps=5.58u w=4.4u l=0.6u
X1038 a_189729_101343# a_189395_101343# QDLL_TOP_0.VDD QDLL_TOP_0.VDD sg13_lv_pmos ad=0.2128p pd=1.5u as=0.2128p ps=1.5u w=1.12u l=0.13u
X1039 a_79025_127401# a_79038_126152# user_project_wrapper_0.IOVSS1 user_project_wrapper_0.IOVSS1 sg13_lv_nmos ad=0.1428p pd=1.52u as=0.1428p ps=1.52u w=0.42u l=0.56u
X1040 user_project_wrapper_0.VDD1 user_project_wrapper_0.sg13g2_IOPadVdd_2.sg13g2_RCClampResistor_0.p2 user_project_wrapper_0.sg13g2_IOPadVdd_2.sg13g2_RCClampInverter_noptap_0.out user_project_wrapper_0.VDD1 sg13_hv_pmos ad=1.33p pd=7.38u as=1.33p ps=7.38u w=7u l=0.5u
X1041 user_project_wrapper_0.IOVSS1 a_86046_241645# a_85989_241383# user_project_wrapper_0.IOVSS1 sg13_lv_nmos ad=0.2516p pd=2.16u as=0.1406p ps=1.12u w=0.74u l=0.13u
X1042 user_project_wrapper_0.IOVSS1 user_project_wrapper_0.sg13g2_IOPadIOVdd_2.sg13g2_Clamp_N43N43D4R_0.gate user_project_wrapper_0.IOVDD4 user_project_wrapper_0.IOVSS1 sg13_hv_nmos ad=1.408p pd=5.04u as=2.596p ps=5.58u w=4.4u l=0.6u
X1043 user_project_wrapper_0.IOVDD4 a_156244_355624# user_project_wrapper_0.analog_io[29] user_project_wrapper_0.IOVDD4 sg13_hv_pmos ad=2.1312p pd=7.3u as=3.9294p ps=7.84u w=6.66u l=0.6u
X1044 a_35456_79975# a_39542_80305# user_project_wrapper_0.IOVSS1 rppd l=20u w=1u
X1045 a_296731_208493# a_296625_208423# VDD3 VDD3 sg13_lv_pmos ad=0.2603p pd=1.75u as=0.2603p ps=1.75u w=1.37u l=0.35u
X1046 user_project_wrapper_0.analog_io[15] a_237844_41476# user_project_wrapper_0.IOVDD2 user_project_wrapper_0.IOVDD2 sg13_hv_pmos ad=3.9294p pd=7.84u as=2.1312p ps=7.3u w=6.66u l=0.6u
X1047 user_project_wrapper_0.analog_io[0] a_41476_115444# user_project_wrapper_0.IOVDD1 user_project_wrapper_0.IOVDD1 sg13_hv_pmos ad=3.9294p pd=7.84u as=2.1312p ps=7.3u w=6.66u l=0.6u
X1048 a_209997_324870# a_209940_324686# user_project_wrapper_0.IOVSS1 user_project_wrapper_0.IOVSS1 sg13_lv_nmos ad=0.19p pd=1.38u as=0.19p ps=1.38u w=1u l=0.13u
X1049 a_296731_189665# a_296625_189595# VDD3 VDD3 sg13_lv_pmos ad=0.2603p pd=1.75u as=0.2603p ps=1.75u w=1.37u l=0.35u
X1050 user_project_wrapper_0.analog_io[27] a_182931_326125# user_project_wrapper_0.IOVSS1 user_project_wrapper_0.IOVSS1 sg13_lv_nmos ad=0.912p pd=5.18u as=0.912p ps=5.18u w=4.8u l=0.13u
X1051 a_309917_194695# a_309516_194555# VDD3 VDD3 sg13_lv_pmos ad=0.19p pd=1.38u as=0.19p ps=1.38u w=1u l=0.7u
X1052 user_project_wrapper_0.IOVSS1 user_project_wrapper_0.sg13g2_IOPadIOVdd_3.sg13g2_Clamp_N43N43D4R_0.gate IOVDD3 user_project_wrapper_0.IOVSS1 sg13_hv_nmos ad=1.408p pd=5.04u as=2.596p ps=5.58u w=4.4u l=0.6u
X1053 QDLL_TOP_0.VOUT a_278644_29676# user_project_wrapper_0.IOVSS1 user_project_wrapper_0.IOVSS1 sg13_hv_nmos ad=2.596p pd=5.58u as=2.068p ps=9.74u w=4.4u l=0.6u
X1054 user_project_wrapper_0.IOVSS1 user_project_wrapper_0.IOVSS1 user_project_wrapper_0.IOVSS1 rhigh l=0.96u w=0.5u
X1055 user_project_wrapper_0.IOVDD1 a_41476_237844# user_project_wrapper_0.analog_io[6] user_project_wrapper_0.IOVDD1 sg13_hv_pmos ad=2.1312p pd=7.3u as=3.9294p ps=7.84u w=6.66u l=0.6u
X1056 a_189016_101343# a_188760_101343# user_project_wrapper_0.IOVSS1 user_project_wrapper_0.IOVSS1 sg13_lv_nmos ad=0.1428p pd=1.52u as=0.1323p ps=1.05u w=0.42u l=0.18u
X1057 a_211084_330987# TOP_ROILIFNEURON_0.MEM user_project_wrapper_0.IOVSS1 rhigh l=4u w=0.5u
X1058 QDLL_TOP_0.VOUT a_278644_41476# user_project_wrapper_0.IOVDD2 user_project_wrapper_0.IOVDD2 sg13_hv_pmos ad=3.9294p pd=7.84u as=2.1312p ps=7.3u w=6.66u l=0.6u
X1059 a_83070_130577# a_82746_130212# user_project_wrapper_0.VDD1 user_project_wrapper_0.VDD1 sg13_lv_pmos ad=0.2128p pd=1.5u as=0.3808p ps=2.92u w=1.12u l=0.13u
X1060 a_77335_364458# a_77005_360372# user_project_wrapper_0.IOVSS1 rppd l=20u w=1u
X1061 a_191438_328605# a_191234_328605# user_project_wrapper_0.IOVSS1 user_project_wrapper_0.IOVSS1 sg13_lv_nmos ad=0.19p pd=1.38u as=0.34p ps=2.68u w=1u l=0.13u
X1062 user_project_wrapper_0.IOVSS1 user_project_wrapper_0.sg13g2_IOPadVdd_3.sg13g2_RCClampResistor_0.p2 user_project_wrapper_0.sg13g2_IOPadVdd_3.sg13g2_RCClampInverter_noptap_0.out user_project_wrapper_0.IOVSS1 sg13_hv_nmos ad=1.71p pd=9.38u as=1.71p ps=9.38u w=9u l=0.5u
X1063 user_project_wrapper_0.sg13g2_IOPadVdd_3.sg13g2_RCClampInverter_noptap_0.out user_project_wrapper_0.sg13g2_IOPadVdd_3.sg13g2_RCClampResistor_0.p2 user_project_wrapper_0.IOVSS1 user_project_wrapper_0.IOVSS1 sg13_hv_nmos ad=1.71p pd=9.38u as=3.06p ps=18.68u w=9u l=0.5u
X1064 user_project_wrapper_0.IOVSS1 a_301186_192011# a_296731_208493# user_project_wrapper_0.IOVSS1 sg13_lv_nmos ad=0.912p pd=5.18u as=0.912p ps=5.18u w=4.8u l=1.06u
X1065 a_296731_208493# a_296625_208423# VDD3 VDD3 sg13_lv_pmos ad=0.2603p pd=1.75u as=0.2603p ps=1.75u w=1.37u l=0.35u
X1066 user_project_wrapper_0.IOVSS1 user_project_wrapper_0.sg13g2_IOPadIOVdd_0.sg13g2_Clamp_N43N43D4R_0.gate user_project_wrapper_0.IOVDD2 user_project_wrapper_0.IOVSS1 sg13_hv_nmos ad=1.408p pd=5.04u as=2.596p ps=5.58u w=4.4u l=0.6u
X1067 user_project_wrapper_0.analog_io[27] a_115444_369296# user_project_wrapper_0.IOVSS1 user_project_wrapper_0.IOVSS1 sg13_hv_nmos ad=2.596p pd=5.58u as=1.408p ps=5.04u w=4.4u l=0.6u
X1068 a_309917_199879# user_project_wrapper_0.sg13g2_IOPadAnalog_29.padres a_311846_195517# VDD3 sg13_lv_pmos ad=0.24415p pd=1.665u as=0.24415p ps=1.665u w=1.285u l=0.35u
X1069 user_project_wrapper_0.analog_io[14] a_217444_29676# user_project_wrapper_0.IOVSS1 user_project_wrapper_0.IOVSS1 sg13_hv_nmos ad=2.596p pd=5.58u as=1.408p ps=5.04u w=4.4u l=0.6u
X1070 user_project_wrapper_0.IOVDD1 user_project_wrapper_0.sg13g2_IOPadIOVdd_1.sg13g2_Clamp_N43N43D4R_0.gate user_project_wrapper_0.IOVSS1 user_project_wrapper_0.IOVSS1 sg13_hv_nmos ad=2.596p pd=5.58u as=1.408p ps=5.04u w=4.4u l=0.6u
X1071 user_project_wrapper_0.IOVSS1 user_project_wrapper_0.IOVSS1 dantenna l=1.26u w=27.78u
X1072 a_89114_129426# a_87434_129426# a_89114_129061# user_project_wrapper_0.IOVSS1 sg13_lv_nmos ad=0.2516p pd=2.16u as=0.1406p ps=1.12u w=0.74u l=0.13u
X1073 user_project_wrapper_0.VDD1 user_project_wrapper_0.sg13g2_IOPadVdd_2.sg13g2_RCClampInverter_noptap_0.out user_project_wrapper_0.IOVSS1 user_project_wrapper_0.IOVSS1 sg13_hv_nmos ad=2.596p pd=5.58u as=2.068p ps=9.74u w=4.4u l=0.6u
X1074 user_project_wrapper_0.IOVDD2 a_197044_41476# user_project_wrapper_0.analog_io[13] user_project_wrapper_0.IOVDD2 sg13_hv_pmos ad=2.1312p pd=7.3u as=3.9294p ps=7.84u w=6.66u l=0.6u
X1075 a_296731_208493# a_296625_208423# VDD3 VDD3 sg13_lv_pmos ad=0.2603p pd=1.75u as=0.2603p ps=1.75u w=1.37u l=0.35u
X1076 a_360372_299425# a_364458_299755# user_project_wrapper_0.IOVSS1 rppd l=20u w=1u
X1077 user_project_wrapper_0.IOVSS1 user_project_wrapper_0.sg13g2_IOPadVdd_2.sg13g2_RCClampResistor_0.p2 user_project_wrapper_0.IOVSS1 user_project_wrapper_0.IOVSS1 sg13_hv_nmos ad=1.71p pd=9.38u as=0 ps=0 w=9u l=9.5u
X1078 VDD3 a_296625_189595# a_296731_189665# VDD3 sg13_lv_pmos ad=0.2603p pd=1.75u as=0.2603p ps=1.75u w=1.37u l=0.35u
X1079 user_project_wrapper_0.IOVSS1 user_project_wrapper_0.IOVSS1 user_project_wrapper_0.IOVSS1 rhigh l=0.96u w=0.5u
X1080 a_311108_179669# analog_io[20] a_313884_185173# user_project_wrapper_0.IOVSS1 sg13_lv_nmos ad=1.9p pd=10.38u as=3.4p ps=20.68u w=10u l=0.5u
X1081 VDD3 a_296625_189595# a_296731_189665# VDD3 sg13_lv_pmos ad=0.2603p pd=1.75u as=0.2603p ps=1.75u w=1.37u l=0.35u
X1082 user_project_wrapper_0.IOVSS1 a_213462_327536# a_213870_324142# user_project_wrapper_0.IOVSS1 sg13_lv_pmos ad=1.824p pd=9.98u as=1.824p ps=9.98u w=9.6u l=0.13u
X1083 user_project_wrapper_0.IOVSS1 a_315347_192648# user_project_wrapper_0.IOVSS1 rppd l=11.5u w=1u
X1084 a_309917_199879# a_309516_194555# VDD3 VDD3 sg13_lv_pmos ad=0.19p pd=1.38u as=0.19p ps=1.38u w=1u l=0.7u
X1085 user_project_wrapper_0.IOVDD2 a_258244_41476# user_project_wrapper_0.analog_io[16] user_project_wrapper_0.IOVDD2 sg13_hv_pmos ad=2.1312p pd=7.3u as=3.9294p ps=7.84u w=6.66u l=0.6u
X1086 VDD3 user_project_wrapper_0.sg13g2_IOPadVdd_0.sg13g2_RCClampResistor_0.p2 user_project_wrapper_0.sg13g2_IOPadVdd_0.sg13g2_RCClampInverter_noptap_0.out VDD3 sg13_hv_pmos ad=1.33p pd=7.38u as=1.33p ps=7.38u w=7u l=0.5u
X1087 user_project_wrapper_0.IOVSS1 user_project_wrapper_0.sg13g2_IOPadVdd_0.sg13g2_RCClampInverter_noptap_0.out VDD3 user_project_wrapper_0.IOVSS1 sg13_hv_nmos ad=1.408p pd=5.04u as=2.596p ps=5.58u w=4.4u l=0.6u
X1088 a_296732_197880# a_301940_196388# a_296625_189595# VDD3 sg13_lv_pmos ad=1.377p pd=8.78u as=0.7695p ps=4.43u w=4.05u l=0.5u
X1089 a_309917_194695# a_309516_194555# VDD3 VDD3 sg13_lv_pmos ad=0.19p pd=1.38u as=0.19p ps=1.38u w=1u l=0.7u
X1090 user_project_wrapper_0.IOVSS1 a_194687_324142# user_project_wrapper_0.analog_io[30] user_project_wrapper_0.IOVSS1 sg13_lv_pmos ad=1.824p pd=9.98u as=1.824p ps=9.98u w=9.6u l=0.13u
X1091 VDD3 a_309516_194555# a_309917_194695# VDD3 sg13_lv_pmos ad=0.19p pd=1.38u as=0.19p ps=1.38u w=1u l=0.7u
X1092 IOVDD3 a_355624_258244# analog_io[25] IOVDD3 sg13_hv_pmos ad=2.1312p pd=7.3u as=3.9294p ps=7.84u w=6.66u l=0.6u
X1093 a_360372_78325# a_364458_78655# user_project_wrapper_0.IOVSS1 rppd l=20u w=1u
X1094 a_311846_195517# user_project_wrapper_0.sg13g2_IOPadAnalog_29.padres a_309917_199879# VDD3 sg13_lv_pmos ad=0.24415p pd=1.665u as=0.24415p ps=1.665u w=1.285u l=0.35u
X1095 user_project_wrapper_0.VDD1 user_project_wrapper_0.sg13g2_IOPadVdd_2.sg13g2_RCClampResistor_0.p2 user_project_wrapper_0.sg13g2_IOPadVdd_2.sg13g2_RCClampInverter_noptap_0.out user_project_wrapper_0.VDD1 sg13_hv_pmos ad=1.33p pd=7.38u as=1.33p ps=7.38u w=7u l=0.5u
X1096 a_311846_195517# user_project_wrapper_0.sg13g2_IOPadAnalog_29.padres a_309917_194695# VDD3 sg13_lv_pmos ad=0.24415p pd=1.665u as=0.24415p ps=1.665u w=1.285u l=0.35u
X1097 a_88274_129426# a_86594_129426# user_project_wrapper_0.VDD1 user_project_wrapper_0.VDD1 sg13_lv_pmos ad=0.2128p pd=1.5u as=0.3808p ps=2.92u w=1.12u l=0.13u
X1098 VDD3 a_296625_208423# a_296731_208493# VDD3 sg13_lv_pmos ad=0.4658p pd=3.42u as=0.2603p ps=1.75u w=1.37u l=0.35u
X1099 user_project_wrapper_0.IOVSS1 user_project_wrapper_0.sg13g2_IOPadVdd_3.sg13g2_RCClampInverter_noptap_0.out user_project_wrapper_0.IOVSS1 user_project_wrapper_0.IOVSS1 sg13_hv_nmos ad=1.408p pd=5.04u as=0 ps=0 w=4.4u l=0.6u
X1100 user_project_wrapper_0.IOVSS1 user_project_wrapper_0.sg13g2_IOPadVdd_2.sg13g2_RCClampInverter_noptap_0.out user_project_wrapper_0.VDD1 user_project_wrapper_0.IOVSS1 sg13_hv_nmos ad=1.408p pd=5.04u as=2.596p ps=5.58u w=4.4u l=0.6u
X1101 user_project_wrapper_0.IOVSS1 user_project_wrapper_0.sg13g2_IOPadVdd_3.sg13g2_RCClampInverter_noptap_0.out user_project_wrapper_0.IOVSS1 user_project_wrapper_0.IOVSS1 sg13_hv_nmos ad=1.408p pd=5.04u as=0 ps=0 w=4.4u l=0.6u
X1102 a_305695_364458# user_project_wrapper_0.sg13g2_IOPadIOVdd_2.sg13g2_RCClampResistor_0.p2 user_project_wrapper_0.IOVSS1 rppd l=20u w=1u
X1103 user_project_wrapper_0.IOVDD1 a_41476_135844# user_project_wrapper_0.analog_io[1] user_project_wrapper_0.IOVDD1 sg13_hv_pmos ad=2.1312p pd=7.3u as=3.9294p ps=7.84u w=6.66u l=0.6u
X1104 VDD3 a_296625_189595# a_296731_189665# VDD3 sg13_lv_pmos ad=0.2603p pd=1.75u as=0.2603p ps=1.75u w=1.37u l=0.35u
X1105 user_project_wrapper_0.IOVSS1 user_project_wrapper_0.sg13g2_IOPadVdd_1.sg13g2_RCClampInverter_noptap_0.out user_project_wrapper_0.VDD2 user_project_wrapper_0.IOVSS1 sg13_hv_nmos ad=1.408p pd=5.04u as=2.596p ps=5.58u w=4.4u l=0.6u
X1106 IOVDD3 a_355624_115444# analog_io[18] IOVDD3 sg13_hv_pmos ad=2.1312p pd=7.3u as=3.9294p ps=7.84u w=6.66u l=0.6u
X1107 a_307232_196607# a_296731_189665# a_309917_194695# VDD3 sg13_lv_pmos ad=0.24415p pd=1.665u as=0.24415p ps=1.665u w=1.285u l=0.35u
X1108 QDLL_TOP_0.VOUT a_278644_41476# user_project_wrapper_0.IOVDD2 user_project_wrapper_0.IOVDD2 sg13_hv_pmos ad=3.9294p pd=7.84u as=2.1312p ps=7.3u w=6.66u l=0.6u
X1109 a_208367_326377# user_project_wrapper_0.IOVSS1 user_project_wrapper_0.IOVSS1 user_project_wrapper_0.IOVSS1 sg13_lv_nmos ad=0.19p pd=1.38u as=0.34p ps=2.68u w=1u l=0.13u
X1110 user_project_wrapper_0.IOVSS1 a_213462_327536# a_213870_324142# user_project_wrapper_0.IOVSS1 sg13_lv_pmos ad=1.824p pd=9.98u as=1.824p ps=9.98u w=9.6u l=0.13u
X1111 a_90579_129060# a_83492_127455# user_project_wrapper_0.IOVSS1 user_project_wrapper_0.IOVSS1 sg13_lv_nmos ad=0.2516p pd=2.16u as=0.2516p ps=2.16u w=0.74u l=0.13u
X1112 a_304196_197873# a_304090_197941# a_296625_189595# user_project_wrapper_0.IOVSS1 sg13_lv_nmos ad=0.646p pd=4.48u as=0.361p ps=2.28u w=1.9u l=0.16u
X1113 a_209684_329719# a_208367_329719# user_project_wrapper_0.IOVSS1 w_207883_330166# sg13_lv_pmos ad=0.68p pd=4.68u as=0.68p ps=4.68u w=2u l=0.13u
X1114 user_project_wrapper_0.IOVSS1 user_project_wrapper_0.sg13g2_IOPadIOVdd_2.sg13g2_Clamp_N43N43D4R_0.gate user_project_wrapper_0.IOVDD4 user_project_wrapper_0.IOVSS1 sg13_hv_nmos ad=1.408p pd=5.04u as=2.596p ps=5.58u w=4.4u l=0.6u
X1115 analog_io[20] a_311108_179669# VDD3 user_project_wrapper_0.IOVSS1 sg13_lv_nmos ad=3.4p pd=20.68u as=3.4p ps=20.68u w=10u l=0.15u
X1116 user_project_wrapper_0.IOVSS1 user_project_wrapper_0.sg13g2_IOPadVdd_3.sg13g2_RCClampInverter_noptap_0.out user_project_wrapper_0.IOVSS1 user_project_wrapper_0.IOVSS1 sg13_hv_nmos ad=2.596p pd=5.58u as=0 ps=0 w=4.4u l=0.6u
X1117 user_project_wrapper_0.analog_io[32] a_217444_355624# user_project_wrapper_0.IOVDD4 user_project_wrapper_0.IOVDD4 sg13_hv_pmos ad=3.9294p pd=7.84u as=2.1312p ps=7.3u w=6.66u l=0.6u
X1118 VDD3 a_314697_196700# a_314697_196700# VDD3 sg13_lv_pmos ad=1.14p pd=6.38u as=1.14p ps=6.38u w=6u l=2.5u
X1119 user_project_wrapper_0.analog_io[15] a_237844_41476# user_project_wrapper_0.IOVDD2 user_project_wrapper_0.IOVDD2 sg13_hv_pmos ad=3.9294p pd=7.84u as=3.1302p ps=14.26u w=6.66u l=0.6u
X1120 a_79038_123516# a_78220_123062# a_79025_124824# user_project_wrapper_0.VDD1 sg13_lv_pmos ad=0.95p pd=5.38u as=1.7p ps=10.68u w=5u l=0.3u
X1121 user_project_wrapper_0.IOVDD4 a_135844_355624# user_project_wrapper_0.analog_io[28] user_project_wrapper_0.IOVDD4 sg13_hv_pmos ad=2.1312p pd=7.3u as=3.9294p ps=7.84u w=6.66u l=0.6u
X1122 user_project_wrapper_0.IOVSS1 a_213870_324142# user_project_wrapper_0.analog_io[35] user_project_wrapper_0.IOVSS1 sg13_lv_pmos ad=1.824p pd=9.98u as=1.824p ps=9.98u w=9.6u l=0.13u
X1123 user_project_wrapper_0.IOVSS1 a_194687_324142# user_project_wrapper_0.analog_io[30] user_project_wrapper_0.IOVSS1 sg13_lv_pmos ad=1.824p pd=9.98u as=1.824p ps=9.98u w=9.6u l=0.13u
X1124 user_project_wrapper_0.analog_io[27] a_182931_326125# user_project_wrapper_0.IOVSS1 user_project_wrapper_0.IOVSS1 sg13_lv_pmos ad=1.824p pd=9.98u as=1.824p ps=9.98u w=9.6u l=0.13u
X1125 IOVDD3 a_355624_176644# analog_io[20] IOVDD3 sg13_hv_pmos ad=2.1312p pd=7.3u as=3.9294p ps=7.84u w=6.66u l=0.6u
X1126 user_project_wrapper_0.analog_io[29] a_156244_355624# user_project_wrapper_0.IOVDD4 user_project_wrapper_0.IOVDD4 sg13_hv_pmos ad=3.9294p pd=7.84u as=2.1312p ps=7.3u w=6.66u l=0.6u
X1127 user_project_wrapper_0.analog_io[14] a_217444_29676# user_project_wrapper_0.IOVSS1 user_project_wrapper_0.IOVSS1 sg13_hv_nmos ad=2.596p pd=5.58u as=1.408p ps=5.04u w=4.4u l=0.6u
X1128 a_82770_125209# a_82667_125418# user_project_wrapper_0.IOVSS1 user_project_wrapper_0.IOVSS1 sg13_lv_nmos ad=0.1406p pd=1.12u as=0.2516p ps=2.16u w=0.74u l=0.13u
X1129 user_project_wrapper_0.IOVDD1 user_project_wrapper_0.sg13g2_IOPadIOVdd_1.sg13g2_Clamp_N43N43D4R_0.gate user_project_wrapper_0.IOVSS1 user_project_wrapper_0.IOVSS1 sg13_hv_nmos ad=2.596p pd=5.58u as=2.068p ps=9.74u w=4.4u l=0.6u
X1130 IOVDD3 a_355624_197044# analog_io[22] IOVDD3 sg13_hv_pmos ad=2.1312p pd=7.3u as=3.9294p ps=7.84u w=6.66u l=0.6u
X1131 user_project_wrapper_0.analog_io[14] a_190389_99046# QDLL_TOP_0.VDD QDLL_TOP_0.VDD sg13_lv_pmos ad=0.2128p pd=1.5u as=0.2128p ps=1.5u w=1.12u l=0.13u
X1132 a_210621_328605# a_210417_328605# user_project_wrapper_0.IOVSS1 user_project_wrapper_0.IOVSS1 sg13_lv_nmos ad=0.19p pd=1.38u as=0.34p ps=2.68u w=1u l=0.13u
X1133 user_project_wrapper_0.IOVSS1 a_194687_324142# user_project_wrapper_0.analog_io[30] user_project_wrapper_0.IOVSS1 sg13_lv_pmos ad=3.264p pd=19.88u as=1.824p ps=9.98u w=9.6u l=0.13u
X1134 user_project_wrapper_0.analog_io[35] a_213870_324142# user_project_wrapper_0.IOVSS1 user_project_wrapper_0.IOVSS1 sg13_lv_nmos ad=0.912p pd=5.18u as=0.912p ps=5.18u w=4.8u l=0.13u
X1135 user_project_wrapper_0.IOVSS1 a_29676_197044# user_project_wrapper_0.analog_io[4] user_project_wrapper_0.IOVSS1 sg13_hv_nmos ad=1.408p pd=5.04u as=2.596p ps=5.58u w=4.4u l=0.6u
X1136 user_project_wrapper_0.analog_io[7] a_29676_258244# user_project_wrapper_0.IOVSS1 user_project_wrapper_0.IOVSS1 sg13_hv_nmos ad=2.596p pd=5.58u as=1.408p ps=5.04u w=4.4u l=0.6u
X1137 user_project_wrapper_0.IOVDD4 user_project_wrapper_0.sg13g2_IOPadIOVdd_2.sg13g2_RCClampResistor_0.p2 user_project_wrapper_0.sg13g2_IOPadIOVdd_2.sg13g2_Clamp_N43N43D4R_0.gate user_project_wrapper_0.IOVDD4 sg13_hv_pmos ad=1.33p pd=7.38u as=1.33p ps=7.38u w=7u l=0.5u
X1138 user_project_wrapper_0.IOVSS1 a_182931_326125# user_project_wrapper_0.analog_io[27] user_project_wrapper_0.IOVSS1 sg13_lv_nmos ad=0.912p pd=5.18u as=0.912p ps=5.18u w=4.8u l=0.13u
X1139 user_project_wrapper_0.IOVSS1 user_project_wrapper_0.IOVSS1 dantenna l=1.26u w=27.78u
X1140 VDD3 a_311108_215937# analog_io[23] user_project_wrapper_0.IOVSS1 sg13_lv_nmos ad=3.4p pd=20.68u as=3.4p ps=20.68u w=10u l=0.15u
X1141 analog_io[18] a_355624_115444# IOVDD3 IOVDD3 sg13_hv_pmos ad=3.9294p pd=7.84u as=2.1312p ps=7.3u w=6.66u l=0.6u
X1142 user_project_wrapper_0.analog_io[35] a_213870_324142# user_project_wrapper_0.IOVSS1 user_project_wrapper_0.IOVSS1 sg13_lv_nmos ad=0.912p pd=5.18u as=0.912p ps=5.18u w=4.8u l=0.13u
X1143 user_project_wrapper_0.VDD1 user_project_wrapper_0.sg13g2_IOPadVdd_2.sg13g2_RCClampInverter_noptap_0.out user_project_wrapper_0.IOVSS1 user_project_wrapper_0.IOVSS1 sg13_hv_nmos ad=2.596p pd=5.58u as=1.408p ps=5.04u w=4.4u l=0.6u
X1144 VDD3 user_project_wrapper_0.sg13g2_IOPadVdd_0.sg13g2_RCClampInverter_noptap_0.out user_project_wrapper_0.IOVSS1 user_project_wrapper_0.IOVSS1 sg13_hv_nmos ad=2.596p pd=5.58u as=1.408p ps=5.04u w=4.4u l=0.6u
X1145 user_project_wrapper_0.IOVSS1 a_311846_195517# a_311846_195517# user_project_wrapper_0.IOVSS1 sg13_lv_nmos ad=0.6327p pd=3.71u as=0.6327p ps=3.71u w=3.33u l=0.2u
X1146 VDD3 a_309516_194555# a_309917_194695# VDD3 sg13_lv_pmos ad=0.19p pd=1.38u as=0.19p ps=1.38u w=1u l=0.7u
X1147 a_315347_192648# a_314793_201808# a_314697_196700# user_project_wrapper_0.IOVSS1 sg13_lv_nmos ad=1.14p pd=6.38u as=1.14p ps=6.38u w=6u l=6.4u
X1148 user_project_wrapper_0.IOVDD4 a_237844_355624# user_project_wrapper_0.analog_io[33] user_project_wrapper_0.IOVDD4 sg13_hv_pmos ad=2.1312p pd=7.3u as=3.9294p ps=7.84u w=6.66u l=0.6u
X1149 user_project_wrapper_0.IOVSS1 user_project_wrapper_0.sg13g2_IOPadVdd_3.sg13g2_RCClampInverter_noptap_0.out user_project_wrapper_0.IOVSS1 user_project_wrapper_0.IOVSS1 sg13_hv_nmos ad=1.408p pd=5.04u as=0 ps=0 w=4.4u l=0.6u
X1150 user_project_wrapper_0.IOVSS1 user_project_wrapper_0.sg13g2_IOPadVdd_3.sg13g2_RCClampInverter_noptap_0.out user_project_wrapper_0.IOVSS1 user_project_wrapper_0.IOVSS1 sg13_hv_nmos ad=1.408p pd=5.04u as=0 ps=0 w=4.4u l=0.6u
X1151 IOVDD3 a_355624_176644# analog_io[20] IOVDD3 sg13_hv_pmos ad=2.1312p pd=7.3u as=3.9294p ps=7.84u w=6.66u l=0.6u
X1152 a_311189_185546# a_311189_185546# VDD3 VDD3 sg13_lv_pmos ad=1.9p pd=10.38u as=1.9p ps=10.38u w=10u l=1u
X1153 analog_io[23] a_355624_237844# IOVDD3 IOVDD3 sg13_hv_pmos ad=3.9294p pd=7.84u as=2.1312p ps=7.3u w=6.66u l=0.6u
X1154 user_project_wrapper_0.IOVSS1 a_213870_324142# user_project_wrapper_0.analog_io[35] user_project_wrapper_0.IOVSS1 sg13_lv_pmos ad=1.824p pd=9.98u as=1.824p ps=9.98u w=9.6u l=0.13u
X1155 user_project_wrapper_0.IOVSS1 a_301186_192011# a_296731_189665# user_project_wrapper_0.IOVSS1 sg13_lv_nmos ad=0.912p pd=5.18u as=0.912p ps=5.18u w=4.8u l=1.06u
X1156 user_project_wrapper_0.analog_io[27] a_182931_326125# user_project_wrapper_0.IOVSS1 user_project_wrapper_0.IOVSS1 sg13_lv_pmos ad=1.824p pd=9.98u as=1.824p ps=9.98u w=9.6u l=0.13u
X1157 user_project_wrapper_0.analog_io[32] a_217444_369296# user_project_wrapper_0.IOVSS1 user_project_wrapper_0.IOVSS1 sg13_hv_nmos ad=2.596p pd=5.58u as=2.068p ps=9.74u w=4.4u l=0.6u
X1158 user_project_wrapper_0.IOVDD4 a_258244_355624# user_project_wrapper_0.IOVDD4 rppd l=12.9u w=0.5u
X1159 user_project_wrapper_0.IOVSS1 user_project_wrapper_0.sg13g2_IOPadIOVdd_3.sg13g2_RCClampResistor_0.p2 user_project_wrapper_0.sg13g2_IOPadIOVdd_3.sg13g2_Clamp_N43N43D4R_0.gate user_project_wrapper_0.IOVSS1 sg13_hv_nmos ad=1.71p pd=9.38u as=1.71p ps=9.38u w=9u l=0.5u
X1160 user_project_wrapper_0.analog_io[16] user_project_wrapper_0.IOVDD2 dpantenna l=1.26u w=27.78u
X1161 VDD3 a_296625_208423# a_296731_208493# VDD3 sg13_lv_pmos ad=0.2603p pd=1.75u as=0.2603p ps=1.75u w=1.37u l=0.35u
X1162 user_project_wrapper_0.IOVSS1 user_project_wrapper_0.sg13g2_IOPadVdd_3.sg13g2_RCClampInverter_noptap_0.out user_project_wrapper_0.IOVSS1 user_project_wrapper_0.IOVSS1 sg13_hv_nmos ad=1.408p pd=5.04u as=0 ps=0 w=4.4u l=0.6u
X1163 a_189286_328013# a_189184_328605# a_189184_327491# w_188704_327938# sg13_lv_pmos ad=0.38p pd=2.38u as=0.38p ps=2.38u w=2u l=0.13u
X1164 user_project_wrapper_0.IOVSS1 a_208855_324776# a_209869_324119# w_207989_323975# sg13_lv_pmos ad=0.68p pd=4.68u as=0.38p ps=2.38u w=2u l=0.13u
X1165 user_project_wrapper_0.IOVSS1 user_project_wrapper_0.sg13g2_IOPadVdd_1.sg13g2_RCClampInverter_noptap_0.out user_project_wrapper_0.VDD2 user_project_wrapper_0.IOVSS1 sg13_hv_nmos ad=1.408p pd=5.04u as=2.596p ps=5.58u w=4.4u l=0.6u
X1166 user_project_wrapper_0.IOVDD2 a_197044_41476# user_project_wrapper_0.analog_io[13] user_project_wrapper_0.IOVDD2 sg13_hv_pmos ad=2.1312p pd=7.3u as=3.9294p ps=7.84u w=6.66u l=0.6u
X1167 user_project_wrapper_0.IOVSS1 a_213870_324142# user_project_wrapper_0.analog_io[35] user_project_wrapper_0.IOVSS1 sg13_lv_pmos ad=1.824p pd=9.98u as=1.824p ps=9.98u w=9.6u l=0.13u
X1168 user_project_wrapper_0.IOVSS1 a_202114_326125# user_project_wrapper_0.analog_io[32] user_project_wrapper_0.IOVSS1 sg13_lv_nmos ad=0.912p pd=5.18u as=0.912p ps=5.18u w=4.8u l=0.13u
X1169 a_79038_132662# a_79038_132196# user_project_wrapper_0.IOVSS1 user_project_wrapper_0.IOVSS1 sg13_lv_nmos ad=0.1428p pd=1.52u as=0.1428p ps=1.52u w=0.42u l=0.56u
X1170 user_project_wrapper_0.sg13g2_IOPadVdd_3.sg13g2_RCClampInverter_noptap_0.out user_project_wrapper_0.sg13g2_IOPadVdd_3.sg13g2_RCClampResistor_0.p2 user_project_wrapper_0.IOVSS1 user_project_wrapper_0.IOVSS1 sg13_hv_nmos ad=1.71p pd=9.38u as=3.06p ps=18.68u w=9u l=0.5u
X1171 user_project_wrapper_0.IOVDD1 user_project_wrapper_0.sg13g2_IOPadIOVdd_1.sg13g2_Clamp_N43N43D4R_0.gate user_project_wrapper_0.IOVSS1 user_project_wrapper_0.IOVSS1 sg13_hv_nmos ad=3.256p pd=10.28u as=1.408p ps=5.04u w=4.4u l=0.6u
X1172 user_project_wrapper_0.analog_io[10] a_135844_41476# user_project_wrapper_0.IOVDD2 user_project_wrapper_0.IOVDD2 sg13_hv_pmos ad=3.9294p pd=7.84u as=2.1312p ps=7.3u w=6.66u l=0.6u
X1173 user_project_wrapper_0.IOVSS1 user_project_wrapper_0.IOVDD1 dpantenna l=1.26u w=27.78u
X1174 a_190926_329719# a_190501_329719# a_190824_329719# user_project_wrapper_0.IOVSS1 sg13_lv_nmos ad=0.19p pd=1.38u as=0.19p ps=1.38u w=1u l=0.13u
X1175 a_189729_101343# a_189395_101343# QDLL_TOP_0.VDD QDLL_TOP_0.VDD sg13_lv_pmos ad=0.2128p pd=1.5u as=0.3808p ps=2.92u w=1.12u l=0.13u
X1176 a_79038_128322# a_79038_127856# user_project_wrapper_0.IOVSS1 user_project_wrapper_0.IOVSS1 sg13_lv_nmos ad=0.1428p pd=1.52u as=0.1428p ps=1.52u w=0.42u l=0.56u
X1177 user_project_wrapper_0.IOVSS1 user_project_wrapper_0.sg13g2_IOPadVdd_2.sg13g2_RCClampInverter_noptap_0.out user_project_wrapper_0.VDD1 user_project_wrapper_0.IOVSS1 sg13_hv_nmos ad=1.408p pd=5.04u as=2.596p ps=5.58u w=4.4u l=0.6u
X1178 user_project_wrapper_0.IOVSS1 a_186202_326221# a_182931_326125# user_project_wrapper_0.IOVSS1 sg13_lv_nmos ad=1.632p pd=10.28u as=0.912p ps=5.18u w=4.8u l=0.13u
X1179 user_project_wrapper_0.IOVSS1 user_project_wrapper_0.sg13g2_IOPadIOVdd_2.sg13g2_Clamp_N43N43D4R_0.gate user_project_wrapper_0.IOVDD4 user_project_wrapper_0.IOVSS1 sg13_hv_nmos ad=1.408p pd=5.04u as=2.596p ps=5.58u w=4.4u l=0.6u
X1180 user_project_wrapper_0.sg13g2_IOPadIOVdd_2.sg13g2_Clamp_N43N43D4R_0.gate user_project_wrapper_0.sg13g2_IOPadIOVdd_2.sg13g2_RCClampResistor_0.p2 user_project_wrapper_0.IOVSS1 user_project_wrapper_0.IOVSS1 sg13_hv_nmos ad=1.71p pd=9.38u as=1.71p ps=9.38u w=9u l=0.5u
X1181 user_project_wrapper_0.IOVSS1 user_project_wrapper_0.sg13g2_IOPadIOVdd_3.sg13g2_RCClampResistor_0.p2 user_project_wrapper_0.sg13g2_IOPadIOVdd_3.sg13g2_Clamp_N43N43D4R_0.gate user_project_wrapper_0.IOVSS1 sg13_hv_nmos ad=1.71p pd=9.38u as=1.71p ps=9.38u w=9u l=0.5u
X1182 user_project_wrapper_0.IOVDD1 a_41476_115444# user_project_wrapper_0.analog_io[0] user_project_wrapper_0.IOVDD1 sg13_hv_pmos ad=2.1312p pd=7.3u as=3.9294p ps=7.84u w=6.66u l=0.6u
X1183 a_296731_189665# a_296625_189595# VDD3 VDD3 sg13_lv_pmos ad=0.2603p pd=1.75u as=0.2603p ps=1.75u w=1.37u l=0.35u
X1184 a_309917_194695# a_309516_194555# VDD3 VDD3 sg13_lv_pmos ad=0.19p pd=1.38u as=0.19p ps=1.38u w=1u l=0.7u
X1185 user_project_wrapper_0.IOVSS1 a_115444_369296# user_project_wrapper_0.analog_io[27] user_project_wrapper_0.IOVSS1 sg13_hv_nmos ad=1.408p pd=5.04u as=2.596p ps=5.58u w=4.4u l=0.6u
X1186 user_project_wrapper_0.IOVSS1 user_project_wrapper_0.IOVSS1 user_project_wrapper_0.IOVSS1 rppd l=0.5u w=0.5u
X1187 IOVDD3 a_355624_115444# analog_io[18] IOVDD3 sg13_hv_pmos ad=3.1302p pd=14.26u as=3.9294p ps=7.84u w=6.66u l=0.6u
X1188 user_project_wrapper_0.IOVSS1 user_project_wrapper_0.sg13g2_IOPadIOVdd_2.sg13g2_RCClampResistor_0.p2 user_project_wrapper_0.IOVSS1 user_project_wrapper_0.IOVSS1 sg13_hv_nmos ad=1.71p pd=9.38u as=0 ps=0 w=9u l=9.5u
X1189 user_project_wrapper_0.analog_io[27] a_182931_326125# user_project_wrapper_0.IOVSS1 user_project_wrapper_0.IOVSS1 sg13_lv_nmos ad=0.912p pd=5.18u as=0.912p ps=5.18u w=4.8u l=0.13u
X1190 IOVDD3 user_project_wrapper_0.sg13g2_IOPadIOVdd_3.sg13g2_Clamp_N43N43D4R_0.gate user_project_wrapper_0.IOVSS1 user_project_wrapper_0.IOVSS1 sg13_hv_nmos ad=2.596p pd=5.58u as=1.408p ps=5.04u w=4.4u l=0.6u
X1191 a_309516_194555# a_309516_194555# VDD3 VDD3 sg13_lv_pmos ad=0.19p pd=1.38u as=0.19p ps=1.38u w=1u l=0.7u
X1192 user_project_wrapper_0.IOVSS1 a_194687_324142# user_project_wrapper_0.analog_io[30] user_project_wrapper_0.IOVSS1 sg13_lv_nmos ad=0.912p pd=5.18u as=0.912p ps=5.18u w=4.8u l=0.13u
X1193 user_project_wrapper_0.uo_PAD[8] user_project_wrapper_0.sg13g2_IOPadOut4mA$1_1.sg13g2_GateLevelUpInv_noptap$1$1_0.ngate user_project_wrapper_0.IOVSS1 user_project_wrapper_0.IOVSS1 sg13_hv_nmos ad=2.596p pd=5.58u as=2.068p ps=9.74u w=4.4u l=0.6u
X1194 user_project_wrapper_0.IOVSS1 user_project_wrapper_0.sg13g2_IOPadVdd_2.sg13g2_RCClampInverter_noptap_0.out user_project_wrapper_0.VDD1 user_project_wrapper_0.IOVSS1 sg13_hv_nmos ad=1.408p pd=5.04u as=2.596p ps=5.58u w=4.4u l=0.6u
X1195 user_project_wrapper_0.IOVDD1 user_project_wrapper_0.sg13g2_IOPadIOVdd_1.sg13g2_Clamp_N43N43D4R_0.gate user_project_wrapper_0.IOVSS1 user_project_wrapper_0.IOVSS1 sg13_hv_nmos ad=2.596p pd=5.58u as=1.408p ps=5.04u w=4.4u l=0.6u
X1196 user_project_wrapper_0.analog_io[14] a_190389_99046# QDLL_TOP_0.VDD QDLL_TOP_0.VDD sg13_lv_pmos ad=0.2128p pd=1.5u as=0.2128p ps=1.5u w=1.12u l=0.13u
X1197 a_296731_189665# a_296625_189595# VDD3 VDD3 sg13_lv_pmos ad=0.2603p pd=1.75u as=0.2603p ps=1.75u w=1.37u l=0.35u
X1198 a_296731_208493# a_296625_208423# VDD3 VDD3 sg13_lv_pmos ad=0.2603p pd=1.75u as=0.2603p ps=1.75u w=1.37u l=0.35u
X1199 user_project_wrapper_0.IOVSS1 user_project_wrapper_0.sg13g2_IOPadIOVdd_0.sg13g2_Clamp_N43N43D4R_0.gate user_project_wrapper_0.IOVDD2 user_project_wrapper_0.IOVSS1 sg13_hv_nmos ad=1.408p pd=5.04u as=2.596p ps=5.58u w=4.4u l=0.6u
X1200 IOVDD3 user_project_wrapper_0.sg13g2_IOPadIOVdd_3.sg13g2_Clamp_N43N43D4R_0.gate user_project_wrapper_0.IOVSS1 user_project_wrapper_0.IOVSS1 sg13_hv_nmos ad=2.596p pd=5.58u as=1.408p ps=5.04u w=4.4u l=0.6u
X1201 QDLL_TOP_0.VOUT a_278644_29676# user_project_wrapper_0.IOVSS1 user_project_wrapper_0.IOVSS1 sg13_hv_nmos ad=2.596p pd=5.58u as=1.408p ps=5.04u w=4.4u l=0.6u
X1202 user_project_wrapper_0.IOVSS1 a_314793_198352# a_313884_211353# user_project_wrapper_0.IOVSS1 sg13_lv_nmos ad=0.57p pd=3.38u as=0.57p ps=3.38u w=3u l=1u
X1203 analog_io[23] a_311108_215937# VDD3 user_project_wrapper_0.IOVSS1 sg13_lv_nmos ad=3.4p pd=20.68u as=3.4p ps=20.68u w=10u l=0.15u
X1204 user_project_wrapper_0.sg13g2_IOPadOut4mA$1_1.sg13g2_GateLevelUpInv_noptap$1$1_0.pgate a_57810_282219# user_project_wrapper_0.IOVDD1 user_project_wrapper_0.IOVDD1 sg13_hv_pmos ad=1.326p pd=8.48u as=1.326p ps=8.48u w=3.9u l=0.45u
X1205 user_project_wrapper_0.VDD1 user_project_wrapper_0.sg13g2_IOPadVdd_2.sg13g2_RCClampResistor_0.p2 user_project_wrapper_0.sg13g2_IOPadVdd_2.sg13g2_RCClampInverter_noptap_0.out user_project_wrapper_0.VDD1 sg13_hv_pmos ad=1.33p pd=7.38u as=1.33p ps=7.38u w=7u l=0.5u
X1206 a_213376_328627# a_208855_324776# user_project_wrapper_0.IOVSS1 user_project_wrapper_0.IOVSS1 sg13_lv_nmos ad=1.632p pd=10.28u as=1.632p ps=10.28u w=4.8u l=0.13u
X1207 user_project_wrapper_0.sg13g2_IOPadVdd_3.sg13g2_RCClampInverter_noptap_0.out user_project_wrapper_0.sg13g2_IOPadVdd_3.sg13g2_RCClampResistor_0.p2 user_project_wrapper_0.IOVSS1 user_project_wrapper_0.IOVSS1 sg13_hv_pmos ad=1.33p pd=7.38u as=1.33p ps=7.38u w=7u l=0.5u
X1208 user_project_wrapper_0.IOVDD2 a_258244_41476# user_project_wrapper_0.analog_io[16] user_project_wrapper_0.IOVDD2 sg13_hv_pmos ad=2.1312p pd=7.3u as=3.9294p ps=7.84u w=6.66u l=0.6u
X1209 a_309917_194695# a_309516_194555# VDD3 VDD3 sg13_lv_pmos ad=0.19p pd=1.38u as=0.19p ps=1.38u w=1u l=0.7u
X1210 a_93719_127531# a_93208_127531# user_project_wrapper_0.IOVSS1 user_project_wrapper_0.IOVSS1 sg13_lv_nmos ad=0.1406p pd=1.12u as=0.2516p ps=2.16u w=0.74u l=0.13u
X1211 user_project_wrapper_0.IOVDD1 user_project_wrapper_0.sg13g2_IOPadIOVdd_1.sg13g2_Clamp_N43N43D4R_0.gate user_project_wrapper_0.IOVSS1 user_project_wrapper_0.IOVSS1 sg13_hv_nmos ad=2.596p pd=5.58u as=1.408p ps=5.04u w=4.4u l=0.6u
X1212 user_project_wrapper_0.VDD2 user_project_wrapper_0.sg13g2_IOPadVdd_1.sg13g2_RCClampInverter_noptap_0.out user_project_wrapper_0.IOVSS1 user_project_wrapper_0.IOVSS1 sg13_hv_nmos ad=2.596p pd=5.58u as=1.408p ps=5.04u w=4.4u l=0.6u
X1213 a_309917_194695# a_309516_194555# VDD3 VDD3 sg13_lv_pmos ad=0.19p pd=1.38u as=0.19p ps=1.38u w=1u l=0.7u
X1214 a_311108_215937# analog_io[23] a_313884_211353# user_project_wrapper_0.IOVSS1 sg13_lv_nmos ad=1.9p pd=10.38u as=1.9p ps=10.38u w=10u l=0.5u
X1215 user_project_wrapper_0.IOVSS1 user_project_wrapper_0.sg13g2_IOPadIOVdd_3.sg13g2_Clamp_N43N43D4R_0.gate IOVDD3 user_project_wrapper_0.IOVSS1 sg13_hv_nmos ad=1.408p pd=5.04u as=2.596p ps=5.58u w=4.4u l=0.6u
X1216 user_project_wrapper_0.IOVSS1 user_project_wrapper_0.sg13g2_IOPadIOVdd_3.sg13g2_Clamp_N43N43D4R_0.gate IOVDD3 user_project_wrapper_0.IOVSS1 sg13_hv_nmos ad=1.408p pd=5.04u as=2.596p ps=5.58u w=4.4u l=0.6u
X1217 user_project_wrapper_0.IOVDD4 a_217444_355624# user_project_wrapper_0.analog_io[32] user_project_wrapper_0.IOVDD4 sg13_hv_pmos ad=2.1312p pd=7.3u as=3.9294p ps=7.84u w=6.66u l=0.6u
X1218 user_project_wrapper_0.IOVSS1 a_191234_326377# a_191438_326377# user_project_wrapper_0.IOVSS1 sg13_lv_nmos ad=0.19p pd=1.38u as=0.19p ps=1.38u w=1u l=0.13u
X1219 user_project_wrapper_0.analog_io[30] a_176644_355624# user_project_wrapper_0.IOVDD4 user_project_wrapper_0.IOVDD4 sg13_hv_pmos ad=3.9294p pd=7.84u as=2.1312p ps=7.3u w=6.66u l=0.6u
X1220 a_296731_208493# a_296625_208423# VDD3 VDD3 sg13_lv_pmos ad=0.2603p pd=1.75u as=0.2603p ps=1.75u w=1.37u l=0.35u
X1221 user_project_wrapper_0.IOVSS1 a_197044_29676# user_project_wrapper_0.analog_io[13] user_project_wrapper_0.IOVSS1 sg13_hv_nmos ad=1.408p pd=5.04u as=2.596p ps=5.58u w=4.4u l=0.6u
X1222 user_project_wrapper_0.IOVSS1 user_project_wrapper_0.IOVSS1 user_project_wrapper_0.IOVSS1 rppd l=0.5u w=0.5u
X1223 user_project_wrapper_0.IOVSS1 a_194687_324142# user_project_wrapper_0.analog_io[30] user_project_wrapper_0.IOVSS1 sg13_lv_pmos ad=1.824p pd=9.98u as=1.824p ps=9.98u w=9.6u l=0.13u
X1224 user_project_wrapper_0.IOVSS1 user_project_wrapper_0.sg13g2_IOPadVdd_0.sg13g2_RCClampInverter_noptap_0.out VDD3 user_project_wrapper_0.IOVSS1 sg13_hv_nmos ad=1.408p pd=5.04u as=2.596p ps=5.58u w=4.4u l=0.6u
X1225 user_project_wrapper_0.sg13g2_IOPadAnalog_4.padres user_project_wrapper_0.analog_io[14] user_project_wrapper_0.IOVSS1 rppd l=2u w=1u
X1226 IOVDD3 a_355624_156244# analog_io[20] IOVDD3 sg13_hv_pmos ad=2.1312p pd=7.3u as=3.9294p ps=7.84u w=6.66u l=0.6u
X1227 a_296731_208493# a_296625_208423# VDD3 VDD3 sg13_lv_pmos ad=0.2603p pd=1.75u as=0.2603p ps=1.75u w=1.37u l=0.35u
X1228 VDD3 a_296625_189595# a_296731_189665# VDD3 sg13_lv_pmos ad=0.2603p pd=1.75u as=0.2603p ps=1.75u w=1.37u l=0.35u
X1229 user_project_wrapper_0.sg13g2_IOPadIOVdd_1.sg13g2_Clamp_N43N43D4R_0.gate user_project_wrapper_0.sg13g2_IOPadIOVdd_1.sg13g2_RCClampResistor_0.p2 user_project_wrapper_0.IOVDD1 user_project_wrapper_0.IOVDD1 sg13_hv_pmos ad=1.33p pd=7.38u as=1.33p ps=7.38u w=7u l=0.5u
X1230 user_project_wrapper_0.IOVDD4 a_156244_355624# user_project_wrapper_0.analog_io[29] user_project_wrapper_0.IOVDD4 sg13_hv_pmos ad=2.1312p pd=7.3u as=3.9294p ps=7.84u w=6.66u l=0.6u
X1231 user_project_wrapper_0.IOVDD2 user_project_wrapper_0.sg13g2_IOPadIOVdd_0.sg13g2_Clamp_N43N43D4R_0.gate user_project_wrapper_0.IOVSS1 user_project_wrapper_0.IOVSS1 sg13_hv_nmos ad=2.596p pd=5.58u as=1.408p ps=5.04u w=4.4u l=0.6u
X1232 user_project_wrapper_0.IOVDD2 user_project_wrapper_0.sg13g2_IOPadIOVdd_0.sg13g2_Clamp_N43N43D4R_0.gate user_project_wrapper_0.IOVSS1 user_project_wrapper_0.IOVSS1 sg13_hv_nmos ad=2.596p pd=5.58u as=1.408p ps=5.04u w=4.4u l=0.6u
X1233 user_project_wrapper_0.IOVSS1 user_project_wrapper_0.sg13g2_IOPadVdd_3.sg13g2_RCClampInverter_noptap_0.out user_project_wrapper_0.IOVSS1 user_project_wrapper_0.IOVSS1 sg13_hv_nmos ad=1.408p pd=5.04u as=0 ps=0 w=4.4u l=0.6u
X1234 a_82846_243261# a_82859_242012# user_project_wrapper_0.IOVSS1 user_project_wrapper_0.IOVSS1 sg13_lv_nmos ad=0.1428p pd=1.52u as=0.1428p ps=1.52u w=0.42u l=0.56u
X1235 IOVDD3 a_355624_278644# analog_io[26] IOVDD3 sg13_hv_pmos ad=2.1312p pd=7.3u as=3.9294p ps=7.84u w=6.66u l=0.6u
X1236 user_project_wrapper_0.analog_io[28] a_135844_369296# user_project_wrapper_0.IOVSS1 user_project_wrapper_0.IOVSS1 sg13_hv_nmos ad=2.596p pd=5.58u as=1.408p ps=5.04u w=4.4u l=0.6u
X1237 VDD3 a_296625_189595# a_296731_189665# VDD3 sg13_lv_pmos ad=0.2603p pd=1.75u as=0.2603p ps=1.75u w=1.37u l=0.35u
X1238 a_309917_199879# a_309516_194555# VDD3 VDD3 sg13_lv_pmos ad=0.19p pd=1.38u as=0.19p ps=1.38u w=1u l=0.7u
X1239 a_314697_196700# a_314793_201808# a_315347_192648# user_project_wrapper_0.IOVSS1 sg13_lv_nmos ad=1.14p pd=6.38u as=1.14p ps=6.38u w=6u l=6.4u
X1240 a_309917_199879# a_309516_194555# VDD3 VDD3 sg13_lv_pmos ad=0.19p pd=1.38u as=0.19p ps=1.38u w=1u l=0.7u
X1241 a_209480_329719# a_208939_329719# user_project_wrapper_0.IOVSS1 w_207883_330166# sg13_lv_pmos ad=0.68p pd=4.68u as=0.68p ps=4.68u w=2u l=0.13u
X1242 user_project_wrapper_0.IOVSS1 a_213462_327536# a_213870_324142# user_project_wrapper_0.IOVSS1 sg13_lv_pmos ad=1.824p pd=9.98u as=1.824p ps=9.98u w=9.6u l=0.13u
X1243 user_project_wrapper_0.IOVDD2 user_project_wrapper_0.sg13g2_IOPadIOVdd_0.sg13g2_Clamp_N43N43D4R_0.gate user_project_wrapper_0.IOVSS1 user_project_wrapper_0.IOVSS1 sg13_hv_nmos ad=2.596p pd=5.58u as=1.408p ps=5.04u w=4.4u l=0.6u
X1244 user_project_wrapper_0.IOVSS1 user_project_wrapper_0.sg13g2_IOPadIOVdd_1.sg13g2_RCClampResistor_0.p2 user_project_wrapper_0.IOVSS1 user_project_wrapper_0.IOVSS1 sg13_hv_nmos ad=1.71p pd=9.38u as=0 ps=0 w=9u l=9.5u
X1245 user_project_wrapper_0.IOVDD2 user_project_wrapper_0.sg13g2_IOPadIOVdd_0.sg13g2_Clamp_N43N43D4R_0.gate user_project_wrapper_0.IOVSS1 user_project_wrapper_0.IOVSS1 sg13_hv_nmos ad=2.596p pd=5.58u as=1.408p ps=5.04u w=4.4u l=0.6u
X1246 a_313884_185173# a_296731_189665# a_311189_185546# user_project_wrapper_0.IOVSS1 sg13_lv_nmos ad=3.4p pd=20.68u as=1.9p ps=10.38u w=10u l=0.5u
X1247 a_296731_208493# a_296625_208423# VDD3 VDD3 sg13_lv_pmos ad=0.2603p pd=1.75u as=0.2603p ps=1.75u w=1.37u l=0.35u
X1248 IOVDD3 a_355624_237844# analog_io[23] IOVDD3 sg13_hv_pmos ad=2.1312p pd=7.3u as=3.9294p ps=7.84u w=6.66u l=0.6u
X1249 user_project_wrapper_0.IOVSS1 a_213870_324142# user_project_wrapper_0.analog_io[35] user_project_wrapper_0.IOVSS1 sg13_lv_pmos ad=1.824p pd=9.98u as=1.824p ps=9.98u w=9.6u l=0.13u
X1250 user_project_wrapper_0.IOVSS1 user_project_wrapper_0.sg13g2_IOPadAnalog_15.padres dantenna l=0.64u w=3.1u
X1251 user_project_wrapper_0.IOVSS1 a_194687_324142# user_project_wrapper_0.analog_io[30] user_project_wrapper_0.IOVSS1 sg13_lv_pmos ad=1.824p pd=9.98u as=1.824p ps=9.98u w=9.6u l=0.13u
X1252 user_project_wrapper_0.analog_io[27] a_182931_326125# user_project_wrapper_0.IOVSS1 user_project_wrapper_0.IOVSS1 sg13_lv_pmos ad=1.824p pd=9.98u as=1.824p ps=9.98u w=9.6u l=0.13u
X1253 user_project_wrapper_0.IOVSS1 TOP_ROILIFNEURON_0.MEM a_192745_324776# user_project_wrapper_0.IOVSS1 sg13_lv_nmos ad=0.34p pd=2.68u as=0.19p ps=1.38u w=1u l=0.13u
X1254 QDLL_TOP_0.VOUT a_278644_29676# user_project_wrapper_0.IOVSS1 user_project_wrapper_0.IOVSS1 sg13_hv_nmos ad=2.596p pd=5.58u as=1.408p ps=5.04u w=4.4u l=0.6u
X1255 VDD3 a_309516_194555# a_309516_194555# VDD3 sg13_lv_pmos ad=0.19p pd=1.38u as=0.19p ps=1.38u w=1u l=0.7u
X1256 VDD3 a_296625_208423# a_296731_208493# VDD3 sg13_lv_pmos ad=0.2603p pd=1.75u as=0.2603p ps=1.75u w=1.37u l=0.35u
X1257 analog_io[26] a_369296_278644# user_project_wrapper_0.IOVSS1 user_project_wrapper_0.IOVSS1 sg13_hv_nmos ad=2.596p pd=5.58u as=1.408p ps=5.04u w=4.4u l=0.6u
X1258 a_78824_124371# user_project_wrapper_0.sg13g2_IOPadAnalog_8.padres user_project_wrapper_0.IOVSS1 user_project_wrapper_0.IOVSS1 sg13_lv_nmos ad=0.17p pd=1.68u as=0.17p ps=1.68u w=0.5u l=0.15u
X1259 user_project_wrapper_0.IOVSS1 a_29676_258244# user_project_wrapper_0.analog_io[7] user_project_wrapper_0.IOVSS1 sg13_hv_nmos ad=1.408p pd=5.04u as=2.596p ps=5.58u w=4.4u l=0.6u
X1260 user_project_wrapper_0.IOVSS1 user_project_wrapper_0.sg13g2_IOPadVdd_3.sg13g2_RCClampInverter_noptap_0.out user_project_wrapper_0.IOVSS1 user_project_wrapper_0.IOVSS1 sg13_hv_nmos ad=2.596p pd=5.58u as=0 ps=0 w=4.4u l=0.6u
X1261 a_210417_328605# a_210007_328605# user_project_wrapper_0.IOVSS1 user_project_wrapper_0.IOVSS1 sg13_lv_nmos ad=0.34p pd=2.68u as=0.34p ps=2.68u w=1u l=0.13u
X1262 user_project_wrapper_0.analog_io[15] a_237844_29676# user_project_wrapper_0.IOVSS1 user_project_wrapper_0.IOVSS1 sg13_hv_nmos ad=2.596p pd=5.58u as=2.068p ps=9.74u w=4.4u l=0.6u
X1263 user_project_wrapper_0.IOVSS1 a_194687_324142# user_project_wrapper_0.analog_io[30] user_project_wrapper_0.IOVSS1 sg13_lv_pmos ad=1.824p pd=9.98u as=1.824p ps=9.98u w=9.6u l=0.13u
X1264 user_project_wrapper_0.sg13g2_IOPadIOVdd_2.sg13g2_Clamp_N43N43D4R_0.gate user_project_wrapper_0.sg13g2_IOPadIOVdd_2.sg13g2_RCClampResistor_0.p2 user_project_wrapper_0.IOVSS1 user_project_wrapper_0.IOVSS1 sg13_hv_nmos ad=1.71p pd=9.38u as=1.71p ps=9.38u w=9u l=0.5u
X1265 user_project_wrapper_0.analog_io[15] a_237844_41476# user_project_wrapper_0.IOVDD2 user_project_wrapper_0.IOVDD2 sg13_hv_pmos ad=3.9294p pd=7.84u as=2.1312p ps=7.3u w=6.66u l=0.6u
X1266 IOVDD3 user_project_wrapper_0.sg13g2_IOPadIOVdd_3.sg13g2_Clamp_N43N43D4R_0.gate user_project_wrapper_0.IOVSS1 user_project_wrapper_0.IOVSS1 sg13_hv_nmos ad=2.596p pd=5.58u as=1.408p ps=5.04u w=4.4u l=0.6u
X1267 IOVDD3 user_project_wrapper_0.sg13g2_IOPadIOVdd_3.sg13g2_Clamp_N43N43D4R_0.gate user_project_wrapper_0.IOVSS1 user_project_wrapper_0.IOVSS1 sg13_hv_nmos ad=2.596p pd=5.58u as=1.408p ps=5.04u w=4.4u l=0.6u
X1268 QDLL_TOP_0.VDD a_189016_99480# a_189148_99070# QDLL_TOP_0.VDD sg13_lv_pmos ad=0.2245p pd=1.53u as=0.445p ps=2.89u w=1u l=0.25u
X1269 user_project_wrapper_0.analog_io[35] a_213870_324142# user_project_wrapper_0.IOVSS1 user_project_wrapper_0.IOVSS1 sg13_lv_nmos ad=0.912p pd=5.18u as=0.912p ps=5.18u w=4.8u l=0.13u
X1270 a_79038_123982# user_project_wrapper_0.sg13g2_IOPadAnalog_9.padres a_79025_124824# user_project_wrapper_0.VDD1 sg13_lv_pmos ad=0.95p pd=5.38u as=1.7p ps=10.68u w=5u l=0.3u
X1271 user_project_wrapper_0.IOVDD2 user_project_wrapper_0.sg13g2_IOPadIOVdd_0.sg13g2_Clamp_N43N43D4R_0.gate user_project_wrapper_0.IOVSS1 user_project_wrapper_0.IOVSS1 sg13_hv_nmos ad=3.256p pd=10.28u as=1.408p ps=5.04u w=4.4u l=0.6u
X1272 user_project_wrapper_0.IOVSS1 user_project_wrapper_0.sg13g2_IOPadIOVdd_1.sg13g2_RCClampResistor_0.p2 user_project_wrapper_0.IOVSS1 user_project_wrapper_0.IOVSS1 sg13_hv_nmos ad=1.71p pd=9.38u as=0 ps=0 w=9u l=9.5u
X1273 user_project_wrapper_0.IOVSS1 user_project_wrapper_0.sg13g2_IOPadIOVdd_2.sg13g2_RCClampResistor_0.p2 user_project_wrapper_0.IOVSS1 user_project_wrapper_0.IOVSS1 sg13_hv_nmos ad=1.71p pd=9.38u as=0 ps=0 w=9u l=9.5u
X1274 a_309917_199879# a_309516_194555# VDD3 VDD3 sg13_lv_pmos ad=0.19p pd=1.38u as=0.19p ps=1.38u w=1u l=0.7u
X1275 user_project_wrapper_0.IOVSS1 user_project_wrapper_0.IOVDD1 dpantenna l=1.26u w=27.78u
X1276 a_311189_211724# a_296731_208493# a_313884_211353# user_project_wrapper_0.IOVSS1 sg13_lv_nmos ad=1.9p pd=10.38u as=1.9p ps=10.38u w=10u l=0.5u
X1277 user_project_wrapper_0.IOVSS1 a_213870_324142# user_project_wrapper_0.analog_io[35] user_project_wrapper_0.IOVSS1 sg13_lv_pmos ad=1.824p pd=9.98u as=1.824p ps=9.98u w=9.6u l=0.13u
X1278 user_project_wrapper_0.IOVSS1 a_258244_369296# user_project_wrapper_0.analog_io[34] user_project_wrapper_0.IOVSS1 sg13_hv_nmos ad=1.408p pd=5.04u as=2.596p ps=5.58u w=4.4u l=0.6u
X1279 user_project_wrapper_0.analog_io[33] a_237844_355624# user_project_wrapper_0.IOVDD4 user_project_wrapper_0.IOVDD4 sg13_hv_pmos ad=3.9294p pd=7.84u as=2.1312p ps=7.3u w=6.66u l=0.6u
X1280 user_project_wrapper_0.analog_io[27] a_182931_326125# user_project_wrapper_0.IOVSS1 user_project_wrapper_0.IOVSS1 sg13_lv_pmos ad=1.824p pd=9.98u as=1.824p ps=9.98u w=9.6u l=0.13u
X1281 user_project_wrapper_0.IOVSS1 a_210417_326377# a_210621_326377# user_project_wrapper_0.IOVSS1 sg13_lv_nmos ad=0.19p pd=1.38u as=0.19p ps=1.38u w=1u l=0.13u
X1282 user_project_wrapper_0.IOVDD2 user_project_wrapper_0.sg13g2_IOPadIOVdd_0.sg13g2_Clamp_N43N43D4R_0.gate user_project_wrapper_0.IOVSS1 user_project_wrapper_0.IOVSS1 sg13_hv_nmos ad=2.596p pd=5.58u as=1.408p ps=5.04u w=4.4u l=0.6u
X1283 a_309917_199879# a_309516_194555# VDD3 VDD3 sg13_lv_pmos ad=0.19p pd=1.38u as=0.19p ps=1.38u w=1u l=0.7u
X1284 user_project_wrapper_0.IOVDD2 a_258244_41476# user_project_wrapper_0.analog_io[16] user_project_wrapper_0.IOVDD2 sg13_hv_pmos ad=2.1312p pd=7.3u as=3.9294p ps=7.84u w=6.66u l=0.6u
X1285 user_project_wrapper_0.IOVSS1 a_213870_324142# user_project_wrapper_0.analog_io[35] user_project_wrapper_0.IOVSS1 sg13_lv_pmos ad=1.824p pd=9.98u as=1.824p ps=9.98u w=9.6u l=0.13u
X1286 user_project_wrapper_0.IOVSS1 a_194687_324142# user_project_wrapper_0.analog_io[30] user_project_wrapper_0.IOVSS1 sg13_lv_pmos ad=3.264p pd=19.88u as=1.824p ps=9.98u w=9.6u l=0.13u
X1287 user_project_wrapper_0.IOVSS1 user_project_wrapper_0.sg13g2_IOPadVdd_3.sg13g2_RCClampInverter_noptap_0.out user_project_wrapper_0.IOVSS1 user_project_wrapper_0.IOVSS1 sg13_hv_nmos ad=1.408p pd=5.04u as=0 ps=0 w=4.4u l=0.6u
X1288 a_369296_237844# user_project_wrapper_0.IOVSS1 user_project_wrapper_0.IOVSS1 rppd l=3.54u w=0.5u
X1289 a_87468_125419# a_88291_125210# user_project_wrapper_0.VDD1 user_project_wrapper_0.VDD1 sg13_lv_pmos ad=0.3808p pd=2.92u as=0.3808p ps=2.92u w=1.12u l=0.13u
X1290 VDD3 a_309516_194555# a_309917_194695# VDD3 sg13_lv_pmos ad=0.19p pd=1.38u as=0.19p ps=1.38u w=1u l=0.7u
X1291 a_309917_194695# a_309516_194555# VDD3 VDD3 sg13_lv_pmos ad=0.19p pd=1.38u as=0.19p ps=1.38u w=1u l=0.7u
X1292 user_project_wrapper_0.IOVDD2 a_217444_41476# user_project_wrapper_0.analog_io[14] user_project_wrapper_0.IOVDD2 sg13_hv_pmos ad=2.1312p pd=7.3u as=3.9294p ps=7.84u w=6.66u l=0.6u
X1293 user_project_wrapper_0.IOVDD4 user_project_wrapper_0.sg13g2_IOPadIOVdd_2.sg13g2_Clamp_N43N43D4R_0.gate user_project_wrapper_0.IOVSS1 user_project_wrapper_0.IOVSS1 sg13_hv_nmos ad=3.256p pd=10.28u as=1.408p ps=5.04u w=4.4u l=0.6u
X1294 user_project_wrapper_0.analog_io[30] a_176644_355624# user_project_wrapper_0.IOVDD4 user_project_wrapper_0.IOVDD4 sg13_hv_pmos ad=3.9294p pd=7.84u as=2.1312p ps=7.3u w=6.66u l=0.6u
X1295 user_project_wrapper_0.IOVSS1 user_project_wrapper_0.sg13g2_IOPadVdd_2.sg13g2_RCClampInverter_noptap_0.out user_project_wrapper_0.VDD1 user_project_wrapper_0.IOVSS1 sg13_hv_nmos ad=1.408p pd=5.04u as=2.596p ps=5.58u w=4.4u l=0.6u
X1296 user_project_wrapper_0.sg13g2_IOPadIOVdd_1.sg13g2_Clamp_N43N43D4R_0.gate user_project_wrapper_0.sg13g2_IOPadIOVdd_1.sg13g2_RCClampResistor_0.p2 user_project_wrapper_0.IOVDD1 user_project_wrapper_0.IOVDD1 sg13_hv_pmos ad=1.33p pd=7.38u as=1.33p ps=7.38u w=7u l=0.5u
X1297 user_project_wrapper_0.IOVDD4 user_project_wrapper_0.sg13g2_IOPadIOVdd_2.sg13g2_Clamp_N43N43D4R_0.gate user_project_wrapper_0.IOVSS1 user_project_wrapper_0.IOVSS1 sg13_hv_nmos ad=2.596p pd=5.58u as=1.408p ps=5.04u w=4.4u l=0.6u
X1298 user_project_wrapper_0.sg13g2_IOPadVdd_0.sg13g2_RCClampInverter_noptap_0.out user_project_wrapper_0.sg13g2_IOPadVdd_0.sg13g2_RCClampResistor_0.p2 user_project_wrapper_0.IOVSS1 user_project_wrapper_0.IOVSS1 sg13_hv_nmos ad=1.71p pd=9.38u as=1.71p ps=9.38u w=9u l=0.5u
X1299 user_project_wrapper_0.VDD2 user_project_wrapper_0.sg13g2_IOPadVdd_1.sg13g2_RCClampInverter_noptap_0.out user_project_wrapper_0.IOVSS1 user_project_wrapper_0.IOVSS1 sg13_hv_nmos ad=2.596p pd=5.58u as=1.408p ps=5.04u w=4.4u l=0.6u
X1300 user_project_wrapper_0.IOVSS1 a_186202_326221# a_182931_326125# user_project_wrapper_0.IOVSS1 sg13_lv_nmos ad=0.912p pd=5.18u as=0.912p ps=5.18u w=4.8u l=0.13u
X1301 user_project_wrapper_0.IOVSS1 user_project_wrapper_0.sg13g2_IOPadVdd_3.sg13g2_RCClampInverter_noptap_0.out user_project_wrapper_0.IOVSS1 user_project_wrapper_0.IOVSS1 sg13_hv_nmos ad=2.596p pd=5.58u as=0 ps=0 w=4.4u l=0.6u
X1302 a_305695_364458# a_305365_360372# user_project_wrapper_0.IOVSS1 rppd l=20u w=1u
X1303 user_project_wrapper_0.analog_io[27] user_project_wrapper_0.sg13g2_IOPadAnalog_16.padres user_project_wrapper_0.IOVSS1 rppd l=2u w=1u
X1304 VDD3 a_296625_189595# a_296731_189665# VDD3 sg13_lv_pmos ad=0.2603p pd=1.75u as=0.2603p ps=1.75u w=1.37u l=0.35u
X1305 VDD3 user_project_wrapper_0.sg13g2_IOPadVdd_0.sg13g2_RCClampInverter_noptap_0.out user_project_wrapper_0.IOVSS1 user_project_wrapper_0.IOVSS1 sg13_hv_nmos ad=2.596p pd=5.58u as=1.408p ps=5.04u w=4.4u l=0.6u
X1306 user_project_wrapper_0.analog_io[10] a_135844_29676# user_project_wrapper_0.IOVSS1 user_project_wrapper_0.IOVSS1 sg13_hv_nmos ad=2.596p pd=5.58u as=1.408p ps=5.04u w=4.4u l=0.6u
X1307 VDD3 a_296625_208423# a_296731_208493# VDD3 sg13_lv_pmos ad=0.2603p pd=1.75u as=0.2603p ps=1.75u w=1.37u l=0.35u
X1308 a_311846_195517# user_project_wrapper_0.sg13g2_IOPadAnalog_29.padres a_309917_199879# VDD3 sg13_lv_pmos ad=0.24415p pd=1.665u as=0.24415p ps=1.665u w=1.285u l=0.35u
X1309 user_project_wrapper_0.IOVSS1 user_project_wrapper_0.sg13g2_IOPadVdd_1.sg13g2_RCClampInverter_noptap_0.out user_project_wrapper_0.VDD2 user_project_wrapper_0.IOVSS1 sg13_hv_nmos ad=1.408p pd=5.04u as=2.596p ps=5.58u w=4.4u l=0.6u
X1310 user_project_wrapper_0.analog_io[6] a_29676_237844# user_project_wrapper_0.IOVSS1 user_project_wrapper_0.IOVSS1 sg13_hv_nmos ad=2.596p pd=5.58u as=1.408p ps=5.04u w=4.4u l=0.6u
X1311 user_project_wrapper_0.IOVSS1 user_project_wrapper_0.analog_io[10] dantenna l=1.26u w=27.78u
X1312 user_project_wrapper_0.IOVSS1 a_213870_324142# user_project_wrapper_0.analog_io[35] user_project_wrapper_0.IOVSS1 sg13_lv_pmos ad=1.824p pd=9.98u as=1.824p ps=9.98u w=9.6u l=0.13u
X1313 VDD3 user_project_wrapper_0.sg13g2_IOPadVdd_0.sg13g2_RCClampResistor_0.p2 user_project_wrapper_0.sg13g2_IOPadVdd_0.sg13g2_RCClampInverter_noptap_0.out VDD3 sg13_hv_pmos ad=1.33p pd=7.38u as=1.33p ps=7.38u w=7u l=0.5u
X1314 user_project_wrapper_0.IOVSS1 user_project_wrapper_0.sg13g2_IOPadVdd_0.sg13g2_RCClampInverter_noptap_0.out VDD3 user_project_wrapper_0.IOVSS1 sg13_hv_nmos ad=1.408p pd=5.04u as=2.596p ps=5.58u w=4.4u l=0.6u
X1315 user_project_wrapper_0.IOVSS1 user_project_wrapper_0.sg13g2_IOPadVdd_1.sg13g2_RCClampInverter_noptap_0.out user_project_wrapper_0.VDD2 user_project_wrapper_0.IOVSS1 sg13_hv_nmos ad=1.408p pd=5.04u as=2.596p ps=5.58u w=4.4u l=0.6u
X1316 VDD3 a_296625_208423# a_296731_208493# VDD3 sg13_lv_pmos ad=0.2603p pd=1.75u as=0.2603p ps=1.75u w=1.37u l=0.35u
X1317 user_project_wrapper_0.IOVDD4 a_258244_355624# user_project_wrapper_0.analog_io[34] user_project_wrapper_0.IOVDD4 sg13_hv_pmos ad=2.1312p pd=7.3u as=3.9294p ps=7.84u w=6.66u l=0.6u
X1318 IOVDD3 user_project_wrapper_0.sg13g2_IOPadIOVdd_3.sg13g2_Clamp_N43N43D4R_0.gate user_project_wrapper_0.IOVSS1 user_project_wrapper_0.IOVSS1 sg13_hv_nmos ad=2.596p pd=5.58u as=1.408p ps=5.04u w=4.4u l=0.6u
X1319 user_project_wrapper_0.IOVSS1 TOP_ROILIFNEURON_0.MEM a_211928_324776# user_project_wrapper_0.IOVSS1 sg13_lv_nmos ad=0.34p pd=2.68u as=0.19p ps=1.38u w=1u l=0.13u
X1320 user_project_wrapper_0.IOVSS1 analog_io[20] dantenna l=27.78u w=1.26u
X1321 user_project_wrapper_0.analog_io[34] user_project_wrapper_0.IOVDD4 dpantenna l=1.26u w=27.78u
X1322 user_project_wrapper_0.sg13g2_IOPadVdd_1.sg13g2_RCClampInverter_noptap_0.out user_project_wrapper_0.sg13g2_IOPadVdd_1.sg13g2_RCClampResistor_0.p2 user_project_wrapper_0.VDD2 user_project_wrapper_0.VDD2 sg13_hv_pmos ad=1.33p pd=7.38u as=1.33p ps=7.38u w=7u l=0.5u
X1323 user_project_wrapper_0.VDD1 user_project_wrapper_0.sg13g2_IOPadOut4mA$1_0.c2p a_58798_179951# user_project_wrapper_0.VDD1 sg13_lv_pmos ad=1.615p pd=10.18u as=1.615p ps=10.18u w=4.75u l=0.13u
X1324 a_296625_208423# a_301940_196388# a_296732_200582# VDD3 sg13_lv_pmos ad=0.7695p pd=4.43u as=1.377p ps=8.78u w=4.05u l=0.5u
X1325 user_project_wrapper_0.IOVSS1 user_project_wrapper_0.sg13g2_IOPadVdd_3.sg13g2_RCClampInverter_noptap_0.out user_project_wrapper_0.IOVSS1 user_project_wrapper_0.IOVSS1 sg13_hv_nmos ad=2.596p pd=5.58u as=0 ps=0 w=4.4u l=0.6u
X1326 a_85127_131750# a_84707_131750# user_project_wrapper_0.IOVSS1 user_project_wrapper_0.IOVSS1 sg13_lv_nmos ad=0.2516p pd=2.16u as=0.2516p ps=2.16u w=0.74u l=0.13u
X1327 VDD3 a_296625_189595# a_296731_189665# VDD3 sg13_lv_pmos ad=0.2603p pd=1.75u as=0.2603p ps=1.75u w=1.37u l=0.35u
X1328 user_project_wrapper_0.IOVSS1 user_project_wrapper_0.sg13g2_IOPadIOVdd_1.sg13g2_RCClampResistor_0.p2 user_project_wrapper_0.IOVSS1 user_project_wrapper_0.IOVSS1 sg13_hv_nmos ad=1.71p pd=9.38u as=0 ps=0 w=9u l=9.5u
X1329 user_project_wrapper_0.analog_io[0] a_41476_115444# user_project_wrapper_0.IOVDD1 user_project_wrapper_0.IOVDD1 sg13_hv_pmos ad=3.9294p pd=7.84u as=2.1312p ps=7.3u w=6.66u l=0.6u
X1330 a_302395_364458# a_302725_360372# user_project_wrapper_0.IOVSS1 rppd l=20u w=1u
X1331 user_project_wrapper_0.IOVSS1 user_project_wrapper_0.sg13g2_IOPadIOVdd_1.sg13g2_Clamp_N43N43D4R_0.gate user_project_wrapper_0.IOVDD1 user_project_wrapper_0.IOVSS1 sg13_hv_nmos ad=1.408p pd=5.04u as=2.596p ps=5.58u w=4.4u l=0.6u
X1332 user_project_wrapper_0.IOVSS1 a_307232_196607# a_304995_198817# user_project_wrapper_0.IOVSS1 sg13_lv_nmos ad=0.6327p pd=3.71u as=0.6327p ps=3.71u w=3.33u l=0.2u
X1333 analog_io[20] a_355624_176644# IOVDD3 IOVDD3 sg13_hv_pmos ad=3.9294p pd=7.84u as=2.1312p ps=7.3u w=6.66u l=0.6u
X1334 a_309917_199879# user_project_wrapper_0.sg13g2_IOPadAnalog_29.padres a_311846_195517# VDD3 sg13_lv_pmos ad=0.24415p pd=1.665u as=0.24415p ps=1.665u w=1.285u l=0.35u
X1335 a_78824_133051# a_78824_133051# user_project_wrapper_0.VDD1 user_project_wrapper_0.VDD1 sg13_lv_pmos ad=0.95p pd=5.38u as=1.7p ps=10.68u w=5u l=0.15u
X1336 a_296731_189665# a_296625_189595# VDD3 VDD3 sg13_lv_pmos ad=0.2603p pd=1.75u as=0.2603p ps=1.75u w=1.37u l=0.35u
X1337 VDD3 a_296625_208423# a_296731_208493# VDD3 sg13_lv_pmos ad=0.2603p pd=1.75u as=0.2603p ps=1.75u w=1.37u l=0.35u
X1338 a_271172_100118# a_270512_100118# user_project_wrapper_0.IOVSS1 user_project_wrapper_0.IOVSS1 sg13_lv_nmos ad=0.1406p pd=1.12u as=0.2516p ps=2.16u w=0.74u l=0.13u
X1339 a_296731_189665# a_296625_189595# VDD3 VDD3 sg13_lv_pmos ad=0.2603p pd=1.75u as=0.2603p ps=1.75u w=1.37u l=0.35u
X1340 user_project_wrapper_0.analog_io[32] a_217444_369296# user_project_wrapper_0.IOVSS1 user_project_wrapper_0.IOVSS1 sg13_hv_nmos ad=2.596p pd=5.58u as=1.408p ps=5.04u w=4.4u l=0.6u
X1341 a_309917_194695# a_296731_189665# a_307232_196607# VDD3 sg13_lv_pmos ad=0.24415p pd=1.665u as=0.24415p ps=1.665u w=1.285u l=0.35u
X1342 user_project_wrapper_0.VDD1 user_project_wrapper_0.sg13g2_IOPadVdd_2.sg13g2_RCClampInverter_noptap_0.out user_project_wrapper_0.IOVSS1 user_project_wrapper_0.IOVSS1 sg13_hv_nmos ad=2.596p pd=5.58u as=2.068p ps=9.74u w=4.4u l=0.6u
X1343 IOVDD3 a_355624_115444# analog_io[18] IOVDD3 sg13_hv_pmos ad=2.1312p pd=7.3u as=3.9294p ps=7.84u w=6.66u l=0.6u
X1344 user_project_wrapper_0.IOVSS1 user_project_wrapper_0.sg13g2_IOPadIOVdd_3.sg13g2_Clamp_N43N43D4R_0.gate IOVDD3 user_project_wrapper_0.IOVSS1 sg13_hv_nmos ad=1.408p pd=5.04u as=2.596p ps=5.58u w=4.4u l=0.6u
X1345 user_project_wrapper_0.analog_io[15] a_237844_41476# user_project_wrapper_0.IOVDD2 user_project_wrapper_0.IOVDD2 sg13_hv_pmos ad=3.9294p pd=7.84u as=2.1312p ps=7.3u w=6.66u l=0.6u
X1346 user_project_wrapper_0.IOVSS1 a_202114_326125# user_project_wrapper_0.analog_io[32] user_project_wrapper_0.IOVSS1 sg13_lv_pmos ad=1.824p pd=9.98u as=1.824p ps=9.98u w=9.6u l=0.13u
X1347 a_360372_75025# a_364458_75355# user_project_wrapper_0.IOVSS1 rppd l=20u w=1u
X1348 user_project_wrapper_0.IOVSS1 user_project_wrapper_0.sg13g2_IOPadIOVdd_1.sg13g2_RCClampResistor_0.p2 user_project_wrapper_0.IOVSS1 user_project_wrapper_0.IOVSS1 sg13_hv_nmos ad=1.71p pd=9.38u as=0 ps=0 w=9u l=9.5u
X1349 user_project_wrapper_0.IOVSS1 user_project_wrapper_0.sg13g2_IOPadVdd_1.sg13g2_RCClampInverter_noptap_0.out user_project_wrapper_0.VDD2 user_project_wrapper_0.IOVSS1 sg13_hv_nmos ad=1.408p pd=5.04u as=2.596p ps=5.58u w=4.4u l=0.6u
X1350 a_35456_299095# a_39542_299425# user_project_wrapper_0.IOVSS1 rppd l=20u w=1u
X1351 user_project_wrapper_0.IOVSS1 a_135844_369296# user_project_wrapper_0.analog_io[28] user_project_wrapper_0.IOVSS1 sg13_hv_nmos ad=1.408p pd=5.04u as=2.596p ps=5.58u w=4.4u l=0.6u
X1352 user_project_wrapper_0.IOVSS1 a_258244_29676# user_project_wrapper_0.analog_io[16] user_project_wrapper_0.IOVSS1 sg13_hv_nmos ad=1.408p pd=5.04u as=2.596p ps=5.58u w=4.4u l=0.6u
X1353 user_project_wrapper_0.analog_io[14] a_190389_99046# user_project_wrapper_0.IOVSS1 user_project_wrapper_0.IOVSS1 sg13_lv_nmos ad=0.1406p pd=1.12u as=0.1406p ps=1.12u w=0.74u l=0.13u
X1354 a_190389_99046# a_189729_99046# user_project_wrapper_0.IOVSS1 user_project_wrapper_0.IOVSS1 sg13_lv_nmos ad=0.1443p pd=1.13u as=0.1406p ps=1.12u w=0.74u l=0.13u
X1355 a_296731_189665# a_296625_189595# VDD3 VDD3 sg13_lv_pmos ad=0.2603p pd=1.75u as=0.2603p ps=1.75u w=1.37u l=0.35u
X1356 user_project_wrapper_0.IOVSS1 user_project_wrapper_0.sg13g2_IOPadIOVdd_1.sg13g2_Clamp_N43N43D4R_0.gate user_project_wrapper_0.IOVDD1 user_project_wrapper_0.IOVSS1 sg13_hv_nmos ad=1.408p pd=5.04u as=2.596p ps=5.58u w=4.4u l=0.6u
X1357 user_project_wrapper_0.IOVSS1 user_project_wrapper_0.sg13g2_IOPadVdd_3.sg13g2_RCClampInverter_noptap_0.out user_project_wrapper_0.IOVSS1 user_project_wrapper_0.IOVSS1 sg13_hv_nmos ad=1.408p pd=5.04u as=0 ps=0 w=4.4u l=0.6u
X1358 user_project_wrapper_0.sg13g2_IOPadAnalog_7.padres QDLL_TOP_0.VOUT user_project_wrapper_0.IOVSS1 rppd l=2u w=1u
X1359 user_project_wrapper_0.IOVDD4 a_258244_355624# user_project_wrapper_0.analog_io[34] user_project_wrapper_0.IOVDD4 sg13_hv_pmos ad=3.1302p pd=14.26u as=3.9294p ps=7.84u w=6.66u l=0.6u
X1360 user_project_wrapper_0.analog_io[14] user_project_wrapper_0.IOVDD2 dpantenna l=1.26u w=27.78u
X1361 a_86594_127896# a_86507_127725# user_project_wrapper_0.VDD1 user_project_wrapper_0.VDD1 sg13_lv_pmos ad=0.2128p pd=1.5u as=0.3808p ps=2.92u w=1.12u l=0.13u
X1362 VDD3 a_309516_194555# a_309917_194695# VDD3 sg13_lv_pmos ad=0.19p pd=1.38u as=0.19p ps=1.38u w=1u l=0.7u
X1363 user_project_wrapper_0.IOVSS1 user_project_wrapper_0.sg13g2_IOPadVdd_1.sg13g2_RCClampInverter_noptap_0.out user_project_wrapper_0.VDD2 user_project_wrapper_0.IOVSS1 sg13_hv_nmos ad=1.408p pd=5.04u as=2.596p ps=5.58u w=4.4u l=0.6u
X1364 user_project_wrapper_0.IOVSS1 user_project_wrapper_0.sg13g2_IOPadAnalog_22.padres a_208469_327491# user_project_wrapper_0.IOVSS1 sg13_lv_nmos ad=0.34p pd=2.68u as=0.19p ps=1.38u w=1u l=0.13u
X1365 VDD3 a_309516_194555# a_309917_199879# VDD3 sg13_lv_pmos ad=0.19p pd=1.38u as=0.19p ps=1.38u w=1u l=0.7u
X1366 a_188184_101343# a_187914_101343# QDLL_TOP_0.VDD QDLL_TOP_0.VDD sg13_lv_pmos ad=0.34p pd=2.68u as=0.1523p ps=1.38u w=1u l=0.5u
X1367 a_296731_208493# a_296625_208423# VDD3 VDD3 sg13_lv_pmos ad=0.2603p pd=1.75u as=0.2603p ps=1.75u w=1.37u l=0.35u
X1368 analog_io[18] a_369296_115444# user_project_wrapper_0.IOVSS1 user_project_wrapper_0.IOVSS1 sg13_hv_nmos ad=2.596p pd=5.58u as=1.408p ps=5.04u w=4.4u l=0.6u
X1369 user_project_wrapper_0.IOVSS1 user_project_wrapper_0.sg13g2_IOPadVdd_1.sg13g2_RCClampInverter_noptap_0.out user_project_wrapper_0.VDD2 user_project_wrapper_0.IOVSS1 sg13_hv_nmos ad=1.408p pd=5.04u as=2.596p ps=5.58u w=4.4u l=0.6u
X1370 user_project_wrapper_0.VDD2 user_project_wrapper_0.sg13g2_IOPadVdd_1.sg13g2_RCClampInverter_noptap_0.out user_project_wrapper_0.IOVSS1 user_project_wrapper_0.IOVSS1 sg13_hv_nmos ad=2.596p pd=5.58u as=1.408p ps=5.04u w=4.4u l=0.6u
X1371 a_296732_200582# a_296626_197740# VDD3 VDD3 sg13_lv_pmos ad=1.33p pd=7.38u as=1.33p ps=7.38u w=7u l=0.7u
X1372 a_360372_301405# a_364458_301735# user_project_wrapper_0.IOVSS1 rppd l=20u w=1u
X1373 user_project_wrapper_0.sg13g2_IOPadOut4mA$1_0.sg13g2_GateLevelUpInv_noptap$1$1_0.pgate a_57810_180219# user_project_wrapper_0.IOVSS1 user_project_wrapper_0.IOVSS1 sg13_hv_nmos ad=0.646p pd=4.48u as=0.646p ps=4.48u w=1.9u l=0.45u
X1374 VDD3 a_309516_194555# a_309516_194555# VDD3 sg13_lv_pmos ad=0.19p pd=1.38u as=0.19p ps=1.38u w=1u l=0.7u
X1375 VDD3 user_project_wrapper_0.sg13g2_IOPadVdd_0.sg13g2_RCClampInverter_noptap_0.out user_project_wrapper_0.IOVSS1 user_project_wrapper_0.IOVSS1 sg13_hv_nmos ad=2.596p pd=5.58u as=1.408p ps=5.04u w=4.4u l=0.6u
X1376 user_project_wrapper_0.IOVSS1 user_project_wrapper_0.sg13g2_IOPadVdd_3.sg13g2_RCClampResistor_0.p2 user_project_wrapper_0.sg13g2_IOPadVdd_3.sg13g2_RCClampInverter_noptap_0.out user_project_wrapper_0.IOVSS1 sg13_hv_pmos ad=2.38p pd=14.68u as=1.33p ps=7.38u w=7u l=0.5u
X1377 a_296732_197880# a_301940_196388# a_296625_189595# VDD3 sg13_lv_pmos ad=1.377p pd=8.78u as=0.7695p ps=4.43u w=4.05u l=0.5u
X1378 a_213870_324142# a_213462_327536# user_project_wrapper_0.IOVSS1 user_project_wrapper_0.IOVSS1 sg13_lv_nmos ad=0.912p pd=5.18u as=0.912p ps=5.18u w=4.8u l=0.13u
X1379 VDD3 user_project_wrapper_0.sg13g2_IOPadVdd_0.sg13g2_RCClampResistor_0.p2 user_project_wrapper_0.sg13g2_IOPadVdd_0.sg13g2_RCClampInverter_noptap_0.out VDD3 sg13_hv_pmos ad=1.33p pd=7.38u as=1.33p ps=7.38u w=7u l=0.5u
X1380 user_project_wrapper_0.IOVSS1 user_project_wrapper_0.sg13g2_IOPadIOVdd_0.sg13g2_Clamp_N43N43D4R_0.gate user_project_wrapper_0.IOVDD2 user_project_wrapper_0.IOVSS1 sg13_hv_nmos ad=1.408p pd=5.04u as=2.596p ps=5.58u w=4.4u l=0.6u
X1381 user_project_wrapper_0.IOVDD4 a_176644_355624# user_project_wrapper_0.IOVDD4 rppd l=12.9u w=0.5u
X1382 user_project_wrapper_0.IOVSS1 a_194687_324142# user_project_wrapper_0.analog_io[30] user_project_wrapper_0.IOVSS1 sg13_lv_pmos ad=1.824p pd=9.98u as=1.824p ps=9.98u w=9.6u l=0.13u
X1383 user_project_wrapper_0.analog_io[28] a_135844_369296# user_project_wrapper_0.IOVSS1 user_project_wrapper_0.IOVSS1 sg13_hv_nmos ad=2.596p pd=5.58u as=2.068p ps=9.74u w=4.4u l=0.6u
X1384 a_83070_130212# a_82746_130212# user_project_wrapper_0.IOVSS1 user_project_wrapper_0.IOVSS1 sg13_lv_nmos ad=0.1406p pd=1.12u as=0.2516p ps=2.16u w=0.74u l=0.13u
X1385 user_project_wrapper_0.VDD1 user_project_wrapper_0.sg13g2_IOPadVdd_2.sg13g2_RCClampResistor_0.p2 user_project_wrapper_0.sg13g2_IOPadVdd_2.sg13g2_RCClampInverter_noptap_0.out user_project_wrapper_0.VDD1 sg13_hv_pmos ad=2.38p pd=14.68u as=1.33p ps=7.38u w=7u l=0.5u
X1386 VDD3 a_309516_194555# a_309917_199879# VDD3 sg13_lv_pmos ad=0.19p pd=1.38u as=0.19p ps=1.38u w=1u l=0.7u
X1387 a_35456_304375# a_39542_304705# user_project_wrapper_0.IOVSS1 rppd l=20u w=1u
X1388 user_project_wrapper_0.IOVSS1 user_project_wrapper_0.sg13g2_IOPadIOVdd_0.sg13g2_Clamp_N43N43D4R_0.gate user_project_wrapper_0.IOVDD2 user_project_wrapper_0.IOVSS1 sg13_hv_nmos ad=1.408p pd=5.04u as=2.596p ps=5.58u w=4.4u l=0.6u
X1389 user_project_wrapper_0.IOVSS1 a_369296_278644# analog_io[26] user_project_wrapper_0.IOVSS1 sg13_hv_nmos ad=1.408p pd=5.04u as=2.596p ps=5.58u w=4.4u l=0.6u
X1390 a_208469_328605# a_208367_329719# a_208367_328605# w_207887_327938# sg13_lv_pmos ad=0.38p pd=2.38u as=0.38p ps=2.38u w=2u l=0.13u
X1391 a_296731_189665# a_296625_189595# VDD3 VDD3 sg13_lv_pmos ad=0.2603p pd=1.75u as=0.2603p ps=1.75u w=1.37u l=0.35u
X1392 user_project_wrapper_0.analog_io[34] a_258244_355624# user_project_wrapper_0.IOVDD4 user_project_wrapper_0.IOVDD4 sg13_hv_pmos ad=3.9294p pd=7.84u as=2.1312p ps=7.3u w=6.66u l=0.6u
X1393 a_296731_208493# a_296625_208423# VDD3 VDD3 sg13_lv_pmos ad=0.2603p pd=1.75u as=0.4658p ps=3.42u w=1.37u l=0.35u
X1394 a_85359_125209# a_84332_125209# a_85257_125209# user_project_wrapper_0.IOVSS1 sg13_lv_nmos ad=0.1406p pd=1.12u as=0.1406p ps=1.12u w=0.74u l=0.13u
X1395 a_296731_189665# a_296625_189595# VDD3 VDD3 sg13_lv_pmos ad=0.2603p pd=1.75u as=0.4658p ps=3.42u w=1.37u l=0.35u
X1396 a_87832_241383# user_project_wrapper_0.sg13g2_IOPadOut4mA$1_1.c2p user_project_wrapper_0.VDD1 user_project_wrapper_0.VDD1 sg13_lv_pmos ad=0.3808p pd=2.92u as=0.3808p ps=2.92u w=1.12u l=0.13u
X1397 user_project_wrapper_0.IOVSS1 a_194687_324142# user_project_wrapper_0.analog_io[30] user_project_wrapper_0.IOVSS1 sg13_lv_pmos ad=1.824p pd=9.98u as=1.824p ps=9.98u w=9.6u l=0.13u
X1398 VDD3 a_296625_189595# a_296731_189665# VDD3 sg13_lv_pmos ad=0.4658p pd=3.42u as=0.2603p ps=1.75u w=1.37u l=0.35u
X1399 analog_io[22] a_355624_197044# IOVDD3 IOVDD3 sg13_hv_pmos ad=3.9294p pd=7.84u as=2.1312p ps=7.3u w=6.66u l=0.6u
X1400 user_project_wrapper_0.IOVSS1 user_project_wrapper_0.sg13g2_IOPadVdd_1.sg13g2_RCClampInverter_noptap_0.out user_project_wrapper_0.VDD2 user_project_wrapper_0.IOVSS1 sg13_hv_nmos ad=1.408p pd=5.04u as=2.596p ps=5.58u w=4.4u l=0.6u
X1401 user_project_wrapper_0.IOVSS1 user_project_wrapper_0.IOVSS1 dantenna l=1.26u w=27.78u
X1402 user_project_wrapper_0.IOVSS1 user_project_wrapper_0.sg13g2_IOPadIOVdd_2.sg13g2_Clamp_N43N43D4R_0.gate user_project_wrapper_0.IOVDD4 user_project_wrapper_0.IOVSS1 sg13_hv_nmos ad=1.408p pd=5.04u as=2.596p ps=5.58u w=4.4u l=0.6u
X1403 user_project_wrapper_0.IOVDD4 a_176644_355624# user_project_wrapper_0.analog_io[30] user_project_wrapper_0.IOVDD4 sg13_hv_pmos ad=2.1312p pd=7.3u as=3.9294p ps=7.84u w=6.66u l=0.6u
X1404 a_296731_208493# a_301186_192011# user_project_wrapper_0.IOVSS1 user_project_wrapper_0.IOVSS1 sg13_lv_nmos ad=0.912p pd=5.18u as=0.912p ps=5.18u w=4.8u l=1.06u
X1405 QDLL_TOP_0.VOUT a_278644_41476# user_project_wrapper_0.IOVDD2 user_project_wrapper_0.IOVDD2 sg13_hv_pmos ad=3.9294p pd=7.84u as=2.1312p ps=7.3u w=6.66u l=0.6u
X1406 a_296731_208493# a_296625_208423# VDD3 VDD3 sg13_lv_pmos ad=0.2603p pd=1.75u as=0.2603p ps=1.75u w=1.37u l=0.35u
X1407 user_project_wrapper_0.IOVSS1 a_213870_324142# user_project_wrapper_0.analog_io[35] user_project_wrapper_0.IOVSS1 sg13_lv_pmos ad=1.824p pd=9.98u as=1.824p ps=9.98u w=9.6u l=0.13u
X1408 user_project_wrapper_0.analog_io[27] a_182931_326125# user_project_wrapper_0.IOVSS1 user_project_wrapper_0.IOVSS1 sg13_lv_pmos ad=1.824p pd=9.98u as=1.824p ps=9.98u w=9.6u l=0.13u
X1409 user_project_wrapper_0.analog_io[15] a_237844_29676# user_project_wrapper_0.IOVSS1 user_project_wrapper_0.IOVSS1 sg13_hv_nmos ad=2.596p pd=5.58u as=1.408p ps=5.04u w=4.4u l=0.6u
X1410 user_project_wrapper_0.IOVSS1 user_project_wrapper_0.sg13g2_IOPadIOVdd_1.sg13g2_Clamp_N43N43D4R_0.gate user_project_wrapper_0.IOVDD1 user_project_wrapper_0.IOVSS1 sg13_hv_nmos ad=1.408p pd=5.04u as=2.596p ps=5.58u w=4.4u l=0.6u
X1411 VDD3 a_296625_189595# a_296731_189665# VDD3 sg13_lv_pmos ad=0.2603p pd=1.75u as=0.2603p ps=1.75u w=1.37u l=0.35u
X1412 user_project_wrapper_0.IOVSS1 user_project_wrapper_0.sg13g2_IOPadVdd_1.sg13g2_RCClampResistor_0.p2 user_project_wrapper_0.sg13g2_IOPadVdd_1.sg13g2_RCClampInverter_noptap_0.out user_project_wrapper_0.IOVSS1 sg13_hv_nmos ad=1.71p pd=9.38u as=1.71p ps=9.38u w=9u l=0.5u
X1413 a_88393_125210# a_87627_124843# a_88291_125210# user_project_wrapper_0.IOVSS1 sg13_lv_nmos ad=0.1406p pd=1.12u as=0.1406p ps=1.12u w=0.74u l=0.13u
X1414 user_project_wrapper_0.analog_io[15] a_237844_41476# user_project_wrapper_0.IOVDD2 user_project_wrapper_0.IOVDD2 sg13_hv_pmos ad=3.9294p pd=7.84u as=2.1312p ps=7.3u w=6.66u l=0.6u
X1415 user_project_wrapper_0.VDD2 user_project_wrapper_0.sg13g2_IOPadVdd_1.sg13g2_RCClampInverter_noptap_0.out user_project_wrapper_0.IOVSS1 user_project_wrapper_0.IOVSS1 sg13_hv_nmos ad=2.596p pd=5.58u as=1.408p ps=5.04u w=4.4u l=0.6u
X1416 user_project_wrapper_0.IOVDD1 user_project_wrapper_0.sg13g2_IOPadIOVdd_1.sg13g2_Clamp_N43N43D4R_0.gate user_project_wrapper_0.IOVSS1 user_project_wrapper_0.IOVSS1 sg13_hv_nmos ad=2.596p pd=5.58u as=2.068p ps=9.74u w=4.4u l=0.6u
X1417 a_76015_364458# a_75685_360372# user_project_wrapper_0.IOVSS1 rppd l=20u w=1u
X1418 user_project_wrapper_0.IOVSS1 user_project_wrapper_0.IOVSS1 user_project_wrapper_0.IOVSS1 rppd l=0.5u w=0.5u
X1419 user_project_wrapper_0.IOVSS1 a_213870_324142# user_project_wrapper_0.analog_io[35] user_project_wrapper_0.IOVSS1 sg13_lv_pmos ad=1.824p pd=9.98u as=1.824p ps=9.98u w=9.6u l=0.13u
X1420 user_project_wrapper_0.IOVSS1 user_project_wrapper_0.sg13g2_IOPadIOVdd_0.sg13g2_Clamp_N43N43D4R_0.gate user_project_wrapper_0.IOVDD2 user_project_wrapper_0.IOVSS1 sg13_hv_nmos ad=1.408p pd=5.04u as=2.596p ps=5.58u w=4.4u l=0.6u
X1421 user_project_wrapper_0.analog_io[14] a_190389_99046# user_project_wrapper_0.IOVSS1 user_project_wrapper_0.IOVSS1 sg13_lv_nmos ad=0.1406p pd=1.12u as=0.1406p ps=1.12u w=0.74u l=0.13u
X1422 user_project_wrapper_0.IOVSS1 a_194687_324142# user_project_wrapper_0.analog_io[30] user_project_wrapper_0.IOVSS1 sg13_lv_pmos ad=1.824p pd=9.98u as=1.824p ps=9.98u w=9.6u l=0.13u
X1423 a_190389_99046# a_189729_99046# user_project_wrapper_0.IOVSS1 user_project_wrapper_0.IOVSS1 sg13_lv_nmos ad=0.1406p pd=1.12u as=0.1406p ps=1.12u w=0.74u l=0.13u
X1424 user_project_wrapper_0.analog_io[5] a_41476_217444# user_project_wrapper_0.IOVDD1 user_project_wrapper_0.IOVDD1 sg13_hv_pmos ad=3.9294p pd=7.84u as=2.1312p ps=7.3u w=6.66u l=0.6u
X1425 user_project_wrapper_0.IOVSS1 user_project_wrapper_0.sg13g2_IOPadVdd_3.sg13g2_RCClampInverter_noptap_0.out user_project_wrapper_0.IOVSS1 user_project_wrapper_0.IOVSS1 sg13_hv_nmos ad=1.408p pd=5.04u as=0 ps=0 w=4.4u l=0.6u
X1426 user_project_wrapper_0.analog_io[33] a_237844_355624# user_project_wrapper_0.IOVDD4 user_project_wrapper_0.IOVDD4 sg13_hv_pmos ad=3.9294p pd=7.84u as=3.1302p ps=14.26u w=6.66u l=0.6u
X1427 user_project_wrapper_0.IOVDD2 a_278644_41476# QDLL_TOP_0.VOUT user_project_wrapper_0.IOVDD2 sg13_hv_pmos ad=2.1312p pd=7.3u as=3.9294p ps=7.84u w=6.66u l=0.6u
X1428 user_project_wrapper_0.analog_io[28] a_135844_369296# user_project_wrapper_0.IOVSS1 user_project_wrapper_0.IOVSS1 sg13_hv_nmos ad=2.596p pd=5.58u as=1.408p ps=5.04u w=4.4u l=0.6u
X1429 a_296732_197880# a_296626_197740# VDD3 VDD3 sg13_lv_pmos ad=1.33p pd=7.38u as=1.33p ps=7.38u w=7u l=0.7u
X1430 user_project_wrapper_0.IOVSS1 a_190297_325263# a_190926_325263# user_project_wrapper_0.IOVSS1 sg13_lv_nmos ad=0.34p pd=2.68u as=0.19p ps=1.38u w=1u l=0.13u
X1431 user_project_wrapper_0.IOVSS1 user_project_wrapper_0.IOVSS1 user_project_wrapper_0.IOVSS1 rppd l=0.5u w=0.5u
X1432 user_project_wrapper_0.IOVSS1 user_project_wrapper_0.analog_io[5] dantenna l=27.78u w=1.26u
X1433 a_304889_199957# user_project_wrapper_0.sg13g2_IOPadAnalog_1.padres user_project_wrapper_0.IOVSS1 rppd l=6.73u w=0.6u
X1434 VDD3 a_309516_194555# a_309917_199879# VDD3 sg13_lv_pmos ad=0.19p pd=1.38u as=0.19p ps=1.38u w=1u l=0.7u
X1435 a_296731_208493# a_296625_208423# VDD3 VDD3 sg13_lv_pmos ad=0.2603p pd=1.75u as=0.2603p ps=1.75u w=1.37u l=0.35u
X1436 VDD3 a_296625_208423# a_296731_208493# VDD3 sg13_lv_pmos ad=0.4658p pd=3.42u as=0.2603p ps=1.75u w=1.37u l=0.35u
X1437 user_project_wrapper_0.IOVDD4 user_project_wrapper_0.sg13g2_IOPadIOVdd_2.sg13g2_Clamp_N43N43D4R_0.gate user_project_wrapper_0.IOVSS1 user_project_wrapper_0.IOVSS1 sg13_hv_nmos ad=2.596p pd=5.58u as=1.408p ps=5.04u w=4.4u l=0.6u
X1438 user_project_wrapper_0.IOVDD4 a_217444_355624# user_project_wrapper_0.analog_io[32] user_project_wrapper_0.IOVDD4 sg13_hv_pmos ad=2.1312p pd=7.3u as=3.9294p ps=7.84u w=6.66u l=0.6u
X1439 VDD3 a_296625_189595# a_296731_189665# VDD3 sg13_lv_pmos ad=0.2603p pd=1.75u as=0.2603p ps=1.75u w=1.37u l=0.35u
X1440 user_project_wrapper_0.IOVSS1 user_project_wrapper_0.sg13g2_IOPadVdd_3.sg13g2_RCClampResistor_0.p2 user_project_wrapper_0.sg13g2_IOPadVdd_3.sg13g2_RCClampInverter_noptap_0.out user_project_wrapper_0.IOVSS1 sg13_hv_pmos ad=1.33p pd=7.38u as=1.33p ps=7.38u w=7u l=0.5u
X1441 user_project_wrapper_0.analog_io[35] a_213870_324142# user_project_wrapper_0.IOVSS1 user_project_wrapper_0.IOVSS1 sg13_lv_nmos ad=0.912p pd=5.18u as=0.912p ps=5.18u w=4.8u l=0.13u
X1442 QDLL_TOP_0.CPIN user_project_wrapper_0.analog_io[14] a_190584_97917# user_project_wrapper_0.IOVSS1 sg13_lv_nmos ad=0.1628p pd=1.18u as=88.8f ps=0.98u w=0.74u l=0.13u
X1443 analog_io[25] a_369296_258244# user_project_wrapper_0.IOVSS1 user_project_wrapper_0.IOVSS1 sg13_hv_nmos ad=2.596p pd=5.58u as=1.408p ps=5.04u w=4.4u l=0.6u
X1444 user_project_wrapper_0.IOVSS1 a_369296_197044# analog_io[22] user_project_wrapper_0.IOVSS1 sg13_hv_nmos ad=1.408p pd=5.04u as=2.596p ps=5.58u w=4.4u l=0.6u
X1445 user_project_wrapper_0.IOVDD1 a_41476_197044# user_project_wrapper_0.analog_io[4] user_project_wrapper_0.IOVDD1 sg13_hv_pmos ad=2.1312p pd=7.3u as=3.9294p ps=7.84u w=6.66u l=0.6u
X1446 user_project_wrapper_0.analog_io[7] a_41476_258244# user_project_wrapper_0.IOVDD1 user_project_wrapper_0.IOVDD1 sg13_hv_pmos ad=3.9294p pd=7.84u as=2.1312p ps=7.3u w=6.66u l=0.6u
X1447 a_210007_325263# a_208367_325263# a_209905_325263# user_project_wrapper_0.IOVSS1 sg13_lv_nmos ad=0.19p pd=1.38u as=0.19p ps=1.38u w=1u l=0.13u
X1448 user_project_wrapper_0.IOVSS1 a_202114_326125# user_project_wrapper_0.analog_io[32] user_project_wrapper_0.IOVSS1 sg13_lv_nmos ad=0.912p pd=5.18u as=0.912p ps=5.18u w=4.8u l=0.13u
X1449 user_project_wrapper_0.IOVSS1 user_project_wrapper_0.analog_io[13] dantenna l=1.26u w=27.78u
X1450 VDD3 a_296625_189595# a_296731_189665# VDD3 sg13_lv_pmos ad=0.2603p pd=1.75u as=0.2603p ps=1.75u w=1.37u l=0.35u
X1451 user_project_wrapper_0.IOVDD4 user_project_wrapper_0.sg13g2_IOPadIOVdd_2.sg13g2_Clamp_N43N43D4R_0.gate user_project_wrapper_0.IOVSS1 user_project_wrapper_0.IOVSS1 sg13_hv_nmos ad=2.596p pd=5.58u as=1.408p ps=5.04u w=4.4u l=0.6u
X1452 user_project_wrapper_0.IOVSS1 user_project_wrapper_0.IOVSS1 user_project_wrapper_0.IOVSS1 rppd l=0.5u w=0.5u
X1453 user_project_wrapper_0.IOVDD2 a_217444_41476# user_project_wrapper_0.analog_io[14] user_project_wrapper_0.IOVDD2 sg13_hv_pmos ad=2.1312p pd=7.3u as=3.9294p ps=7.84u w=6.66u l=0.6u
X1454 user_project_wrapper_0.IOVSS1 a_217444_369296# user_project_wrapper_0.analog_io[32] user_project_wrapper_0.IOVSS1 sg13_hv_nmos ad=1.408p pd=5.04u as=2.596p ps=5.58u w=4.4u l=0.6u
X1455 user_project_wrapper_0.IOVSS1 a_213870_324142# user_project_wrapper_0.analog_io[35] user_project_wrapper_0.IOVSS1 sg13_lv_pmos ad=1.824p pd=9.98u as=1.824p ps=9.98u w=9.6u l=0.13u
X1456 user_project_wrapper_0.analog_io[7] user_project_wrapper_0.IOVDD1 dpantenna l=27.78u w=1.26u
X1457 a_209041_329327# a_208939_329719# a_208939_328605# user_project_wrapper_0.IOVSS1 sg13_lv_nmos ad=0.19p pd=1.38u as=0.19p ps=1.38u w=1u l=0.13u
X1458 a_296625_208423# a_304090_197941# a_304196_200821# user_project_wrapper_0.IOVSS1 sg13_lv_nmos ad=0.361p pd=2.28u as=0.361p ps=2.28u w=1.9u l=0.16u
X1459 analog_io[19] a_355624_135844# IOVDD3 IOVDD3 sg13_hv_pmos ad=3.9294p pd=7.84u as=2.1312p ps=7.3u w=6.66u l=0.6u
X1460 VDD3 a_296625_208423# a_296731_208493# VDD3 sg13_lv_pmos ad=0.4658p pd=3.42u as=0.2603p ps=1.75u w=1.37u l=0.35u
X1461 a_313884_211353# a_314793_198352# user_project_wrapper_0.IOVSS1 user_project_wrapper_0.IOVSS1 sg13_lv_nmos ad=1.02p pd=6.68u as=0.57p ps=3.38u w=3u l=1u
X1462 a_190501_326377# a_189184_326377# user_project_wrapper_0.IOVSS1 user_project_wrapper_0.IOVSS1 sg13_lv_nmos ad=0.34p pd=2.68u as=0.34p ps=2.68u w=1u l=0.13u
X1463 user_project_wrapper_0.VDD1 user_project_wrapper_0.sg13g2_IOPadVdd_2.sg13g2_RCClampInverter_noptap_0.out user_project_wrapper_0.IOVSS1 user_project_wrapper_0.IOVSS1 sg13_hv_nmos ad=2.596p pd=5.58u as=1.408p ps=5.04u w=4.4u l=0.6u
X1464 user_project_wrapper_0.IOVSS1 user_project_wrapper_0.sg13g2_IOPadVdd_3.sg13g2_RCClampInverter_noptap_0.out user_project_wrapper_0.IOVSS1 user_project_wrapper_0.IOVSS1 sg13_hv_nmos ad=2.596p pd=5.58u as=0 ps=0 w=4.4u l=0.6u
X1465 analog_io[23] a_355624_237844# IOVDD3 IOVDD3 sg13_hv_pmos ad=3.9294p pd=7.84u as=2.1312p ps=7.3u w=6.66u l=0.6u
X1466 user_project_wrapper_0.sg13g2_IOPadAnalog_3.padres IOVDD3 dpantenna l=4.98u w=0.64u
X1467 a_296731_189665# a_301186_192011# user_project_wrapper_0.IOVSS1 user_project_wrapper_0.IOVSS1 sg13_lv_nmos ad=0.912p pd=5.18u as=0.912p ps=5.18u w=4.8u l=1.06u
X1468 user_project_wrapper_0.IOVSS1 a_258244_369296# user_project_wrapper_0.analog_io[34] user_project_wrapper_0.IOVSS1 sg13_hv_nmos ad=1.408p pd=5.04u as=2.596p ps=5.58u w=4.4u l=0.6u
X1469 user_project_wrapper_0.analog_io[33] a_237844_355624# user_project_wrapper_0.IOVDD4 user_project_wrapper_0.IOVDD4 sg13_hv_pmos ad=3.9294p pd=7.84u as=2.1312p ps=7.3u w=6.66u l=0.6u
X1470 user_project_wrapper_0.IOVDD4 user_project_wrapper_0.sg13g2_IOPadIOVdd_2.sg13g2_RCClampResistor_0.p2 user_project_wrapper_0.sg13g2_IOPadIOVdd_2.sg13g2_Clamp_N43N43D4R_0.gate user_project_wrapper_0.IOVDD4 sg13_hv_pmos ad=1.33p pd=7.38u as=1.33p ps=7.38u w=7u l=0.5u
X1471 user_project_wrapper_0.VDD1 user_project_wrapper_0.sg13g2_IOPadVdd_2.sg13g2_RCClampInverter_noptap_0.out user_project_wrapper_0.IOVSS1 user_project_wrapper_0.IOVSS1 sg13_hv_nmos ad=2.596p pd=5.58u as=2.068p ps=9.74u w=4.4u l=0.6u
X1472 a_304995_198817# a_307232_196607# user_project_wrapper_0.IOVSS1 user_project_wrapper_0.IOVSS1 sg13_lv_nmos ad=0.6327p pd=3.71u as=0.6327p ps=3.71u w=3.33u l=0.2u
X1473 VDD3 user_project_wrapper_0.sg13g2_IOPadVdd_0.sg13g2_RCClampInverter_noptap_0.out user_project_wrapper_0.IOVSS1 user_project_wrapper_0.IOVSS1 sg13_hv_nmos ad=2.596p pd=5.58u as=1.408p ps=5.04u w=4.4u l=0.6u
X1474 user_project_wrapper_0.analog_io[13] a_197044_41476# user_project_wrapper_0.IOVDD2 user_project_wrapper_0.IOVDD2 sg13_hv_pmos ad=3.9294p pd=7.84u as=2.1312p ps=7.3u w=6.66u l=0.6u
X1475 a_190722_329327# a_189756_328605# user_project_wrapper_0.IOVSS1 user_project_wrapper_0.IOVSS1 sg13_lv_nmos ad=0.19p pd=1.38u as=0.34p ps=2.68u w=1u l=0.13u
X1476 user_project_wrapper_0.VDD1 user_project_wrapper_0.sg13g2_IOPadVdd_2.sg13g2_RCClampInverter_noptap_0.out user_project_wrapper_0.IOVSS1 user_project_wrapper_0.IOVSS1 sg13_hv_nmos ad=2.596p pd=5.58u as=1.408p ps=5.04u w=4.4u l=0.6u
X1477 user_project_wrapper_0.analog_io[1] a_41476_135844# user_project_wrapper_0.IOVDD1 user_project_wrapper_0.IOVDD1 sg13_hv_pmos ad=3.9294p pd=7.84u as=2.1312p ps=7.3u w=6.66u l=0.6u
X1478 analog_io[22] IOVDD3 dpantenna l=27.78u w=1.26u
X1479 IOVDD3 user_project_wrapper_0.sg13g2_IOPadIOVdd_3.sg13g2_Clamp_N43N43D4R_0.gate user_project_wrapper_0.IOVSS1 user_project_wrapper_0.IOVSS1 sg13_hv_nmos ad=2.596p pd=5.58u as=1.408p ps=5.04u w=4.4u l=0.6u
X1480 IOVDD3 user_project_wrapper_0.sg13g2_IOPadIOVdd_3.sg13g2_Clamp_N43N43D4R_0.gate user_project_wrapper_0.IOVSS1 user_project_wrapper_0.IOVSS1 sg13_hv_nmos ad=2.596p pd=5.58u as=1.408p ps=5.04u w=4.4u l=0.6u
X1481 user_project_wrapper_0.IOVSS1 a_202114_326125# user_project_wrapper_0.analog_io[32] user_project_wrapper_0.IOVSS1 sg13_lv_pmos ad=1.824p pd=9.98u as=1.824p ps=9.98u w=9.6u l=0.13u
X1482 VDD3 a_309516_194555# a_309917_199879# VDD3 sg13_lv_pmos ad=0.19p pd=1.38u as=0.19p ps=1.38u w=1u l=0.7u
X1483 user_project_wrapper_0.IOVSS1 a_369296_237844# analog_io[23] user_project_wrapper_0.IOVSS1 sg13_hv_nmos ad=1.408p pd=5.04u as=2.596p ps=5.58u w=4.4u l=0.6u
X1484 user_project_wrapper_0.analog_io[16] a_258244_41476# user_project_wrapper_0.IOVDD2 user_project_wrapper_0.IOVDD2 sg13_hv_pmos ad=3.9294p pd=7.84u as=3.1302p ps=14.26u w=6.66u l=0.6u
X1485 a_187852_92557# a_187294_90472# user_project_wrapper_0.IOVSS1 rppd l=10u w=1u
X1486 IOVDD3 a_355624_156244# analog_io[20] IOVDD3 sg13_hv_pmos ad=2.1312p pd=7.3u as=3.9294p ps=7.84u w=6.66u l=0.6u
X1487 VDD3 a_296625_208423# a_296731_208493# VDD3 sg13_lv_pmos ad=0.2603p pd=1.75u as=0.2603p ps=1.75u w=1.37u l=0.35u
X1488 analog_io[23] a_355624_217444# IOVDD3 IOVDD3 sg13_hv_pmos ad=3.9294p pd=7.84u as=2.1312p ps=7.3u w=6.66u l=0.6u
X1489 user_project_wrapper_0.analog_io[14] a_190389_99046# user_project_wrapper_0.IOVSS1 user_project_wrapper_0.IOVSS1 sg13_lv_nmos ad=0.1406p pd=1.12u as=0.1406p ps=1.12u w=0.74u l=0.13u
X1490 analog_io[20] a_369296_156244# user_project_wrapper_0.IOVSS1 user_project_wrapper_0.IOVSS1 sg13_hv_nmos ad=2.596p pd=5.58u as=2.068p ps=9.74u w=4.4u l=0.6u
X1491 user_project_wrapper_0.IOVDD1 user_project_wrapper_0.sg13g2_IOPadIOVdd_1.sg13g2_Clamp_N43N43D4R_0.gate user_project_wrapper_0.IOVSS1 user_project_wrapper_0.IOVSS1 sg13_hv_nmos ad=2.596p pd=5.58u as=1.408p ps=5.04u w=4.4u l=0.6u
X1492 user_project_wrapper_0.analog_io[33] user_project_wrapper_0.IOVDD4 dpantenna l=1.26u w=27.78u
X1493 QDLL_TOP_0.VOUT user_project_wrapper_0.IOVDD2 dpantenna l=1.26u w=27.78u
X1494 user_project_wrapper_0.IOVSS1 a_209480_325263# a_210109_325263# user_project_wrapper_0.IOVSS1 sg13_lv_nmos ad=0.34p pd=2.68u as=0.19p ps=1.38u w=1u l=0.13u
X1495 user_project_wrapper_0.analog_io[27] a_115444_355624# user_project_wrapper_0.IOVDD4 user_project_wrapper_0.IOVDD4 sg13_hv_pmos ad=3.9294p pd=7.84u as=2.1312p ps=7.3u w=6.66u l=0.6u
X1496 a_309917_194695# user_project_wrapper_0.sg13g2_IOPadAnalog_29.padres a_311846_195517# VDD3 sg13_lv_pmos ad=0.24415p pd=1.665u as=0.24415p ps=1.665u w=1.285u l=0.35u
X1497 a_296731_208493# a_296625_208423# VDD3 VDD3 sg13_lv_pmos ad=0.2603p pd=1.75u as=0.2603p ps=1.75u w=1.37u l=0.35u
X1498 a_208367_327491# a_208103_324155# user_project_wrapper_0.IOVSS1 user_project_wrapper_0.IOVSS1 sg13_lv_nmos ad=0.19p pd=1.38u as=0.34p ps=2.68u w=1u l=0.13u
X1499 user_project_wrapper_0.IOVDD2 a_217444_41476# user_project_wrapper_0.analog_io[14] user_project_wrapper_0.IOVDD2 sg13_hv_pmos ad=2.1312p pd=7.3u as=3.9294p ps=7.84u w=6.66u l=0.6u
X1500 IOVDD3 user_project_wrapper_0.sg13g2_IOPadIOVdd_3.sg13g2_Clamp_N43N43D4R_0.gate user_project_wrapper_0.IOVSS1 user_project_wrapper_0.IOVSS1 sg13_hv_nmos ad=2.596p pd=5.58u as=1.408p ps=5.04u w=4.4u l=0.6u
X1501 IOVDD3 user_project_wrapper_0.sg13g2_IOPadIOVdd_3.sg13g2_Clamp_N43N43D4R_0.gate user_project_wrapper_0.IOVSS1 user_project_wrapper_0.IOVSS1 sg13_hv_nmos ad=2.596p pd=5.58u as=1.408p ps=5.04u w=4.4u l=0.6u
X1502 user_project_wrapper_0.IOVSS1 a_194193_328627# a_194279_327536# user_project_wrapper_0.IOVSS1 sg13_lv_pmos ad=1.824p pd=9.98u as=1.824p ps=9.98u w=9.6u l=0.13u
X1503 a_296626_197740# a_301186_192011# user_project_wrapper_0.IOVSS1 user_project_wrapper_0.IOVSS1 sg13_lv_nmos ad=1.632p pd=10.28u as=0.912p ps=5.18u w=4.8u l=1.06u
X1504 user_project_wrapper_0.analog_io[11] a_156244_41476# user_project_wrapper_0.IOVDD2 user_project_wrapper_0.IOVDD2 sg13_hv_pmos ad=3.9294p pd=7.84u as=2.1312p ps=7.3u w=6.66u l=0.6u
X1505 a_191438_328605# a_191234_328605# user_project_wrapper_0.IOVSS1 w_188704_327938# sg13_lv_pmos ad=0.68p pd=4.68u as=0.38p ps=2.38u w=2u l=0.13u
X1506 user_project_wrapper_0.IOVSS1 user_project_wrapper_0.sg13g2_IOPadVdd_2.sg13g2_RCClampInverter_noptap_0.out user_project_wrapper_0.VDD1 user_project_wrapper_0.IOVSS1 sg13_hv_nmos ad=1.408p pd=5.04u as=2.596p ps=5.58u w=4.4u l=0.6u
X1507 user_project_wrapper_0.IOVSS1 user_project_wrapper_0.sg13g2_IOPadVdd_1.sg13g2_RCClampResistor_0.p2 user_project_wrapper_0.sg13g2_IOPadVdd_1.sg13g2_RCClampInverter_noptap_0.out user_project_wrapper_0.IOVSS1 sg13_hv_nmos ad=1.71p pd=9.38u as=1.71p ps=9.38u w=9u l=0.5u
X1508 a_311189_211724# a_296731_208493# a_313884_211353# user_project_wrapper_0.IOVSS1 sg13_lv_nmos ad=1.9p pd=10.38u as=1.9p ps=10.38u w=10u l=0.5u
X1509 a_360372_304705# a_364458_305035# user_project_wrapper_0.IOVSS1 rppd l=20u w=1u
X1510 user_project_wrapper_0.IOVDD4 a_258244_355624# user_project_wrapper_0.analog_io[34] user_project_wrapper_0.IOVDD4 sg13_hv_pmos ad=2.1312p pd=7.3u as=3.9294p ps=7.84u w=6.66u l=0.6u
X1511 user_project_wrapper_0.IOVSS1 a_202114_326125# user_project_wrapper_0.analog_io[32] user_project_wrapper_0.IOVSS1 sg13_lv_pmos ad=1.824p pd=9.98u as=1.824p ps=9.98u w=9.6u l=0.13u
X1512 a_268967_100118# a_268697_100118# QDLL_TOP_0.VDD QDLL_TOP_0.VDD sg13_lv_pmos ad=0.34p pd=2.68u as=0.1523p ps=1.38u w=1u l=0.5u
X1513 user_project_wrapper_0.IOVDD1 user_project_wrapper_0.sg13g2_IOPadIOVdd_1.sg13g2_Clamp_N43N43D4R_0.gate user_project_wrapper_0.IOVSS1 user_project_wrapper_0.IOVSS1 sg13_hv_nmos ad=2.596p pd=5.58u as=1.408p ps=5.04u w=4.4u l=0.6u
X1514 IOVDD3 a_355624_237844# analog_io[23] IOVDD3 sg13_hv_pmos ad=2.1312p pd=7.3u as=3.9294p ps=7.84u w=6.66u l=0.6u
X1515 user_project_wrapper_0.IOVSS1 a_194687_324142# user_project_wrapper_0.analog_io[30] user_project_wrapper_0.IOVSS1 sg13_lv_pmos ad=1.824p pd=9.98u as=1.824p ps=9.98u w=9.6u l=0.13u
X1516 a_213870_324142# a_213462_327536# user_project_wrapper_0.IOVSS1 user_project_wrapper_0.IOVSS1 sg13_lv_nmos ad=0.912p pd=5.18u as=0.912p ps=5.18u w=4.8u l=0.13u
X1517 user_project_wrapper_0.IOVDD4 user_project_wrapper_0.sg13g2_IOPadIOVdd_2.sg13g2_Clamp_N43N43D4R_0.gate user_project_wrapper_0.IOVSS1 user_project_wrapper_0.IOVSS1 sg13_hv_nmos ad=2.596p pd=5.58u as=1.408p ps=5.04u w=4.4u l=0.6u
X1518 user_project_wrapper_0.IOVDD2 a_258244_41476# user_project_wrapper_0.analog_io[16] user_project_wrapper_0.IOVDD2 sg13_hv_pmos ad=3.1302p pd=14.26u as=3.9294p ps=7.84u w=6.66u l=0.6u
X1519 user_project_wrapper_0.IOVSS1 a_29676_115444# user_project_wrapper_0.analog_io[0] user_project_wrapper_0.IOVSS1 sg13_hv_nmos ad=1.408p pd=5.04u as=2.596p ps=5.58u w=4.4u l=0.6u
X1520 a_213870_324142# a_213462_327536# user_project_wrapper_0.IOVSS1 user_project_wrapper_0.IOVSS1 sg13_lv_nmos ad=0.912p pd=5.18u as=0.912p ps=5.18u w=4.8u l=0.13u
X1521 user_project_wrapper_0.IOVSS1 user_project_wrapper_0.sg13g2_IOPadVdd_2.sg13g2_RCClampInverter_noptap_0.out user_project_wrapper_0.VDD1 user_project_wrapper_0.IOVSS1 sg13_hv_nmos ad=1.408p pd=5.04u as=2.596p ps=5.58u w=4.4u l=0.6u
X1522 user_project_wrapper_0.IOVSS1 user_project_wrapper_0.sg13g2_IOPadVdd_3.sg13g2_RCClampInverter_noptap_0.out user_project_wrapper_0.IOVSS1 user_project_wrapper_0.IOVSS1 sg13_hv_nmos ad=2.596p pd=5.58u as=0 ps=0 w=4.4u l=0.6u
X1523 user_project_wrapper_0.analog_io[29] a_156244_355624# user_project_wrapper_0.IOVDD4 user_project_wrapper_0.IOVDD4 sg13_hv_pmos ad=3.9294p pd=7.84u as=2.1312p ps=7.3u w=6.66u l=0.6u
X1524 analog_io[20] a_355624_156244# IOVDD3 IOVDD3 sg13_hv_pmos ad=3.9294p pd=7.84u as=2.1312p ps=7.3u w=6.66u l=0.6u
X1525 user_project_wrapper_0.analog_io[33] a_237844_369296# user_project_wrapper_0.IOVSS1 user_project_wrapper_0.IOVSS1 sg13_hv_nmos ad=2.596p pd=5.58u as=1.408p ps=5.04u w=4.4u l=0.6u
X1526 a_355624_135844# IOVDD3 IOVDD3 rppd l=12.9u w=0.5u
X1527 user_project_wrapper_0.IOVDD2 a_217444_41476# user_project_wrapper_0.analog_io[14] user_project_wrapper_0.IOVDD2 sg13_hv_pmos ad=2.1312p pd=7.3u as=3.9294p ps=7.84u w=6.66u l=0.6u
X1528 a_120445_39542# a_120775_35456# user_project_wrapper_0.IOVSS1 rppd l=20u w=1u
X1529 user_project_wrapper_0.IOVSS1 a_205385_326221# a_202114_326125# user_project_wrapper_0.IOVSS1 sg13_lv_pmos ad=1.824p pd=9.98u as=1.824p ps=9.98u w=9.6u l=0.13u
X1530 user_project_wrapper_0.analog_io[30] a_194687_324142# user_project_wrapper_0.IOVSS1 user_project_wrapper_0.IOVSS1 sg13_lv_nmos ad=0.912p pd=5.18u as=0.912p ps=5.18u w=4.8u l=0.13u
X1531 user_project_wrapper_0.IOVSS1 user_project_wrapper_0.sg13g2_IOPadIn$1_1.sg13g2_LevelDown_noptap$1_0.sg13g2_SecondaryProtection$1$1_0.core dantenna l=3.1u w=0.64u
X1532 a_296625_189595# a_304090_197941# a_304196_197873# user_project_wrapper_0.IOVSS1 sg13_lv_nmos ad=0.361p pd=2.28u as=0.361p ps=2.28u w=1.9u l=0.16u
X1533 a_309516_194555# a_309516_194555# VDD3 VDD3 sg13_lv_pmos ad=0.19p pd=1.38u as=0.19p ps=1.38u w=1u l=0.7u
X1534 a_296731_208493# a_301186_192011# user_project_wrapper_0.IOVSS1 user_project_wrapper_0.IOVSS1 sg13_lv_nmos ad=0.912p pd=5.18u as=0.912p ps=5.18u w=4.8u l=1.06u
X1535 a_296731_189665# a_296625_189595# VDD3 VDD3 sg13_lv_pmos ad=0.2603p pd=1.75u as=0.2603p ps=1.75u w=1.37u l=0.35u
X1536 a_296625_208423# a_304090_197941# a_304196_200821# user_project_wrapper_0.IOVSS1 sg13_lv_nmos ad=0.361p pd=2.28u as=0.361p ps=2.28u w=1.9u l=0.16u
X1537 analog_io[20] IOVDD3 dpantenna l=27.78u w=1.26u
X1538 analog_io[25] a_355624_258244# IOVDD3 IOVDD3 sg13_hv_pmos ad=3.9294p pd=7.84u as=3.1302p ps=14.26u w=6.66u l=0.6u
X1539 IOVDD3 user_project_wrapper_0.sg13g2_IOPadIOVdd_3.sg13g2_Clamp_N43N43D4R_0.gate user_project_wrapper_0.IOVSS1 user_project_wrapper_0.IOVSS1 sg13_hv_nmos ad=2.596p pd=5.58u as=1.408p ps=5.04u w=4.4u l=0.6u
X1540 user_project_wrapper_0.IOVSS1 user_project_wrapper_0.sg13g2_IOPadVdd_2.sg13g2_RCClampResistor_0.p2 user_project_wrapper_0.sg13g2_IOPadVdd_2.sg13g2_RCClampInverter_noptap_0.out user_project_wrapper_0.IOVSS1 sg13_hv_nmos ad=1.71p pd=9.38u as=1.71p ps=9.38u w=9u l=0.5u
X1541 a_120445_39542# a_120115_35456# user_project_wrapper_0.IOVSS1 rppd l=20u w=1u
X1542 user_project_wrapper_0.IOVSS1 a_369296_156244# analog_io[20] user_project_wrapper_0.IOVSS1 sg13_hv_nmos ad=1.408p pd=5.04u as=2.596p ps=5.58u w=4.4u l=0.6u
X1543 user_project_wrapper_0.IOVDD4 user_project_wrapper_0.sg13g2_IOPadIOVdd_2.sg13g2_RCClampResistor_0.p2 user_project_wrapper_0.sg13g2_IOPadIOVdd_2.sg13g2_Clamp_N43N43D4R_0.gate user_project_wrapper_0.IOVDD4 sg13_hv_pmos ad=1.33p pd=7.38u as=1.33p ps=7.38u w=7u l=0.5u
X1544 a_87105_130835# a_86507_129255# a_87105_130470# user_project_wrapper_0.IOVSS1 sg13_lv_nmos ad=0.2516p pd=2.16u as=0.1406p ps=1.12u w=0.74u l=0.13u
X1545 a_313884_185173# analog_io[20] a_311108_179669# user_project_wrapper_0.IOVSS1 sg13_lv_nmos ad=1.9p pd=10.38u as=1.9p ps=10.38u w=10u l=0.5u
X1546 user_project_wrapper_0.VDD2 user_project_wrapper_0.sg13g2_IOPadVdd_1.sg13g2_RCClampResistor_0.p2 user_project_wrapper_0.sg13g2_IOPadVdd_1.sg13g2_RCClampInverter_noptap_0.out user_project_wrapper_0.VDD2 sg13_hv_pmos ad=1.33p pd=7.38u as=1.33p ps=7.38u w=7u l=0.5u
X1547 user_project_wrapper_0.VDD1 a_78824_133051# a_78824_133051# user_project_wrapper_0.VDD1 sg13_lv_pmos ad=1.7p pd=10.68u as=0.95p ps=5.38u w=5u l=0.15u
X1548 user_project_wrapper_0.IOVSS1 a_208017_327918# a_208469_326377# w_207887_326203# sg13_lv_pmos ad=0.68p pd=4.68u as=0.38p ps=2.38u w=2u l=0.13u
X1549 user_project_wrapper_0.IOVSS1 user_project_wrapper_0.sg13g2_IOPadVdd_2.sg13g2_RCClampInverter_noptap_0.out user_project_wrapper_0.VDD1 user_project_wrapper_0.IOVSS1 sg13_hv_nmos ad=1.408p pd=5.04u as=2.596p ps=5.58u w=4.4u l=0.6u
X1550 user_project_wrapper_0.analog_io[6] a_41476_237844# user_project_wrapper_0.IOVDD1 user_project_wrapper_0.IOVDD1 sg13_hv_pmos ad=3.9294p pd=7.84u as=3.1302p ps=14.26u w=6.66u l=0.6u
X1551 user_project_wrapper_0.analog_io[35] a_213870_324142# user_project_wrapper_0.IOVSS1 user_project_wrapper_0.IOVSS1 sg13_lv_nmos ad=0.912p pd=5.18u as=0.912p ps=5.18u w=4.8u l=0.13u
X1552 a_119785_39542# a_120115_35456# user_project_wrapper_0.IOVSS1 rppd l=20u w=1u
X1553 user_project_wrapper_0.IOVSS1 a_182931_326125# user_project_wrapper_0.analog_io[27] user_project_wrapper_0.IOVSS1 sg13_lv_nmos ad=0.912p pd=5.18u as=0.912p ps=5.18u w=4.8u l=0.13u
X1554 a_298765_39542# a_299095_35456# user_project_wrapper_0.IOVSS1 rppd l=20u w=1u
X1555 a_87851_125174# a_87673_125210# user_project_wrapper_0.IOVSS1 user_project_wrapper_0.IOVSS1 sg13_lv_nmos ad=0.1406p pd=1.12u as=0.2516p ps=2.16u w=0.74u l=0.13u
X1556 IOVDD3 a_355624_176644# analog_io[20] IOVDD3 sg13_hv_pmos ad=2.1312p pd=7.3u as=3.9294p ps=7.84u w=6.66u l=0.6u
X1557 a_309917_199879# user_project_wrapper_0.sg13g2_IOPadAnalog_29.padres a_311846_195517# VDD3 sg13_lv_pmos ad=0.24415p pd=1.665u as=0.24415p ps=1.665u w=1.285u l=0.35u
X1558 user_project_wrapper_0.IOVSS1 user_project_wrapper_0.sg13g2_IOPadVdd_1.sg13g2_RCClampInverter_noptap_0.out user_project_wrapper_0.VDD2 user_project_wrapper_0.IOVSS1 sg13_hv_nmos ad=1.408p pd=5.04u as=2.596p ps=5.58u w=4.4u l=0.6u
X1559 user_project_wrapper_0.IOVSS1 analog_io[23] dantenna l=27.78u w=1.26u
X1560 user_project_wrapper_0.analog_io[13] a_197044_41476# user_project_wrapper_0.IOVDD2 user_project_wrapper_0.IOVDD2 sg13_hv_pmos ad=3.9294p pd=7.84u as=2.1312p ps=7.3u w=6.66u l=0.6u
X1561 a_82846_243261# a_82645_242401# user_project_wrapper_0.VDD1 user_project_wrapper_0.VDD1 sg13_lv_pmos ad=1.7p pd=10.68u as=1.7p ps=10.68u w=5u l=0.15u
X1562 user_project_wrapper_0.IOVSS1 a_194687_324142# user_project_wrapper_0.analog_io[30] user_project_wrapper_0.IOVSS1 sg13_lv_pmos ad=1.824p pd=9.98u as=1.824p ps=9.98u w=9.6u l=0.13u
X1563 VDD3 a_296625_189595# a_296731_189665# VDD3 sg13_lv_pmos ad=0.4658p pd=3.42u as=0.2603p ps=1.75u w=1.37u l=0.35u
X1564 user_project_wrapper_0.IOVDD1 a_41476_217444# user_project_wrapper_0.analog_io[5] user_project_wrapper_0.IOVDD1 sg13_hv_pmos ad=2.1312p pd=7.3u as=3.9294p ps=7.84u w=6.66u l=0.6u
X1565 user_project_wrapper_0.VDD1 a_77638_59490# user_project_wrapper_0.sg13g2_IOPadIn$1_1.p2c user_project_wrapper_0.VDD1 sg13_lv_pmos ad=1.615p pd=10.18u as=1.615p ps=10.18u w=4.75u l=0.13u
X1566 user_project_wrapper_0.VDD2 user_project_wrapper_0.sg13g2_IOPadVdd_1.sg13g2_RCClampResistor_0.p2 user_project_wrapper_0.sg13g2_IOPadVdd_1.sg13g2_RCClampInverter_noptap_0.out user_project_wrapper_0.VDD2 sg13_hv_pmos ad=1.33p pd=7.38u as=1.33p ps=7.38u w=7u l=0.5u
X1567 QDLL_TOP_0.VOUT a_278644_29676# user_project_wrapper_0.IOVSS1 user_project_wrapper_0.IOVSS1 sg13_hv_nmos ad=2.596p pd=5.58u as=1.408p ps=5.04u w=4.4u l=0.6u
X1568 user_project_wrapper_0.analog_io[30] user_project_wrapper_0.IOVDD4 dpantenna l=1.26u w=27.78u
X1569 IOVDD3 a_355624_156244# analog_io[20] IOVDD3 sg13_hv_pmos ad=3.1302p pd=14.26u as=3.9294p ps=7.84u w=6.66u l=0.6u
X1570 IOVDD3 user_project_wrapper_0.sg13g2_IOPadIOVdd_3.sg13g2_RCClampResistor_0.p2 user_project_wrapper_0.sg13g2_IOPadIOVdd_3.sg13g2_Clamp_N43N43D4R_0.gate IOVDD3 sg13_hv_pmos ad=1.33p pd=7.38u as=1.33p ps=7.38u w=7u l=0.5u
X1571 user_project_wrapper_0.sg13g2_IOPadIOVdd_0.sg13g2_Clamp_N43N43D4R_0.gate user_project_wrapper_0.sg13g2_IOPadIOVdd_0.sg13g2_RCClampResistor_0.p2 user_project_wrapper_0.IOVDD2 user_project_wrapper_0.IOVDD2 sg13_hv_pmos ad=1.33p pd=7.38u as=1.33p ps=7.38u w=7u l=0.5u
X1572 user_project_wrapper_0.analog_io[15] a_237844_29676# user_project_wrapper_0.IOVSS1 user_project_wrapper_0.IOVSS1 sg13_hv_nmos ad=2.596p pd=5.58u as=1.408p ps=5.04u w=4.4u l=0.6u
X1573 a_304196_200821# a_304889_199957# a_304995_198817# user_project_wrapper_0.IOVSS1 sg13_lv_nmos ad=0.209p pd=1.48u as=0.374p ps=2.88u w=1.1u l=0.15u
X1574 a_210621_328605# a_210417_328605# user_project_wrapper_0.IOVSS1 w_207887_327938# sg13_lv_pmos ad=0.68p pd=4.68u as=0.38p ps=2.38u w=2u l=0.13u
X1575 user_project_wrapper_0.IOVSS1 a_189729_101343# a_190389_101343# user_project_wrapper_0.IOVSS1 sg13_lv_nmos ad=0.1406p pd=1.12u as=0.1406p ps=1.12u w=0.74u l=0.13u
X1576 user_project_wrapper_0.analog_io[35] a_278644_355624# user_project_wrapper_0.IOVDD4 user_project_wrapper_0.IOVDD4 sg13_hv_pmos ad=3.9294p pd=7.84u as=2.1312p ps=7.3u w=6.66u l=0.6u
X1577 user_project_wrapper_0.sg13g2_IOPadAnalog_5.padres user_project_wrapper_0.analog_io[15] user_project_wrapper_0.IOVSS1 rppd l=2u w=1u
X1578 user_project_wrapper_0.IOVDD2 a_217444_41476# user_project_wrapper_0.analog_io[14] user_project_wrapper_0.IOVDD2 sg13_hv_pmos ad=2.1312p pd=7.3u as=3.9294p ps=7.84u w=6.66u l=0.6u
X1579 user_project_wrapper_0.IOVDD4 user_project_wrapper_0.sg13g2_IOPadIOVdd_2.sg13g2_Clamp_N43N43D4R_0.gate user_project_wrapper_0.IOVSS1 user_project_wrapper_0.IOVSS1 sg13_hv_nmos ad=2.596p pd=5.58u as=1.408p ps=5.04u w=4.4u l=0.6u
X1580 a_296731_208493# a_296625_208423# VDD3 VDD3 sg13_lv_pmos ad=0.2603p pd=1.75u as=0.2603p ps=1.75u w=1.37u l=0.35u
X1581 a_296732_200582# a_301940_196388# a_296625_208423# VDD3 sg13_lv_pmos ad=1.377p pd=8.78u as=0.7695p ps=4.43u w=4.05u l=0.5u
X1582 IOVDD3 a_355624_258244# analog_io[25] IOVDD3 sg13_hv_pmos ad=2.1312p pd=7.3u as=3.9294p ps=7.84u w=6.66u l=0.6u
X1583 a_191438_327491# TOP_ROILIFNEURON_0.MEM user_project_wrapper_0.IOVSS1 rppd l=0.5u w=0.5u
X1584 VDD3 user_project_wrapper_0.sg13g2_IOPadVdd_0.sg13g2_RCClampInverter_noptap_0.out user_project_wrapper_0.IOVSS1 user_project_wrapper_0.IOVSS1 sg13_hv_nmos ad=2.596p pd=5.58u as=1.408p ps=5.04u w=4.4u l=0.6u
X1585 user_project_wrapper_0.VDD1 user_project_wrapper_0.sg13g2_IOPadVdd_2.sg13g2_RCClampInverter_noptap_0.out user_project_wrapper_0.IOVSS1 user_project_wrapper_0.IOVSS1 sg13_hv_nmos ad=2.596p pd=5.58u as=1.408p ps=5.04u w=4.4u l=0.6u
X1586 a_307232_196607# a_296731_208493# a_309917_199879# VDD3 sg13_lv_pmos ad=0.24415p pd=1.665u as=0.24415p ps=1.665u w=1.285u l=0.35u
X1587 a_296731_208493# a_296625_208423# VDD3 VDD3 sg13_lv_pmos ad=0.2603p pd=1.75u as=0.4658p ps=3.42u w=1.37u l=0.35u
X1588 user_project_wrapper_0.IOVDD2 a_278644_41476# QDLL_TOP_0.VOUT user_project_wrapper_0.IOVDD2 sg13_hv_pmos ad=2.1312p pd=7.3u as=3.9294p ps=7.84u w=6.66u l=0.6u
X1589 analog_io[20] a_355624_176644# IOVDD3 IOVDD3 sg13_hv_pmos ad=3.9294p pd=7.84u as=2.1312p ps=7.3u w=6.66u l=0.6u
X1590 a_307232_196607# a_296731_189665# a_309917_194695# VDD3 sg13_lv_pmos ad=0.24415p pd=1.665u as=0.24415p ps=1.665u w=1.285u l=0.35u
X1591 user_project_wrapper_0.IOVSS1 a_213870_324142# user_project_wrapper_0.analog_io[35] user_project_wrapper_0.IOVSS1 sg13_lv_pmos ad=1.824p pd=9.98u as=1.824p ps=9.98u w=9.6u l=0.13u
X1592 a_309917_199879# a_309516_194555# VDD3 VDD3 sg13_lv_pmos ad=0.19p pd=1.38u as=0.19p ps=1.38u w=1u l=0.7u
X1593 VDD3 user_project_wrapper_0.sg13g2_IOPadVdd_0.sg13g2_RCClampInverter_noptap_0.out user_project_wrapper_0.IOVSS1 user_project_wrapper_0.IOVSS1 sg13_hv_nmos ad=2.596p pd=5.58u as=1.408p ps=5.04u w=4.4u l=0.6u
X1594 user_project_wrapper_0.IOVDD4 user_project_wrapper_0.sg13g2_IOPadIOVdd_2.sg13g2_Clamp_N43N43D4R_0.gate user_project_wrapper_0.IOVSS1 user_project_wrapper_0.IOVSS1 sg13_hv_nmos ad=2.596p pd=5.58u as=1.408p ps=5.04u w=4.4u l=0.6u
X1595 user_project_wrapper_0.IOVSS1 user_project_wrapper_0.IOVSS1 user_project_wrapper_0.IOVSS1 rppd l=0.5u w=0.5u
X1596 user_project_wrapper_0.IOVSS1 a_369296_217444# analog_io[23] user_project_wrapper_0.IOVSS1 sg13_hv_nmos ad=1.408p pd=5.04u as=2.596p ps=5.58u w=4.4u l=0.6u
X1597 a_190297_326377# a_189756_326377# user_project_wrapper_0.IOVSS1 user_project_wrapper_0.IOVSS1 sg13_lv_nmos ad=0.34p pd=2.68u as=0.34p ps=2.68u w=1u l=0.13u
X1598 user_project_wrapper_0.IOVSS1 a_301186_192011# a_296731_189665# user_project_wrapper_0.IOVSS1 sg13_lv_nmos ad=0.912p pd=5.18u as=0.912p ps=5.18u w=4.8u l=1.06u
X1599 user_project_wrapper_0.IOVDD1 a_41476_237844# user_project_wrapper_0.analog_io[6] user_project_wrapper_0.IOVDD1 sg13_hv_pmos ad=2.1312p pd=7.3u as=3.9294p ps=7.84u w=6.66u l=0.6u
X1600 VDD3 a_309516_194555# a_309917_199879# VDD3 sg13_lv_pmos ad=0.19p pd=1.38u as=0.19p ps=1.38u w=1u l=0.7u
X1601 IOVDD3 user_project_wrapper_0.sg13g2_IOPadIOVdd_3.sg13g2_RCClampResistor_0.p2 user_project_wrapper_0.sg13g2_IOPadIOVdd_3.sg13g2_Clamp_N43N43D4R_0.gate IOVDD3 sg13_hv_pmos ad=1.33p pd=7.38u as=1.33p ps=7.38u w=7u l=0.5u
X1602 user_project_wrapper_0.IOVDD4 a_176644_355624# user_project_wrapper_0.analog_io[30] user_project_wrapper_0.IOVDD4 sg13_hv_pmos ad=3.1302p pd=14.26u as=3.9294p ps=7.84u w=6.66u l=0.6u
X1603 VDD3 a_296625_189595# a_296731_189665# VDD3 sg13_lv_pmos ad=0.2603p pd=1.75u as=0.2603p ps=1.75u w=1.37u l=0.35u
X1604 user_project_wrapper_0.IOVSS1 a_209638_324119# a_209230_324119# user_project_wrapper_0.IOVSS1 sg13_lv_nmos ad=0.34p pd=2.68u as=0.34p ps=2.68u w=1u l=0.13u
X1605 a_208939_327491# user_project_wrapper_0.IOVSS1 user_project_wrapper_0.IOVSS1 w_207887_327938# sg13_lv_pmos ad=0.38p pd=2.38u as=0.68p ps=4.68u w=2u l=0.13u
X1606 user_project_wrapper_0.IOVDD2 user_project_wrapper_0.sg13g2_IOPadIOVdd_0.sg13g2_Clamp_N43N43D4R_0.gate user_project_wrapper_0.IOVSS1 user_project_wrapper_0.IOVSS1 sg13_hv_nmos ad=2.596p pd=5.58u as=1.408p ps=5.04u w=4.4u l=0.6u
X1607 QDLL_TOP_0.VDD a_189729_99046# a_190389_99046# QDLL_TOP_0.VDD sg13_lv_pmos ad=0.2128p pd=1.5u as=0.2128p ps=1.5u w=1.12u l=0.13u
X1608 VDD3 a_296625_189595# a_296731_189665# VDD3 sg13_lv_pmos ad=0.2603p pd=1.75u as=0.2603p ps=1.75u w=1.37u l=0.35u
X1609 user_project_wrapper_0.analog_io[29] a_156244_369296# user_project_wrapper_0.IOVSS1 user_project_wrapper_0.IOVSS1 sg13_hv_nmos ad=2.596p pd=5.58u as=1.408p ps=5.04u w=4.4u l=0.6u
X1610 user_project_wrapper_0.IOVDD1 user_project_wrapper_0.sg13g2_IOPadIOVdd_1.sg13g2_Clamp_N43N43D4R_0.gate user_project_wrapper_0.IOVSS1 user_project_wrapper_0.IOVSS1 sg13_hv_nmos ad=2.596p pd=5.58u as=1.408p ps=5.04u w=4.4u l=0.6u
X1611 VDD3 a_296625_208423# a_296731_208493# VDD3 sg13_lv_pmos ad=0.2603p pd=1.75u as=0.2603p ps=1.75u w=1.37u l=0.35u
X1612 user_project_wrapper_0.analog_io[4] a_41476_197044# user_project_wrapper_0.IOVDD1 user_project_wrapper_0.IOVDD1 sg13_hv_pmos ad=3.9294p pd=7.84u as=2.1312p ps=7.3u w=6.66u l=0.6u
X1613 user_project_wrapper_0.analog_io[16] a_258244_41476# user_project_wrapper_0.IOVDD2 user_project_wrapper_0.IOVDD2 sg13_hv_pmos ad=3.9294p pd=7.84u as=2.1312p ps=7.3u w=6.66u l=0.6u
X1614 user_project_wrapper_0.IOVDD1 a_41476_135844# user_project_wrapper_0.analog_io[1] user_project_wrapper_0.IOVDD1 sg13_hv_pmos ad=2.1312p pd=7.3u as=3.9294p ps=7.84u w=6.66u l=0.6u
X1615 user_project_wrapper_0.IOVSS1 user_project_wrapper_0.sg13g2_IOPadAnalog_21.padres a_209041_327099# user_project_wrapper_0.IOVSS1 sg13_lv_nmos ad=0.34p pd=2.68u as=0.19p ps=1.38u w=1u l=0.13u
X1616 user_project_wrapper_0.IOVSS1 a_190389_101343# user_project_wrapper_0.analog_io[15] user_project_wrapper_0.IOVSS1 sg13_lv_nmos ad=0.1406p pd=1.12u as=0.1406p ps=1.12u w=0.74u l=0.13u
X1617 a_188920_324155# a_188988_324119# user_project_wrapper_0.IOVSS1 w_188806_323975# sg13_lv_pmos ad=0.38p pd=2.38u as=0.38p ps=2.38u w=2u l=0.13u
X1618 analog_io[25] a_355624_258244# IOVDD3 IOVDD3 sg13_hv_pmos ad=3.9294p pd=7.84u as=2.1312p ps=7.3u w=6.66u l=0.6u
X1619 IOVDD3 a_355624_197044# analog_io[22] IOVDD3 sg13_hv_pmos ad=2.1312p pd=7.3u as=3.9294p ps=7.84u w=6.66u l=0.6u
X1620 VDD3 a_309516_194555# a_309917_194695# VDD3 sg13_lv_pmos ad=0.19p pd=1.38u as=0.19p ps=1.38u w=1u l=0.7u
X1621 user_project_wrapper_0.IOVSS1 a_191234_327491# a_191438_327491# user_project_wrapper_0.IOVSS1 sg13_lv_nmos ad=0.19p pd=1.38u as=0.19p ps=1.38u w=1u l=0.13u
X1622 IOVDD3 user_project_wrapper_0.sg13g2_IOPadIOVdd_3.sg13g2_Clamp_N43N43D4R_0.gate user_project_wrapper_0.IOVSS1 user_project_wrapper_0.IOVSS1 sg13_hv_nmos ad=2.596p pd=5.58u as=1.408p ps=5.04u w=4.4u l=0.6u
X1623 user_project_wrapper_0.IOVSS1 a_205385_326221# a_202114_326125# user_project_wrapper_0.IOVSS1 sg13_lv_nmos ad=0.912p pd=5.18u as=0.912p ps=5.18u w=4.8u l=0.13u
X1624 a_307232_196607# a_296731_189665# a_309917_194695# VDD3 sg13_lv_pmos ad=0.24415p pd=1.665u as=0.24415p ps=1.665u w=1.285u l=0.35u
X1625 IOVDD3 a_355624_217444# analog_io[23] IOVDD3 sg13_hv_pmos ad=2.1312p pd=7.3u as=3.9294p ps=7.84u w=6.66u l=0.6u
X1626 user_project_wrapper_0.analog_io[33] a_237844_355624# user_project_wrapper_0.IOVDD4 user_project_wrapper_0.IOVDD4 sg13_hv_pmos ad=3.9294p pd=7.84u as=2.1312p ps=7.3u w=6.66u l=0.6u
X1627 user_project_wrapper_0.IOVSS1 user_project_wrapper_0.sg13g2_IOPadIOVdd_2.sg13g2_Clamp_N43N43D4R_0.gate user_project_wrapper_0.IOVDD4 user_project_wrapper_0.IOVSS1 sg13_hv_nmos ad=1.408p pd=5.04u as=2.596p ps=5.58u w=4.4u l=0.6u
X1628 user_project_wrapper_0.analog_io[15] a_237844_41476# user_project_wrapper_0.IOVDD2 user_project_wrapper_0.IOVDD2 sg13_hv_pmos ad=3.9294p pd=7.84u as=2.1312p ps=7.3u w=6.66u l=0.6u
X1629 a_75355_364458# a_75685_360372# user_project_wrapper_0.IOVSS1 rppd l=20u w=1u
X1630 user_project_wrapper_0.IOVSS1 user_project_wrapper_0.IOVSS1 user_project_wrapper_0.IOVSS1 rppd l=0.5u w=0.5u
X1631 user_project_wrapper_0.analog_io[13] a_197044_29676# user_project_wrapper_0.IOVSS1 user_project_wrapper_0.IOVSS1 sg13_hv_nmos ad=2.596p pd=5.58u as=1.408p ps=5.04u w=4.4u l=0.6u
X1632 user_project_wrapper_0.IOVDD4 a_156244_355624# user_project_wrapper_0.analog_io[29] user_project_wrapper_0.IOVDD4 sg13_hv_pmos ad=2.1312p pd=7.3u as=3.9294p ps=7.84u w=6.66u l=0.6u
X1633 IOVDD3 a_355624_176644# analog_io[20] IOVDD3 sg13_hv_pmos ad=2.1312p pd=7.3u as=3.9294p ps=7.84u w=6.66u l=0.6u
X1634 analog_io[20] a_311108_179669# VDD3 user_project_wrapper_0.IOVSS1 sg13_lv_nmos ad=3.4p pd=20.68u as=3.4p ps=20.68u w=10u l=0.15u
X1635 user_project_wrapper_0.IOVSS1 a_237844_369296# user_project_wrapper_0.analog_io[33] user_project_wrapper_0.IOVSS1 sg13_hv_nmos ad=1.408p pd=5.04u as=2.596p ps=5.58u w=4.4u l=0.6u
X1636 user_project_wrapper_0.IOVDD4 a_217444_355624# user_project_wrapper_0.analog_io[32] user_project_wrapper_0.IOVDD4 sg13_hv_pmos ad=2.1312p pd=7.3u as=3.9294p ps=7.84u w=6.66u l=0.6u
X1637 user_project_wrapper_0.IOVSS1 user_project_wrapper_0.sg13g2_IOPadAnalog_21.padres dantenna l=3.1u w=0.64u
X1638 user_project_wrapper_0.IOVDD1 user_project_wrapper_0.sg13g2_IOPadIOVdd_1.sg13g2_Clamp_N43N43D4R_0.gate user_project_wrapper_0.IOVSS1 user_project_wrapper_0.IOVSS1 sg13_hv_nmos ad=2.596p pd=5.58u as=1.408p ps=5.04u w=4.4u l=0.6u
X1639 user_project_wrapper_0.IOVSS1 user_project_wrapper_0.sg13g2_IOPadVdd_0.sg13g2_RCClampInverter_noptap_0.out VDD3 user_project_wrapper_0.IOVSS1 sg13_hv_nmos ad=1.408p pd=5.04u as=2.596p ps=5.58u w=4.4u l=0.6u
X1640 VDD3 a_296625_208423# a_296731_208493# VDD3 sg13_lv_pmos ad=0.2603p pd=1.75u as=0.2603p ps=1.75u w=1.37u l=0.35u
X1641 user_project_wrapper_0.IOVDD2 a_278644_41476# QDLL_TOP_0.VOUT user_project_wrapper_0.IOVDD2 sg13_hv_pmos ad=2.1312p pd=7.3u as=3.9294p ps=7.84u w=6.66u l=0.6u
X1642 analog_io[22] a_369296_197044# user_project_wrapper_0.IOVSS1 user_project_wrapper_0.IOVSS1 sg13_hv_nmos ad=2.596p pd=5.58u as=1.408p ps=5.04u w=4.4u l=0.6u
X1643 a_190824_326377# a_189184_326377# a_190722_327099# user_project_wrapper_0.IOVSS1 sg13_lv_nmos ad=0.19p pd=1.38u as=0.19p ps=1.38u w=1u l=0.13u
X1644 user_project_wrapper_0.IOVSS1 a_194193_328627# a_194279_327536# user_project_wrapper_0.IOVSS1 sg13_lv_pmos ad=1.824p pd=9.98u as=1.824p ps=9.98u w=9.6u l=0.13u
X1645 user_project_wrapper_0.IOVSS1 user_project_wrapper_0.sg13g2_IOPadIOVdd_0.sg13g2_Clamp_N43N43D4R_0.gate user_project_wrapper_0.IOVDD2 user_project_wrapper_0.IOVSS1 sg13_hv_nmos ad=1.408p pd=5.04u as=2.596p ps=5.58u w=4.4u l=0.6u
X1646 user_project_wrapper_0.analog_io[6] a_29676_237844# user_project_wrapper_0.IOVSS1 user_project_wrapper_0.IOVSS1 sg13_hv_nmos ad=2.596p pd=5.58u as=1.408p ps=5.04u w=4.4u l=0.6u
X1647 a_191438_328605# a_191234_328605# user_project_wrapper_0.IOVSS1 w_188704_327938# sg13_lv_pmos ad=0.38p pd=2.38u as=0.68p ps=4.68u w=2u l=0.13u
X1648 user_project_wrapper_0.IOVDD2 a_237844_41476# user_project_wrapper_0.analog_io[15] user_project_wrapper_0.IOVDD2 sg13_hv_pmos ad=2.1312p pd=7.3u as=3.9294p ps=7.84u w=6.66u l=0.6u
X1649 user_project_wrapper_0.IOVSS1 user_project_wrapper_0.sg13g2_IOPadVdd_0.sg13g2_RCClampInverter_noptap_0.out VDD3 user_project_wrapper_0.IOVSS1 sg13_hv_nmos ad=1.408p pd=5.04u as=2.596p ps=5.58u w=4.4u l=0.6u
X1650 user_project_wrapper_0.IOVSS1 user_project_wrapper_0.sg13g2_IOPadVdd_2.sg13g2_RCClampInverter_noptap_0.out user_project_wrapper_0.VDD1 user_project_wrapper_0.IOVSS1 sg13_hv_nmos ad=1.408p pd=5.04u as=2.596p ps=5.58u w=4.4u l=0.6u
X1651 user_project_wrapper_0.IOVSS1 user_project_wrapper_0.IOVSS1 user_project_wrapper_0.IOVSS1 rppd l=0.5u w=0.5u
X1652 user_project_wrapper_0.IOVDD4 user_project_wrapper_0.sg13g2_IOPadIOVdd_2.sg13g2_Clamp_N43N43D4R_0.gate user_project_wrapper_0.IOVSS1 user_project_wrapper_0.IOVSS1 sg13_hv_nmos ad=2.596p pd=5.58u as=1.408p ps=5.04u w=4.4u l=0.6u
X1653 user_project_wrapper_0.IOVSS1 a_202114_326125# user_project_wrapper_0.analog_io[32] user_project_wrapper_0.IOVSS1 sg13_lv_pmos ad=1.824p pd=9.98u as=1.824p ps=9.98u w=9.6u l=0.13u
X1654 user_project_wrapper_0.IOVSS1 a_369296_135844# analog_io[19] user_project_wrapper_0.IOVSS1 sg13_hv_nmos ad=1.408p pd=5.04u as=2.596p ps=5.58u w=4.4u l=0.6u
X1655 user_project_wrapper_0.IOVDD1 a_41476_135844# user_project_wrapper_0.analog_io[1] user_project_wrapper_0.IOVDD1 sg13_hv_pmos ad=2.1312p pd=7.3u as=3.9294p ps=7.84u w=6.66u l=0.6u
X1656 user_project_wrapper_0.IOVSS1 a_194279_327536# a_194687_324142# user_project_wrapper_0.IOVSS1 sg13_lv_pmos ad=1.824p pd=9.98u as=1.824p ps=9.98u w=9.6u l=0.13u
X1657 user_project_wrapper_0.IOVSS1 user_project_wrapper_0.sg13g2_IOPadIOVdd_3.sg13g2_Clamp_N43N43D4R_0.gate IOVDD3 user_project_wrapper_0.IOVSS1 sg13_hv_nmos ad=1.408p pd=5.04u as=2.596p ps=5.58u w=4.4u l=0.6u
X1658 user_project_wrapper_0.IOVSS1 user_project_wrapper_0.sg13g2_IOPadIOVdd_3.sg13g2_Clamp_N43N43D4R_0.gate IOVDD3 user_project_wrapper_0.IOVSS1 sg13_hv_nmos ad=1.408p pd=5.04u as=2.596p ps=5.58u w=4.4u l=0.6u
X1659 a_35456_301075# a_39542_301405# user_project_wrapper_0.IOVSS1 rppd l=20u w=1u
X1660 a_189286_329327# a_189184_329719# a_189184_328605# user_project_wrapper_0.IOVSS1 sg13_lv_nmos ad=0.19p pd=1.38u as=0.19p ps=1.38u w=1u l=0.13u
X1661 VDD3 a_296625_208423# a_296731_208493# VDD3 sg13_lv_pmos ad=0.2603p pd=1.75u as=0.2603p ps=1.75u w=1.37u l=0.35u
X1662 analog_io[23] a_355624_217444# IOVDD3 IOVDD3 sg13_hv_pmos ad=3.9294p pd=7.84u as=2.1312p ps=7.3u w=6.66u l=0.6u
X1663 a_213462_327536# a_213376_328627# user_project_wrapper_0.IOVSS1 user_project_wrapper_0.IOVSS1 sg13_lv_nmos ad=0.912p pd=5.18u as=0.912p ps=5.18u w=4.8u l=0.13u
X1664 user_project_wrapper_0.sg13g2_IOPadVdd_2.sg13g2_RCClampInverter_noptap_0.out user_project_wrapper_0.sg13g2_IOPadVdd_2.sg13g2_RCClampResistor_0.p2 user_project_wrapper_0.IOVSS1 user_project_wrapper_0.IOVSS1 sg13_hv_nmos ad=1.71p pd=9.38u as=1.71p ps=9.38u w=9u l=0.5u
X1665 user_project_wrapper_0.analog_io[11] a_156244_29676# user_project_wrapper_0.IOVSS1 user_project_wrapper_0.IOVSS1 sg13_hv_nmos ad=2.596p pd=5.58u as=1.408p ps=5.04u w=4.4u l=0.6u
X1666 a_35456_78655# a_39542_78325# user_project_wrapper_0.IOVSS1 rppd l=20u w=1u
X1667 user_project_wrapper_0.IOVDD4 user_project_wrapper_0.sg13g2_IOPadIOVdd_2.sg13g2_Clamp_N43N43D4R_0.gate user_project_wrapper_0.IOVSS1 user_project_wrapper_0.IOVSS1 sg13_hv_nmos ad=2.596p pd=5.58u as=1.408p ps=5.04u w=4.4u l=0.6u
X1668 user_project_wrapper_0.IOVSS1 a_202114_326125# user_project_wrapper_0.analog_io[32] user_project_wrapper_0.IOVSS1 sg13_lv_pmos ad=1.824p pd=9.98u as=1.824p ps=9.98u w=9.6u l=0.13u
X1669 VDD3 a_296625_208423# a_296731_208493# VDD3 sg13_lv_pmos ad=0.2603p pd=1.75u as=0.2603p ps=1.75u w=1.37u l=0.35u
X1670 user_project_wrapper_0.IOVSS1 user_project_wrapper_0.sg13g2_IOPadIOVdd_1.sg13g2_Clamp_N43N43D4R_0.gate user_project_wrapper_0.IOVDD1 user_project_wrapper_0.IOVSS1 sg13_hv_nmos ad=1.408p pd=5.04u as=2.596p ps=5.58u w=4.4u l=0.6u
X1671 user_project_wrapper_0.analog_io[30] a_194687_324142# user_project_wrapper_0.IOVSS1 user_project_wrapper_0.IOVSS1 sg13_lv_nmos ad=0.912p pd=5.18u as=0.912p ps=5.18u w=4.8u l=0.13u
X1672 user_project_wrapper_0.IOVSS1 a_307232_196607# a_304995_198817# user_project_wrapper_0.IOVSS1 sg13_lv_nmos ad=0.6327p pd=3.71u as=0.6327p ps=3.71u w=3.33u l=0.2u
X1673 user_project_wrapper_0.analog_io[5] a_29676_217444# user_project_wrapper_0.IOVSS1 user_project_wrapper_0.IOVSS1 sg13_hv_nmos ad=2.596p pd=5.58u as=1.408p ps=5.04u w=4.4u l=0.6u
X1674 user_project_wrapper_0.IOVSS1 user_project_wrapper_0.analog_io[11] dantenna l=1.26u w=27.78u
X1675 user_project_wrapper_0.analog_io[30] a_194687_324142# user_project_wrapper_0.IOVSS1 user_project_wrapper_0.IOVSS1 sg13_lv_nmos ad=0.912p pd=5.18u as=0.912p ps=5.18u w=4.8u l=0.13u
X1676 user_project_wrapper_0.IOVSS1 a_258244_29676# user_project_wrapper_0.analog_io[16] user_project_wrapper_0.IOVSS1 sg13_hv_nmos ad=2.068p pd=9.74u as=2.596p ps=5.58u w=4.4u l=0.6u
X1677 a_189729_99046# a_189395_99046# QDLL_TOP_0.VDD QDLL_TOP_0.VDD sg13_lv_pmos ad=0.2128p pd=1.5u as=0.2128p ps=1.5u w=1.12u l=0.13u
X1678 user_project_wrapper_0.IOVSS1 user_project_wrapper_0.sg13g2_IOPadIOVdd_1.sg13g2_RCClampResistor_0.p2 user_project_wrapper_0.sg13g2_IOPadIOVdd_1.sg13g2_Clamp_N43N43D4R_0.gate user_project_wrapper_0.IOVSS1 sg13_hv_nmos ad=1.71p pd=9.38u as=1.71p ps=9.38u w=9u l=0.5u
X1679 a_304375_364458# a_304045_360372# user_project_wrapper_0.IOVSS1 rppd l=20u w=1u
X1680 user_project_wrapper_0.IOVSS1 user_project_wrapper_0.sg13g2_IOPadVdd_1.sg13g2_RCClampInverter_noptap_0.out user_project_wrapper_0.VDD2 user_project_wrapper_0.IOVSS1 sg13_hv_nmos ad=1.408p pd=5.04u as=2.596p ps=5.58u w=4.4u l=0.6u
X1681 user_project_wrapper_0.IOVDD2 user_project_wrapper_0.sg13g2_IOPadIOVdd_0.sg13g2_Clamp_N43N43D4R_0.gate user_project_wrapper_0.IOVSS1 user_project_wrapper_0.IOVSS1 sg13_hv_nmos ad=2.596p pd=5.58u as=1.408p ps=5.04u w=4.4u l=0.6u
X1682 a_296731_208493# a_301186_192011# user_project_wrapper_0.IOVSS1 user_project_wrapper_0.IOVSS1 sg13_lv_nmos ad=1.632p pd=10.28u as=0.912p ps=5.18u w=4.8u l=1.06u
X1683 user_project_wrapper_0.IOVSS1 a_369296_217444# analog_io[23] user_project_wrapper_0.IOVSS1 sg13_hv_nmos ad=1.408p pd=5.04u as=2.596p ps=5.58u w=4.4u l=0.6u
X1684 user_project_wrapper_0.IOVSS1 user_project_wrapper_0.IOVSS1 user_project_wrapper_0.IOVSS1 rhigh l=4u w=0.5u
X1685 user_project_wrapper_0.IOVSS1 a_217444_29676# user_project_wrapper_0.analog_io[14] user_project_wrapper_0.IOVSS1 sg13_hv_nmos ad=1.408p pd=5.04u as=2.596p ps=5.58u w=4.4u l=0.6u
X1686 user_project_wrapper_0.VDD1 a_87851_125174# a_87775_125210# user_project_wrapper_0.VDD1 sg13_lv_pmos ad=0.3808p pd=2.92u as=0.2128p ps=1.5u w=1.12u l=0.13u
X1687 QDLL_TOP_0.VDD a_190389_99046# user_project_wrapper_0.analog_io[14] QDLL_TOP_0.VDD sg13_lv_pmos ad=0.2128p pd=1.5u as=0.2128p ps=1.5u w=1.12u l=0.13u
X1688 QDLL_TOP_0.VDD a_189729_99046# a_190389_99046# QDLL_TOP_0.VDD sg13_lv_pmos ad=0.2128p pd=1.5u as=0.2128p ps=1.5u w=1.12u l=0.13u
X1689 analog_io[22] a_355624_197044# IOVDD3 IOVDD3 sg13_hv_pmos ad=3.9294p pd=7.84u as=2.1312p ps=7.3u w=6.66u l=0.6u
X1690 IOVDD3 a_355624_135844# analog_io[19] IOVDD3 sg13_hv_pmos ad=2.1312p pd=7.3u as=3.9294p ps=7.84u w=6.66u l=0.6u
X1691 user_project_wrapper_0.IOVSS1 user_project_wrapper_0.sg13g2_IOPadVdd_3.sg13g2_RCClampInverter_noptap_0.out user_project_wrapper_0.IOVSS1 user_project_wrapper_0.IOVSS1 sg13_hv_nmos ad=2.596p pd=5.58u as=0 ps=0 w=4.4u l=0.6u
X1692 user_project_wrapper_0.IOVSS1 a_194687_324142# user_project_wrapper_0.analog_io[30] user_project_wrapper_0.IOVSS1 sg13_lv_pmos ad=1.824p pd=9.98u as=1.824p ps=9.98u w=9.6u l=0.13u
X1693 a_309917_199879# a_309516_194555# VDD3 VDD3 sg13_lv_pmos ad=0.19p pd=1.38u as=0.19p ps=1.38u w=1u l=0.7u
X1694 a_296731_189665# a_296625_189595# VDD3 VDD3 sg13_lv_pmos ad=0.2603p pd=1.75u as=0.2603p ps=1.75u w=1.37u l=0.35u
X1695 VDD3 a_309516_194555# a_309917_199879# VDD3 sg13_lv_pmos ad=0.19p pd=1.38u as=0.19p ps=1.38u w=1u l=0.7u
X1696 a_304995_198817# a_307232_196607# user_project_wrapper_0.IOVSS1 user_project_wrapper_0.IOVSS1 sg13_lv_nmos ad=0.6327p pd=3.71u as=0.6327p ps=3.71u w=3.33u l=0.2u
X1697 a_85989_241383# a_85591_241748# user_project_wrapper_0.IOVSS1 user_project_wrapper_0.IOVSS1 sg13_lv_nmos ad=0.1406p pd=1.12u as=0.2516p ps=2.16u w=0.74u l=0.13u
X1698 user_project_wrapper_0.IOVDD1 user_project_wrapper_0.sg13g2_IOPadIOVdd_1.sg13g2_Clamp_N43N43D4R_0.gate user_project_wrapper_0.IOVSS1 user_project_wrapper_0.IOVSS1 sg13_hv_nmos ad=2.596p pd=5.58u as=1.408p ps=5.04u w=4.4u l=0.6u
X1699 user_project_wrapper_0.IOVSS1 a_210417_327491# a_210621_327491# user_project_wrapper_0.IOVSS1 sg13_lv_nmos ad=0.19p pd=1.38u as=0.19p ps=1.38u w=1u l=0.13u
X1700 VDD3 a_296625_208423# a_296731_208493# VDD3 sg13_lv_pmos ad=0.2603p pd=1.75u as=0.2603p ps=1.75u w=1.37u l=0.35u
X1701 user_project_wrapper_0.VDD1 user_project_wrapper_0.sg13g2_IOPadVdd_2.sg13g2_RCClampResistor_0.p2 user_project_wrapper_0.sg13g2_IOPadVdd_2.sg13g2_RCClampInverter_noptap_0.out user_project_wrapper_0.VDD1 sg13_hv_pmos ad=1.33p pd=7.38u as=1.33p ps=7.38u w=7u l=0.5u
X1702 user_project_wrapper_0.IOVDD2 a_176644_41476# user_project_wrapper_0.analog_io[12] user_project_wrapper_0.IOVDD2 sg13_hv_pmos ad=2.1312p pd=7.3u as=3.9294p ps=7.84u w=6.66u l=0.6u
X1703 QDLL_TOP_0.VOUT user_project_wrapper_0.sg13g2_IOPadAnalog_6.padres a_186430_102197# QDLL_TOP_0.VDD sg13_lv_pmos ad=1.5164p pd=9.6u as=1.5164p ps=9.6u w=4.46u l=0.13u
X1704 user_project_wrapper_0.IOVSS1 user_project_wrapper_0.sg13g2_IOPadIOVdd_2.sg13g2_Clamp_N43N43D4R_0.gate user_project_wrapper_0.IOVDD4 user_project_wrapper_0.IOVSS1 sg13_hv_nmos ad=1.408p pd=5.04u as=2.596p ps=5.58u w=4.4u l=0.6u
X1705 user_project_wrapper_0.IOVSS1 a_29676_237844# user_project_wrapper_0.analog_io[6] user_project_wrapper_0.IOVSS1 sg13_hv_nmos ad=1.408p pd=5.04u as=2.596p ps=5.58u w=4.4u l=0.6u
X1706 user_project_wrapper_0.IOVSS1 user_project_wrapper_0.sg13g2_IOPadIOVdd_2.sg13g2_Clamp_N43N43D4R_0.gate user_project_wrapper_0.IOVDD4 user_project_wrapper_0.IOVSS1 sg13_hv_nmos ad=1.408p pd=5.04u as=2.596p ps=5.58u w=4.4u l=0.6u
X1707 user_project_wrapper_0.IOVSS1 a_205385_326221# a_202114_326125# user_project_wrapper_0.IOVSS1 sg13_lv_pmos ad=1.824p pd=9.98u as=1.824p ps=9.98u w=9.6u l=0.13u
X1708 a_208367_326377# user_project_wrapper_0.IOVSS1 user_project_wrapper_0.IOVSS1 w_207887_326203# sg13_lv_pmos ad=0.38p pd=2.38u as=0.68p ps=4.68u w=2u l=0.13u
X1709 QDLL_TOP_0.VDD a_189729_101343# a_190389_101343# QDLL_TOP_0.VDD sg13_lv_pmos ad=0.3808p pd=2.92u as=0.2184p ps=1.51u w=1.12u l=0.13u
X1710 a_309917_194695# a_309516_194555# VDD3 VDD3 sg13_lv_pmos ad=0.19p pd=1.38u as=0.19p ps=1.38u w=1u l=0.7u
X1711 user_project_wrapper_0.IOVSS1 a_301186_192011# a_296731_208493# user_project_wrapper_0.IOVSS1 sg13_lv_nmos ad=0.912p pd=5.18u as=0.912p ps=5.18u w=4.8u l=1.06u
X1712 user_project_wrapper_0.IOVSS1 a_194687_324142# user_project_wrapper_0.analog_io[30] user_project_wrapper_0.IOVSS1 sg13_lv_pmos ad=1.824p pd=9.98u as=1.824p ps=9.98u w=9.6u l=0.13u
X1713 IOVDD3 a_355624_237844# analog_io[23] IOVDD3 sg13_hv_pmos ad=2.1312p pd=7.3u as=3.9294p ps=7.84u w=6.66u l=0.6u
X1714 user_project_wrapper_0.analog_io[35] a_213870_324142# user_project_wrapper_0.IOVSS1 user_project_wrapper_0.IOVSS1 sg13_lv_nmos ad=0.912p pd=5.18u as=0.912p ps=5.18u w=4.8u l=0.13u
X1715 user_project_wrapper_0.IOVSS1 a_182931_326125# user_project_wrapper_0.analog_io[27] user_project_wrapper_0.IOVSS1 sg13_lv_nmos ad=0.912p pd=5.18u as=0.912p ps=5.18u w=4.8u l=0.13u
X1716 a_210621_327491# TOP_ROILIFNEURON_0.MEM user_project_wrapper_0.IOVSS1 rppd l=0.5u w=0.5u
X1717 user_project_wrapper_0.IOVSS1 user_project_wrapper_0.sg13g2_IOPadIOVdd_0.sg13g2_Clamp_N43N43D4R_0.gate user_project_wrapper_0.IOVDD2 user_project_wrapper_0.IOVSS1 sg13_hv_nmos ad=1.408p pd=5.04u as=2.596p ps=5.58u w=4.4u l=0.6u
X1718 user_project_wrapper_0.IOVSS1 a_307232_196607# a_307232_196607# user_project_wrapper_0.IOVSS1 sg13_lv_nmos ad=0.6327p pd=3.71u as=0.6327p ps=3.71u w=3.33u l=0.2u
X1719 user_project_wrapper_0.IOVSS1 user_project_wrapper_0.sg13g2_IOPadIOVdd_3.sg13g2_Clamp_N43N43D4R_0.gate IOVDD3 user_project_wrapper_0.IOVSS1 sg13_hv_nmos ad=1.408p pd=5.04u as=2.596p ps=5.58u w=4.4u l=0.6u
X1720 user_project_wrapper_0.analog_io[35] a_213870_324142# user_project_wrapper_0.IOVSS1 user_project_wrapper_0.IOVSS1 sg13_lv_nmos ad=0.912p pd=5.18u as=0.912p ps=5.18u w=4.8u l=0.13u
X1721 user_project_wrapper_0.IOVSS1 user_project_wrapper_0.sg13g2_IOPadIOVdd_1.sg13g2_RCClampResistor_0.p2 user_project_wrapper_0.sg13g2_IOPadIOVdd_1.sg13g2_Clamp_N43N43D4R_0.gate user_project_wrapper_0.IOVSS1 sg13_hv_nmos ad=1.71p pd=9.38u as=1.71p ps=9.38u w=9u l=0.5u
X1722 user_project_wrapper_0.analog_io[16] a_258244_41476# user_project_wrapper_0.IOVDD2 user_project_wrapper_0.IOVDD2 sg13_hv_pmos ad=3.9294p pd=7.84u as=2.1312p ps=7.3u w=6.66u l=0.6u
X1723 a_86594_127531# a_86507_127725# user_project_wrapper_0.IOVSS1 user_project_wrapper_0.IOVSS1 sg13_lv_nmos ad=0.1406p pd=1.12u as=0.2516p ps=2.16u w=0.74u l=0.13u
X1724 user_project_wrapper_0.IOVSS1 a_206547_324106# a_206201_328627# user_project_wrapper_0.IOVSS1 sg13_lv_pmos ad=3.264p pd=19.88u as=3.264p ps=19.88u w=9.6u l=0.13u
X1725 IOVDD3 a_355624_217444# analog_io[23] IOVDD3 sg13_hv_pmos ad=2.1312p pd=7.3u as=3.9294p ps=7.84u w=6.66u l=0.6u
X1726 user_project_wrapper_0.analog_io[30] a_194687_324142# user_project_wrapper_0.IOVSS1 user_project_wrapper_0.IOVSS1 sg13_lv_nmos ad=0.912p pd=5.18u as=0.912p ps=5.18u w=4.8u l=0.13u
X1727 a_296731_189665# a_296625_189595# VDD3 VDD3 sg13_lv_pmos ad=0.2603p pd=1.75u as=0.4658p ps=3.42u w=1.37u l=0.35u
X1728 user_project_wrapper_0.IOVSS1 a_82667_125418# a_83592_125209# user_project_wrapper_0.IOVSS1 sg13_lv_nmos ad=0.2516p pd=2.16u as=0.1406p ps=1.12u w=0.74u l=0.13u
X1729 a_301075_364458# a_301405_360372# user_project_wrapper_0.IOVSS1 rppd l=20u w=1u
X1730 user_project_wrapper_0.IOVSS1 user_project_wrapper_0.sg13g2_IOPadVdd_2.sg13g2_RCClampResistor_0.p2 user_project_wrapper_0.IOVSS1 user_project_wrapper_0.IOVSS1 sg13_hv_nmos ad=1.71p pd=9.38u as=0 ps=0 w=9u l=9.5u
X1731 user_project_wrapper_0.analog_io[14] a_217444_41476# user_project_wrapper_0.IOVDD2 user_project_wrapper_0.IOVDD2 sg13_hv_pmos ad=3.9294p pd=7.84u as=3.1302p ps=14.26u w=6.66u l=0.6u
X1732 user_project_wrapper_0.sg13g2_IOPadVdd_1.sg13g2_RCClampInverter_noptap_0.out user_project_wrapper_0.sg13g2_IOPadVdd_1.sg13g2_RCClampResistor_0.p2 user_project_wrapper_0.VDD2 user_project_wrapper_0.VDD2 sg13_hv_pmos ad=1.33p pd=7.38u as=1.33p ps=7.38u w=7u l=0.5u
X1733 a_210621_328605# a_210417_328605# user_project_wrapper_0.IOVSS1 w_207887_327938# sg13_lv_pmos ad=0.38p pd=2.38u as=0.68p ps=4.68u w=2u l=0.13u
X1734 user_project_wrapper_0.IOVSS1 a_189729_101343# a_190389_101343# user_project_wrapper_0.IOVSS1 sg13_lv_nmos ad=0.1406p pd=1.12u as=0.1406p ps=1.12u w=0.74u l=0.13u
X1735 a_360372_80305# a_364458_80635# user_project_wrapper_0.IOVSS1 rppd l=20u w=1u
X1736 user_project_wrapper_0.analog_io[0] user_project_wrapper_0.IOVDD1 dpantenna l=27.78u w=1.26u
X1737 IOVDD3 user_project_wrapper_0.sg13g2_IOPadIOVdd_3.sg13g2_RCClampResistor_0.p2 user_project_wrapper_0.sg13g2_IOPadIOVdd_3.sg13g2_Clamp_N43N43D4R_0.gate IOVDD3 sg13_hv_pmos ad=1.33p pd=7.38u as=1.33p ps=7.38u w=7u l=0.5u
X1738 user_project_wrapper_0.analog_io[29] a_156244_355624# user_project_wrapper_0.IOVDD4 user_project_wrapper_0.IOVDD4 sg13_hv_pmos ad=3.9294p pd=7.84u as=2.1312p ps=7.3u w=6.66u l=0.6u
X1739 VDD3 a_296625_189595# a_296731_189665# VDD3 sg13_lv_pmos ad=0.4658p pd=3.42u as=0.2603p ps=1.75u w=1.37u l=0.35u
X1740 user_project_wrapper_0.analog_io[33] a_237844_369296# user_project_wrapper_0.IOVSS1 user_project_wrapper_0.IOVSS1 sg13_hv_nmos ad=2.596p pd=5.58u as=1.408p ps=5.04u w=4.4u l=0.6u
X1741 user_project_wrapper_0.IOVDD2 user_project_wrapper_0.sg13g2_IOPadIOVdd_0.sg13g2_RCClampResistor_0.p2 user_project_wrapper_0.sg13g2_IOPadIOVdd_0.sg13g2_Clamp_N43N43D4R_0.gate user_project_wrapper_0.IOVDD2 sg13_hv_pmos ad=1.33p pd=7.38u as=1.33p ps=7.38u w=7u l=0.5u
X1742 user_project_wrapper_0.IOVDD4 user_project_wrapper_0.sg13g2_IOPadIOVdd_2.sg13g2_Clamp_N43N43D4R_0.gate user_project_wrapper_0.IOVSS1 user_project_wrapper_0.IOVSS1 sg13_hv_nmos ad=2.596p pd=5.58u as=2.068p ps=9.74u w=4.4u l=0.6u
X1743 a_302725_39542# a_302395_35456# user_project_wrapper_0.IOVSS1 rppd l=20u w=1u
X1744 user_project_wrapper_0.sg13g2_IOPadVdd_3.sg13g2_RCClampInverter_noptap_0.out user_project_wrapper_0.sg13g2_IOPadVdd_3.sg13g2_RCClampResistor_0.p2 user_project_wrapper_0.IOVSS1 user_project_wrapper_0.IOVSS1 sg13_hv_pmos ad=1.33p pd=7.38u as=1.33p ps=7.38u w=7u l=0.5u
X1745 user_project_wrapper_0.IOVSS1 a_156244_369296# user_project_wrapper_0.analog_io[29] user_project_wrapper_0.IOVSS1 sg13_hv_nmos ad=1.408p pd=5.04u as=2.596p ps=5.58u w=4.4u l=0.6u
X1746 user_project_wrapper_0.VDD2 user_project_wrapper_0.sg13g2_IOPadVdd_1.sg13g2_RCClampInverter_noptap_0.out user_project_wrapper_0.IOVSS1 user_project_wrapper_0.IOVSS1 sg13_hv_nmos ad=2.596p pd=5.58u as=1.408p ps=5.04u w=4.4u l=0.6u
X1747 user_project_wrapper_0.IOVDD2 user_project_wrapper_0.sg13g2_IOPadIOVdd_0.sg13g2_Clamp_N43N43D4R_0.gate user_project_wrapper_0.IOVSS1 user_project_wrapper_0.IOVSS1 sg13_hv_nmos ad=2.596p pd=5.58u as=1.408p ps=5.04u w=4.4u l=0.6u
X1748 user_project_wrapper_0.VDD2 user_project_wrapper_0.sg13g2_IOPadVdd_1.sg13g2_RCClampInverter_noptap_0.out user_project_wrapper_0.IOVSS1 user_project_wrapper_0.IOVSS1 sg13_hv_nmos ad=2.596p pd=5.58u as=1.408p ps=5.04u w=4.4u l=0.6u
X1749 user_project_wrapper_0.IOVSS1 a_217444_29676# user_project_wrapper_0.analog_io[14] user_project_wrapper_0.IOVSS1 sg13_hv_nmos ad=1.408p pd=5.04u as=2.596p ps=5.58u w=4.4u l=0.6u
X1750 user_project_wrapper_0.sg13g2_IOPadIOVdd_2.sg13g2_Clamp_N43N43D4R_0.gate user_project_wrapper_0.sg13g2_IOPadIOVdd_2.sg13g2_RCClampResistor_0.p2 user_project_wrapper_0.IOVDD4 user_project_wrapper_0.IOVDD4 sg13_hv_pmos ad=1.33p pd=7.38u as=1.33p ps=7.38u w=7u l=0.5u
X1751 user_project_wrapper_0.IOVDD1 user_project_wrapper_0.sg13g2_IOPadIOVdd_1.sg13g2_Clamp_N43N43D4R_0.gate user_project_wrapper_0.IOVSS1 user_project_wrapper_0.IOVSS1 sg13_hv_nmos ad=2.596p pd=5.58u as=2.068p ps=9.74u w=4.4u l=0.6u
X1752 user_project_wrapper_0.analog_io[35] a_213870_324142# user_project_wrapper_0.IOVSS1 user_project_wrapper_0.IOVSS1 sg13_lv_nmos ad=0.912p pd=5.18u as=0.912p ps=5.18u w=4.8u l=0.13u
X1753 a_311108_215937# analog_io[23] a_313884_211353# user_project_wrapper_0.IOVSS1 sg13_lv_nmos ad=1.9p pd=10.38u as=1.9p ps=10.38u w=10u l=0.5u
X1754 user_project_wrapper_0.IOVDD2 a_217444_41476# user_project_wrapper_0.analog_io[14] user_project_wrapper_0.IOVDD2 sg13_hv_pmos ad=3.1302p pd=14.26u as=3.9294p ps=7.84u w=6.66u l=0.6u
X1755 user_project_wrapper_0.IOVSS1 user_project_wrapper_0.sg13g2_IOPadAnalog_19.padres a_189858_325263# user_project_wrapper_0.IOVSS1 sg13_lv_nmos ad=0.34p pd=2.68u as=0.19p ps=1.38u w=1u l=0.13u
X1756 user_project_wrapper_0.analog_io[35] a_278644_369296# user_project_wrapper_0.IOVSS1 user_project_wrapper_0.IOVSS1 sg13_hv_nmos ad=2.596p pd=5.58u as=1.408p ps=5.04u w=4.4u l=0.6u
X1757 user_project_wrapper_0.VDD2 user_project_wrapper_0.sg13g2_IOPadVdd_1.sg13g2_RCClampInverter_noptap_0.out user_project_wrapper_0.IOVSS1 user_project_wrapper_0.IOVSS1 sg13_hv_nmos ad=2.596p pd=5.58u as=1.408p ps=5.04u w=4.4u l=0.6u
X1758 user_project_wrapper_0.IOVDD4 a_237844_355624# user_project_wrapper_0.analog_io[33] user_project_wrapper_0.IOVDD4 sg13_hv_pmos ad=2.1312p pd=7.3u as=3.9294p ps=7.84u w=6.66u l=0.6u
X1759 VDD3 a_309516_194555# a_309917_194695# VDD3 sg13_lv_pmos ad=0.19p pd=1.38u as=0.19p ps=1.38u w=1u l=0.7u
X1760 user_project_wrapper_0.analog_io[29] user_project_wrapper_0.IOVDD4 dpantenna l=1.26u w=27.78u
X1761 VDD3 user_project_wrapper_0.sg13g2_IOPadVdd_0.sg13g2_RCClampResistor_0.p2 user_project_wrapper_0.sg13g2_IOPadVdd_0.sg13g2_RCClampInverter_noptap_0.out VDD3 sg13_hv_pmos ad=1.33p pd=7.38u as=1.33p ps=7.38u w=7u l=0.5u
X1762 a_296731_208493# a_296625_208423# VDD3 VDD3 sg13_lv_pmos ad=0.2603p pd=1.75u as=0.4658p ps=3.42u w=1.37u l=0.35u
X1763 IOVDD3 user_project_wrapper_0.sg13g2_IOPadIOVdd_3.sg13g2_RCClampResistor_0.p2 user_project_wrapper_0.sg13g2_IOPadIOVdd_3.sg13g2_Clamp_N43N43D4R_0.gate IOVDD3 sg13_hv_pmos ad=1.33p pd=7.38u as=1.33p ps=7.38u w=7u l=0.5u
X1764 user_project_wrapper_0.IOVSS1 user_project_wrapper_0.sg13g2_IOPadIOVdd_0.sg13g2_Clamp_N43N43D4R_0.gate user_project_wrapper_0.IOVDD2 user_project_wrapper_0.IOVSS1 sg13_hv_nmos ad=1.408p pd=5.04u as=2.596p ps=5.58u w=4.4u l=0.6u
X1765 user_project_wrapper_0.IOVSS1 a_209230_324119# a_206547_324106# user_project_wrapper_0.IOVSS1 sg13_lv_nmos ad=0.34p pd=2.68u as=0.19p ps=1.38u w=1u l=0.13u
X1766 IOVDD3 a_355624_156244# analog_io[20] IOVDD3 sg13_hv_pmos ad=2.1312p pd=7.3u as=3.9294p ps=7.84u w=6.66u l=0.6u
X1767 user_project_wrapper_0.sg13g2_IOPadIOVdd_1.sg13g2_Clamp_N43N43D4R_0.gate user_project_wrapper_0.sg13g2_IOPadIOVdd_1.sg13g2_RCClampResistor_0.p2 user_project_wrapper_0.IOVDD1 user_project_wrapper_0.IOVDD1 sg13_hv_pmos ad=1.33p pd=7.38u as=1.33p ps=7.38u w=7u l=0.5u
X1768 VDD3 a_296625_208423# a_296731_208493# VDD3 sg13_lv_pmos ad=0.4658p pd=3.42u as=0.2603p ps=1.75u w=1.37u l=0.35u
X1769 a_296731_208493# a_296625_208423# VDD3 VDD3 sg13_lv_pmos ad=0.2603p pd=1.75u as=0.2603p ps=1.75u w=1.37u l=0.35u
X1770 user_project_wrapper_0.VDD2 user_project_wrapper_0.sg13g2_IOPadVdd_1.sg13g2_RCClampResistor_0.p2 user_project_wrapper_0.sg13g2_IOPadVdd_1.sg13g2_RCClampInverter_noptap_0.out user_project_wrapper_0.VDD2 sg13_hv_pmos ad=2.38p pd=14.68u as=1.33p ps=7.38u w=7u l=0.5u
X1771 user_project_wrapper_0.IOVSS1 user_project_wrapper_0.sg13g2_IOPadIOVdd_2.sg13g2_Clamp_N43N43D4R_0.gate user_project_wrapper_0.IOVDD4 user_project_wrapper_0.IOVSS1 sg13_hv_nmos ad=1.408p pd=5.04u as=2.596p ps=5.58u w=4.4u l=0.6u
X1772 a_296732_200582# a_301940_196388# a_296625_208423# VDD3 sg13_lv_pmos ad=0.7695p pd=4.43u as=0.7695p ps=4.43u w=4.05u l=0.5u
X1773 user_project_wrapper_0.IOVSS1 user_project_wrapper_0.IOVSS1 user_project_wrapper_0.IOVSS1 rppd l=0.5u w=0.5u
X1774 a_309917_199879# a_309516_194555# VDD3 VDD3 sg13_lv_pmos ad=0.19p pd=1.38u as=0.19p ps=1.38u w=1u l=0.7u
X1775 user_project_wrapper_0.sg13g2_IOPadIOVdd_0.sg13g2_Clamp_N43N43D4R_0.gate user_project_wrapper_0.sg13g2_IOPadIOVdd_0.sg13g2_RCClampResistor_0.p2 user_project_wrapper_0.IOVDD2 user_project_wrapper_0.IOVDD2 sg13_hv_pmos ad=1.33p pd=7.38u as=1.33p ps=7.38u w=7u l=0.5u
X1776 user_project_wrapper_0.VDD1 user_project_wrapper_0.sg13g2_IOPadVdd_2.sg13g2_RCClampInverter_noptap_0.out user_project_wrapper_0.IOVSS1 user_project_wrapper_0.IOVSS1 sg13_hv_nmos ad=2.596p pd=5.58u as=1.408p ps=5.04u w=4.4u l=0.6u
X1777 VDD3 a_296626_197740# a_296732_200582# VDD3 sg13_lv_pmos ad=1.33p pd=7.38u as=1.33p ps=7.38u w=7u l=0.7u
X1778 user_project_wrapper_0.IOVDD2 a_176644_41476# user_project_wrapper_0.analog_io[12] user_project_wrapper_0.IOVDD2 sg13_hv_pmos ad=2.1312p pd=7.3u as=3.9294p ps=7.84u w=6.66u l=0.6u
X1779 a_116485_39542# a_116815_35456# user_project_wrapper_0.IOVSS1 rppd l=20u w=1u
X1780 a_82974_125209# a_82826_124842# a_82872_125209# user_project_wrapper_0.VDD1 sg13_lv_pmos ad=0.2128p pd=1.5u as=0.2128p ps=1.5u w=1.12u l=0.13u
X1781 a_313884_185173# a_296731_189665# a_311189_185546# user_project_wrapper_0.IOVSS1 sg13_lv_nmos ad=1.9p pd=10.38u as=1.9p ps=10.38u w=10u l=0.5u
X1782 user_project_wrapper_0.analog_io[16] a_258244_29676# user_project_wrapper_0.IOVSS1 user_project_wrapper_0.IOVSS1 sg13_hv_nmos ad=2.596p pd=5.58u as=1.408p ps=5.04u w=4.4u l=0.6u
X1783 user_project_wrapper_0.analog_io[35] a_278644_355624# user_project_wrapper_0.IOVDD4 user_project_wrapper_0.IOVDD4 sg13_hv_pmos ad=3.9294p pd=7.84u as=2.1312p ps=7.3u w=6.66u l=0.6u
X1784 user_project_wrapper_0.sg13g2_IOPadAnalog_20.padres user_project_wrapper_0.IOVDD4 dpantenna l=0.64u w=4.98u
X1785 user_project_wrapper_0.analog_io[16] a_258244_41476# user_project_wrapper_0.IOVDD2 user_project_wrapper_0.IOVDD2 sg13_hv_pmos ad=3.9294p pd=7.84u as=2.1312p ps=7.3u w=6.66u l=0.6u
X1786 user_project_wrapper_0.analog_io[27] a_115444_355624# user_project_wrapper_0.IOVDD4 user_project_wrapper_0.IOVDD4 sg13_hv_pmos ad=3.9294p pd=7.84u as=2.1312p ps=7.3u w=6.66u l=0.6u
X1787 analog_io[25] a_369296_258244# user_project_wrapper_0.IOVSS1 user_project_wrapper_0.IOVSS1 sg13_hv_nmos ad=2.596p pd=5.58u as=1.408p ps=5.04u w=4.4u l=0.6u
X1788 user_project_wrapper_0.sg13g2_IOPadVdd_1.sg13g2_RCClampInverter_noptap_0.out user_project_wrapper_0.sg13g2_IOPadVdd_1.sg13g2_RCClampResistor_0.p2 user_project_wrapper_0.VDD2 user_project_wrapper_0.VDD2 sg13_hv_pmos ad=1.33p pd=7.38u as=1.33p ps=7.38u w=7u l=0.5u
X1789 user_project_wrapper_0.VDD2 user_project_wrapper_0.sg13g2_IOPadVdd_1.sg13g2_RCClampInverter_noptap_0.out user_project_wrapper_0.IOVSS1 user_project_wrapper_0.IOVSS1 sg13_hv_nmos ad=2.596p pd=5.58u as=2.068p ps=9.74u w=4.4u l=0.6u
X1790 IOVDD3 user_project_wrapper_0.sg13g2_IOPadIOVdd_3.sg13g2_RCClampResistor_0.p2 user_project_wrapper_0.sg13g2_IOPadIOVdd_3.sg13g2_Clamp_N43N43D4R_0.gate IOVDD3 sg13_hv_pmos ad=1.33p pd=7.38u as=1.33p ps=7.38u w=7u l=0.5u
X1791 user_project_wrapper_0.IOVSS1 a_211321_324119# a_210983_324119# w_207989_323975# sg13_lv_pmos ad=0.68p pd=4.68u as=0.68p ps=4.68u w=2u l=0.65u
X1792 user_project_wrapper_0.analog_io[15] a_237844_29676# user_project_wrapper_0.IOVSS1 user_project_wrapper_0.IOVSS1 sg13_hv_nmos ad=2.596p pd=5.58u as=1.408p ps=5.04u w=4.4u l=0.6u
X1793 user_project_wrapper_0.VDD2 user_project_wrapper_0.sg13g2_IOPadVdd_1.sg13g2_RCClampInverter_noptap_0.out user_project_wrapper_0.IOVSS1 user_project_wrapper_0.IOVSS1 sg13_hv_nmos ad=2.596p pd=5.58u as=1.408p ps=5.04u w=4.4u l=0.6u
X1794 a_309516_194555# a_309516_194555# VDD3 VDD3 sg13_lv_pmos ad=0.19p pd=1.38u as=0.19p ps=1.38u w=1u l=0.7u
X1795 user_project_wrapper_0.IOVSS1 user_project_wrapper_0.sg13g2_IOPadIOVdd_1.sg13g2_Clamp_N43N43D4R_0.gate user_project_wrapper_0.IOVDD1 user_project_wrapper_0.IOVSS1 sg13_hv_nmos ad=1.408p pd=5.04u as=2.596p ps=5.58u w=4.4u l=0.6u
X1796 user_project_wrapper_0.IOVDD1 a_41476_258244# user_project_wrapper_0.analog_io[7] user_project_wrapper_0.IOVDD1 sg13_hv_pmos ad=3.1302p pd=14.26u as=3.9294p ps=7.84u w=6.66u l=0.6u
X1797 user_project_wrapper_0.IOVSS1 user_project_wrapper_0.sg13g2_IOPadVdd_0.sg13g2_RCClampInverter_noptap_0.out VDD3 user_project_wrapper_0.IOVSS1 sg13_hv_nmos ad=1.408p pd=5.04u as=2.596p ps=5.58u w=4.4u l=0.6u
X1798 user_project_wrapper_0.sg13g2_IOPadVdd_3.sg13g2_RCClampInverter_noptap_0.out user_project_wrapper_0.sg13g2_IOPadVdd_3.sg13g2_RCClampResistor_0.p2 user_project_wrapper_0.IOVSS1 user_project_wrapper_0.IOVSS1 sg13_hv_pmos ad=1.33p pd=7.38u as=1.33p ps=7.38u w=7u l=0.5u
X1799 IOVDD3 a_355624_197044# analog_io[22] IOVDD3 sg13_hv_pmos ad=2.1312p pd=7.3u as=3.9294p ps=7.84u w=6.66u l=0.6u
X1800 user_project_wrapper_0.IOVSS1 a_194279_327536# a_194687_324142# user_project_wrapper_0.IOVSS1 sg13_lv_pmos ad=1.824p pd=9.98u as=1.824p ps=9.98u w=9.6u l=0.13u
X1801 user_project_wrapper_0.analog_io[32] a_202114_326125# user_project_wrapper_0.IOVSS1 user_project_wrapper_0.IOVSS1 sg13_lv_nmos ad=0.912p pd=5.18u as=0.912p ps=5.18u w=4.8u l=0.13u
X1802 user_project_wrapper_0.analog_io[7] a_29676_258244# user_project_wrapper_0.IOVSS1 user_project_wrapper_0.IOVSS1 sg13_hv_nmos ad=2.596p pd=5.58u as=1.408p ps=5.04u w=4.4u l=0.6u
X1803 user_project_wrapper_0.IOVSS1 a_29676_197044# user_project_wrapper_0.analog_io[4] user_project_wrapper_0.IOVSS1 sg13_hv_nmos ad=1.408p pd=5.04u as=2.596p ps=5.58u w=4.4u l=0.6u
X1804 user_project_wrapper_0.sg13g2_IOPadAnalog_30.padres user_project_wrapper_0.analog_io[13] user_project_wrapper_0.IOVSS1 rppd l=2u w=1u
X1805 analog_io[18] a_355624_115444# IOVDD3 IOVDD3 sg13_hv_pmos ad=3.9294p pd=7.84u as=3.1302p ps=14.26u w=6.66u l=0.6u
X1806 VDD3 a_296625_189595# a_296731_189665# VDD3 sg13_lv_pmos ad=0.2603p pd=1.75u as=0.2603p ps=1.75u w=1.37u l=0.35u
X1807 user_project_wrapper_0.IOVSS1 user_project_wrapper_0.sg13g2_IOPadAnalog_26.padres dantenna l=0.64u w=3.1u
X1808 VDD3 user_project_wrapper_0.sg13g2_IOPadVdd_0.sg13g2_RCClampInverter_noptap_0.out user_project_wrapper_0.IOVSS1 user_project_wrapper_0.IOVSS1 sg13_hv_nmos ad=2.596p pd=5.58u as=1.408p ps=5.04u w=4.4u l=0.6u
X1809 user_project_wrapper_0.IOVSS1 a_29676_217444# user_project_wrapper_0.analog_io[5] user_project_wrapper_0.IOVSS1 sg13_hv_nmos ad=1.408p pd=5.04u as=2.596p ps=5.58u w=4.4u l=0.6u
X1810 VDD3 a_296626_197740# a_296732_200582# VDD3 sg13_lv_pmos ad=2.38p pd=14.68u as=1.33p ps=7.38u w=7u l=0.7u
X1811 a_311846_195517# user_project_wrapper_0.sg13g2_IOPadAnalog_29.padres a_309917_199879# VDD3 sg13_lv_pmos ad=0.24415p pd=1.665u as=0.24415p ps=1.665u w=1.285u l=0.35u
X1812 user_project_wrapper_0.IOVDD2 a_237844_41476# user_project_wrapper_0.analog_io[15] user_project_wrapper_0.IOVDD2 sg13_hv_pmos ad=2.1312p pd=7.3u as=3.9294p ps=7.84u w=6.66u l=0.6u
X1813 user_project_wrapper_0.IOVDD1 user_project_wrapper_0.sg13g2_IOPadIOVdd_1.sg13g2_Clamp_N43N43D4R_0.gate user_project_wrapper_0.IOVSS1 user_project_wrapper_0.IOVSS1 sg13_hv_nmos ad=2.596p pd=5.58u as=1.408p ps=5.04u w=4.4u l=0.6u
X1814 a_309917_199879# a_309516_194555# VDD3 VDD3 sg13_lv_pmos ad=0.19p pd=1.38u as=0.19p ps=1.38u w=1u l=0.7u
X1815 user_project_wrapper_0.analog_io[30] a_194687_324142# user_project_wrapper_0.IOVSS1 user_project_wrapper_0.IOVSS1 sg13_lv_nmos ad=0.912p pd=5.18u as=0.912p ps=5.18u w=4.8u l=0.13u
X1816 user_project_wrapper_0.IOVSS1 a_191234_326377# a_191438_326377# w_188704_326203# sg13_lv_pmos ad=0.38p pd=2.38u as=0.38p ps=2.38u w=2u l=0.13u
X1817 user_project_wrapper_0.VDD1 user_project_wrapper_0.sg13g2_IOPadVdd_2.sg13g2_RCClampInverter_noptap_0.out user_project_wrapper_0.IOVSS1 user_project_wrapper_0.IOVSS1 sg13_hv_nmos ad=2.596p pd=5.58u as=1.408p ps=5.04u w=4.4u l=0.6u
X1818 user_project_wrapper_0.analog_io[1] a_41476_135844# user_project_wrapper_0.IOVDD1 user_project_wrapper_0.IOVDD1 sg13_hv_pmos ad=3.9294p pd=7.84u as=2.1312p ps=7.3u w=6.66u l=0.6u
X1819 user_project_wrapper_0.IOVSS1 user_project_wrapper_0.sg13g2_IOPadAnalog_17.padres a_189286_327099# user_project_wrapper_0.IOVSS1 sg13_lv_nmos ad=0.34p pd=2.68u as=0.19p ps=1.38u w=1u l=0.13u
X1820 user_project_wrapper_0.IOVSS1 a_194279_327536# a_194687_324142# user_project_wrapper_0.IOVSS1 sg13_lv_pmos ad=1.824p pd=9.98u as=1.824p ps=9.98u w=9.6u l=0.13u
X1821 VDD3 a_296625_189595# a_296731_189665# VDD3 sg13_lv_pmos ad=0.2603p pd=1.75u as=0.2603p ps=1.75u w=1.37u l=0.35u
X1822 a_191234_325263# a_190824_325263# user_project_wrapper_0.IOVSS1 w_188704_326203# sg13_lv_pmos ad=0.68p pd=4.68u as=0.68p ps=4.68u w=2u l=0.13u
X1823 VDD3 a_296626_197740# a_296732_197880# VDD3 sg13_lv_pmos ad=1.33p pd=7.38u as=1.33p ps=7.38u w=7u l=0.7u
X1824 user_project_wrapper_0.IOVSS1 a_369296_258244# analog_io[25] user_project_wrapper_0.IOVSS1 sg13_hv_nmos ad=1.408p pd=5.04u as=2.596p ps=5.58u w=4.4u l=0.6u
X1825 user_project_wrapper_0.IOVDD1 user_project_wrapper_0.sg13g2_IOPadIOVdd_1.sg13g2_Clamp_N43N43D4R_0.gate user_project_wrapper_0.IOVSS1 user_project_wrapper_0.IOVSS1 sg13_hv_nmos ad=2.596p pd=5.58u as=1.408p ps=5.04u w=4.4u l=0.6u
X1826 user_project_wrapper_0.IOVSS1 user_project_wrapper_0.sg13g2_IOPadIOVdd_2.sg13g2_Clamp_N43N43D4R_0.gate user_project_wrapper_0.IOVDD4 user_project_wrapper_0.IOVSS1 sg13_hv_nmos ad=1.408p pd=5.04u as=2.596p ps=5.58u w=4.4u l=0.6u
X1827 VDD3 user_project_wrapper_0.sg13g2_IOPadVdd_0.sg13g2_RCClampInverter_noptap_0.out user_project_wrapper_0.IOVSS1 user_project_wrapper_0.IOVSS1 sg13_hv_nmos ad=2.596p pd=5.58u as=1.408p ps=5.04u w=4.4u l=0.6u
X1828 a_304995_198817# a_307232_196607# user_project_wrapper_0.IOVSS1 user_project_wrapper_0.IOVSS1 sg13_lv_nmos ad=0.6327p pd=3.71u as=0.6327p ps=3.71u w=3.33u l=0.2u
X1829 VDD3 a_296625_208423# a_296731_208493# VDD3 sg13_lv_pmos ad=0.2603p pd=1.75u as=0.2603p ps=1.75u w=1.37u l=0.35u
X1830 user_project_wrapper_0.IOVSS1 a_202114_326125# user_project_wrapper_0.analog_io[32] user_project_wrapper_0.IOVSS1 sg13_lv_pmos ad=1.824p pd=9.98u as=1.824p ps=9.98u w=9.6u l=0.13u
X1831 analog_io[20] a_369296_176644# user_project_wrapper_0.IOVSS1 user_project_wrapper_0.IOVSS1 sg13_hv_nmos ad=2.596p pd=5.58u as=1.408p ps=5.04u w=4.4u l=0.6u
X1832 user_project_wrapper_0.IOVSS1 a_194687_324142# user_project_wrapper_0.analog_io[30] user_project_wrapper_0.IOVSS1 sg13_lv_pmos ad=1.824p pd=9.98u as=1.824p ps=9.98u w=9.6u l=0.13u
X1833 user_project_wrapper_0.IOVDD4 a_156244_355624# user_project_wrapper_0.analog_io[29] user_project_wrapper_0.IOVDD4 sg13_hv_pmos ad=2.1312p pd=7.3u as=3.9294p ps=7.84u w=6.66u l=0.6u
X1834 user_project_wrapper_0.IOVSS1 user_project_wrapper_0.IOVSS1 dantenna l=1.26u w=27.78u
X1835 user_project_wrapper_0.sg13g2_IOPadVdd_2.sg13g2_RCClampInverter_noptap_0.out user_project_wrapper_0.sg13g2_IOPadVdd_2.sg13g2_RCClampResistor_0.p2 user_project_wrapper_0.IOVSS1 user_project_wrapper_0.IOVSS1 sg13_hv_nmos ad=1.71p pd=9.38u as=3.06p ps=18.68u w=9u l=0.5u
X1836 VDD3 a_296625_208423# a_296731_208493# VDD3 sg13_lv_pmos ad=0.2603p pd=1.75u as=0.2603p ps=1.75u w=1.37u l=0.35u
X1837 user_project_wrapper_0.analog_io[5] a_29676_217444# user_project_wrapper_0.IOVSS1 user_project_wrapper_0.IOVSS1 sg13_hv_nmos ad=2.596p pd=5.58u as=1.408p ps=5.04u w=4.4u l=0.6u
X1838 user_project_wrapper_0.IOVSS1 a_237844_369296# user_project_wrapper_0.analog_io[33] user_project_wrapper_0.IOVSS1 sg13_hv_nmos ad=1.408p pd=5.04u as=2.596p ps=5.58u w=4.4u l=0.6u
X1839 user_project_wrapper_0.IOVSS1 user_project_wrapper_0.sg13g2_IOPadVdd_1.sg13g2_RCClampInverter_noptap_0.out user_project_wrapper_0.VDD2 user_project_wrapper_0.IOVSS1 sg13_hv_nmos ad=1.408p pd=5.04u as=2.596p ps=5.58u w=4.4u l=0.6u
X1840 user_project_wrapper_0.IOVSS1 user_project_wrapper_0.sg13g2_IOPadIOVdd_0.sg13g2_Clamp_N43N43D4R_0.gate user_project_wrapper_0.IOVDD2 user_project_wrapper_0.IOVSS1 sg13_hv_nmos ad=1.408p pd=5.04u as=2.596p ps=5.58u w=4.4u l=0.6u
X1841 analog_io[20] a_355624_176644# IOVDD3 IOVDD3 sg13_hv_pmos ad=3.9294p pd=7.84u as=2.1312p ps=7.3u w=6.66u l=0.6u
X1842 user_project_wrapper_0.IOVSS1 user_project_wrapper_0.sg13g2_IOPadVdd_2.sg13g2_RCClampInverter_noptap_0.out user_project_wrapper_0.VDD1 user_project_wrapper_0.IOVSS1 sg13_hv_nmos ad=1.408p pd=5.04u as=2.596p ps=5.58u w=4.4u l=0.6u
X1843 user_project_wrapper_0.analog_io[35] a_213870_324142# user_project_wrapper_0.IOVSS1 user_project_wrapper_0.IOVSS1 sg13_lv_nmos ad=0.912p pd=5.18u as=0.912p ps=5.18u w=4.8u l=0.13u
X1844 a_309917_194695# a_296731_189665# a_307232_196607# VDD3 sg13_lv_pmos ad=0.24415p pd=1.665u as=0.24415p ps=1.665u w=1.285u l=0.35u
X1845 IOVDD3 user_project_wrapper_0.sg13g2_IOPadIOVdd_3.sg13g2_RCClampResistor_0.p2 user_project_wrapper_0.sg13g2_IOPadIOVdd_3.sg13g2_Clamp_N43N43D4R_0.gate IOVDD3 sg13_hv_pmos ad=1.33p pd=7.38u as=1.33p ps=7.38u w=7u l=0.5u
X1846 user_project_wrapper_0.sg13g2_IOPadVdd_3.sg13g2_RCClampInverter_noptap_0.out user_project_wrapper_0.sg13g2_IOPadVdd_3.sg13g2_RCClampResistor_0.p2 user_project_wrapper_0.IOVSS1 user_project_wrapper_0.IOVSS1 sg13_hv_pmos ad=1.33p pd=7.38u as=1.33p ps=7.38u w=7u l=0.5u
X1847 a_296731_208493# a_304889_198885# user_project_wrapper_0.IOVSS1 rppd l=19u w=0.6u
X1848 user_project_wrapper_0.analog_io[30] a_194687_324142# user_project_wrapper_0.IOVSS1 user_project_wrapper_0.IOVSS1 sg13_lv_nmos ad=0.912p pd=5.18u as=0.912p ps=5.18u w=4.8u l=0.13u
X1849 user_project_wrapper_0.sg13g2_IOPadVdd_2.sg13g2_RCClampInverter_noptap_0.out user_project_wrapper_0.sg13g2_IOPadVdd_2.sg13g2_RCClampResistor_0.p2 user_project_wrapper_0.VDD1 user_project_wrapper_0.VDD1 sg13_hv_pmos ad=1.33p pd=7.38u as=1.33p ps=7.38u w=7u l=0.5u
X1850 a_83490_125209# user_project_wrapper_0.sg13g2_IOPadIn$1_0.p2c a_83050_125173# user_project_wrapper_0.IOVSS1 sg13_lv_nmos ad=0.1406p pd=1.12u as=0.1406p ps=1.12u w=0.74u l=0.13u
X1851 QDLL_TOP_0.VOUT a_278644_41476# user_project_wrapper_0.IOVDD2 user_project_wrapper_0.IOVDD2 sg13_hv_pmos ad=3.9294p pd=7.84u as=3.1302p ps=14.26u w=6.66u l=0.6u
X1852 a_309917_194695# a_309516_194555# VDD3 VDD3 sg13_lv_pmos ad=0.19p pd=1.38u as=0.19p ps=1.38u w=1u l=0.7u
X1853 user_project_wrapper_0.analog_io[30] a_194687_324142# user_project_wrapper_0.IOVSS1 user_project_wrapper_0.IOVSS1 sg13_lv_nmos ad=0.912p pd=5.18u as=0.912p ps=5.18u w=4.8u l=0.13u
X1854 user_project_wrapper_0.analog_io[13] a_197044_41476# user_project_wrapper_0.IOVDD2 user_project_wrapper_0.IOVDD2 sg13_hv_pmos ad=3.9294p pd=7.84u as=2.1312p ps=7.3u w=6.66u l=0.6u
X1855 VDD3 a_309516_194555# a_309917_199879# VDD3 sg13_lv_pmos ad=0.19p pd=1.38u as=0.19p ps=1.38u w=1u l=0.7u
X1856 IOVDD3 user_project_wrapper_0.sg13g2_IOPadIOVdd_3.sg13g2_Clamp_N43N43D4R_0.gate user_project_wrapper_0.IOVSS1 user_project_wrapper_0.IOVSS1 sg13_hv_nmos ad=2.596p pd=5.58u as=1.408p ps=5.04u w=4.4u l=0.6u
X1857 a_296731_189665# a_296625_189595# VDD3 VDD3 sg13_lv_pmos ad=0.2603p pd=1.75u as=0.2603p ps=1.75u w=1.37u l=0.35u
X1858 a_210417_328605# a_210007_328605# user_project_wrapper_0.IOVSS1 w_207887_327938# sg13_lv_pmos ad=0.68p pd=4.68u as=0.68p ps=4.68u w=2u l=0.13u
X1859 user_project_wrapper_0.analog_io[4] a_29676_197044# user_project_wrapper_0.IOVSS1 user_project_wrapper_0.IOVSS1 sg13_hv_nmos ad=2.596p pd=5.58u as=1.408p ps=5.04u w=4.4u l=0.6u
X1860 user_project_wrapper_0.IOVSS1 a_278644_369296# user_project_wrapper_0.analog_io[35] user_project_wrapper_0.IOVSS1 sg13_hv_nmos ad=1.408p pd=5.04u as=2.596p ps=5.58u w=4.4u l=0.6u
X1861 user_project_wrapper_0.IOVSS1 a_29676_135844# user_project_wrapper_0.analog_io[1] user_project_wrapper_0.IOVSS1 sg13_hv_nmos ad=1.408p pd=5.04u as=2.596p ps=5.58u w=4.4u l=0.6u
X1862 user_project_wrapper_0.IOVSS1 user_project_wrapper_0.sg13g2_IOPadIOVdd_1.sg13g2_Clamp_N43N43D4R_0.gate user_project_wrapper_0.IOVDD1 user_project_wrapper_0.IOVSS1 sg13_hv_nmos ad=1.408p pd=5.04u as=2.596p ps=5.58u w=4.4u l=0.6u
X1863 a_79025_135674# a_78219_134797# a_79038_134366# user_project_wrapper_0.VDD1 sg13_lv_pmos ad=1.7p pd=10.68u as=0.95p ps=5.38u w=5u l=0.3u
X1864 user_project_wrapper_0.IOVSS1 a_307232_196607# a_304995_198817# user_project_wrapper_0.IOVSS1 sg13_lv_nmos ad=0.6327p pd=3.71u as=0.6327p ps=3.71u w=3.33u l=0.2u
X1865 user_project_wrapper_0.IOVSS1 user_project_wrapper_0.sg13g2_IOPadVdd_0.sg13g2_RCClampInverter_noptap_0.out VDD3 user_project_wrapper_0.IOVSS1 sg13_hv_nmos ad=1.408p pd=5.04u as=2.596p ps=5.58u w=4.4u l=0.6u
X1866 user_project_wrapper_0.IOVSS1 a_194687_324142# user_project_wrapper_0.analog_io[30] user_project_wrapper_0.IOVSS1 sg13_lv_pmos ad=1.824p pd=9.98u as=1.824p ps=9.98u w=9.6u l=0.13u
X1867 user_project_wrapper_0.IOVDD4 user_project_wrapper_0.sg13g2_IOPadIOVdd_2.sg13g2_Clamp_N43N43D4R_0.gate user_project_wrapper_0.IOVSS1 user_project_wrapper_0.IOVSS1 sg13_hv_nmos ad=2.596p pd=5.58u as=1.408p ps=5.04u w=4.4u l=0.6u
X1868 user_project_wrapper_0.analog_io[6] user_project_wrapper_0.sg13g2_IOPadAnalog_14.padres user_project_wrapper_0.IOVSS1 rppd l=2u w=1u
X1869 user_project_wrapper_0.VDD1 user_project_wrapper_0.sg13g2_IOPadVdd_2.sg13g2_RCClampInverter_noptap_0.out user_project_wrapper_0.IOVSS1 user_project_wrapper_0.IOVSS1 sg13_hv_nmos ad=2.596p pd=5.58u as=1.408p ps=5.04u w=4.4u l=0.6u
X1870 user_project_wrapper_0.analog_io[14] a_217444_41476# user_project_wrapper_0.IOVDD2 user_project_wrapper_0.IOVDD2 sg13_hv_pmos ad=3.9294p pd=7.84u as=2.1312p ps=7.3u w=6.66u l=0.6u
X1871 VDD3 a_296626_197740# a_296732_197880# VDD3 sg13_lv_pmos ad=2.38p pd=14.68u as=1.33p ps=7.38u w=7u l=0.7u
X1872 user_project_wrapper_0.IOVDD4 a_115444_355624# user_project_wrapper_0.IOVDD4 rppd l=12.9u w=0.5u
X1873 a_189395_101343# a_189148_101407# QDLL_TOP_0.VDD QDLL_TOP_0.VDD sg13_lv_pmos ad=0.3808p pd=2.92u as=0.2245p ps=1.53u w=1.12u l=0.13u
X1874 user_project_wrapper_0.IOVSS1 a_206201_328627# a_205385_326221# user_project_wrapper_0.IOVSS1 sg13_lv_pmos ad=3.264p pd=19.88u as=1.824p ps=9.98u w=9.6u l=0.13u
X1875 a_190501_327491# a_189184_327491# user_project_wrapper_0.IOVSS1 user_project_wrapper_0.IOVSS1 sg13_lv_nmos ad=0.34p pd=2.68u as=0.34p ps=2.68u w=1u l=0.13u
X1876 a_271172_100118# a_270512_100118# QDLL_TOP_0.VDD QDLL_TOP_0.VDD sg13_lv_pmos ad=0.2128p pd=1.5u as=0.3808p ps=2.92u w=1.12u l=0.13u
X1877 user_project_wrapper_0.analog_io[35] a_213870_324142# user_project_wrapper_0.IOVSS1 user_project_wrapper_0.IOVSS1 sg13_lv_nmos ad=0.912p pd=5.18u as=0.912p ps=5.18u w=4.8u l=0.13u
X1878 user_project_wrapper_0.IOVDD2 a_278644_41476# QDLL_TOP_0.VOUT user_project_wrapper_0.IOVDD2 sg13_hv_pmos ad=3.1302p pd=14.26u as=3.9294p ps=7.84u w=6.66u l=0.6u
X1879 a_189756_325263# a_188920_324155# user_project_wrapper_0.IOVSS1 user_project_wrapper_0.IOVSS1 sg13_lv_nmos ad=0.19p pd=1.38u as=0.34p ps=2.68u w=1u l=0.13u
X1880 user_project_wrapper_0.IOVSS1 a_210417_326377# a_210621_326377# w_207887_326203# sg13_lv_pmos ad=0.38p pd=2.38u as=0.38p ps=2.38u w=2u l=0.13u
X1881 user_project_wrapper_0.analog_io[35] a_213870_324142# user_project_wrapper_0.IOVSS1 user_project_wrapper_0.IOVSS1 sg13_lv_nmos ad=0.912p pd=5.18u as=0.912p ps=5.18u w=4.8u l=0.13u
X1882 user_project_wrapper_0.IOVSS1 a_369296_176644# analog_io[20] user_project_wrapper_0.IOVSS1 sg13_hv_nmos ad=2.068p pd=9.74u as=2.596p ps=5.58u w=4.4u l=0.6u
X1883 a_309917_194695# a_309516_194555# VDD3 VDD3 sg13_lv_pmos ad=0.19p pd=1.38u as=0.19p ps=1.38u w=1u l=0.7u
X1884 user_project_wrapper_0.IOVSS1 a_29676_217444# user_project_wrapper_0.analog_io[5] user_project_wrapper_0.IOVSS1 sg13_hv_nmos ad=1.408p pd=5.04u as=2.596p ps=5.58u w=4.4u l=0.6u
X1885 user_project_wrapper_0.IOVSS1 a_156244_369296# user_project_wrapper_0.analog_io[29] user_project_wrapper_0.IOVSS1 sg13_hv_nmos ad=1.408p pd=5.04u as=2.596p ps=5.58u w=4.4u l=0.6u
X1886 user_project_wrapper_0.IOVDD1 user_project_wrapper_0.sg13g2_IOPadIOVdd_1.sg13g2_Clamp_N43N43D4R_0.gate user_project_wrapper_0.IOVSS1 user_project_wrapper_0.IOVSS1 sg13_hv_nmos ad=2.596p pd=5.58u as=1.408p ps=5.04u w=4.4u l=0.6u
X1887 user_project_wrapper_0.IOVDD2 a_237844_41476# user_project_wrapper_0.analog_io[15] user_project_wrapper_0.IOVDD2 sg13_hv_pmos ad=2.1312p pd=7.3u as=3.9294p ps=7.84u w=6.66u l=0.6u
X1888 a_304196_197873# a_304090_197941# a_296625_189595# user_project_wrapper_0.IOVSS1 sg13_lv_nmos ad=0.361p pd=2.28u as=0.361p ps=2.28u w=1.9u l=0.16u
X1889 user_project_wrapper_0.IOVSS1 user_project_wrapper_0.sg13g2_IOPadAnalog_17.padres dantenna l=3.1u w=0.64u
X1890 user_project_wrapper_0.IOVSS1 a_209230_324119# a_206547_324106# user_project_wrapper_0.IOVSS1 sg13_lv_nmos ad=0.19p pd=1.38u as=0.34p ps=2.68u w=1u l=0.13u
X1891 user_project_wrapper_0.IOVSS1 a_217444_29676# user_project_wrapper_0.analog_io[14] user_project_wrapper_0.IOVSS1 sg13_hv_nmos ad=2.068p pd=9.74u as=2.596p ps=5.58u w=4.4u l=0.6u
X1892 user_project_wrapper_0.IOVDD4 a_115444_355624# user_project_wrapper_0.analog_io[27] user_project_wrapper_0.IOVDD4 sg13_hv_pmos ad=2.1312p pd=7.3u as=3.9294p ps=7.84u w=6.66u l=0.6u
X1893 a_91911_129060# a_91090_129425# user_project_wrapper_0.VDD1 user_project_wrapper_0.VDD1 sg13_lv_pmos ad=0.3808p pd=2.92u as=0.3808p ps=2.92u w=1.12u l=0.13u
X1894 a_296731_189665# a_296625_189595# VDD3 VDD3 sg13_lv_pmos ad=0.2603p pd=1.75u as=0.2603p ps=1.75u w=1.37u l=0.35u
X1895 a_296731_208493# a_296625_208423# VDD3 VDD3 sg13_lv_pmos ad=0.2603p pd=1.75u as=0.2603p ps=1.75u w=1.37u l=0.35u
X1896 user_project_wrapper_0.analog_io[0] a_41476_115444# user_project_wrapper_0.IOVDD1 user_project_wrapper_0.IOVDD1 sg13_hv_pmos ad=3.9294p pd=7.84u as=2.1312p ps=7.3u w=6.66u l=0.6u
X1897 user_project_wrapper_0.IOVSS1 a_182931_326125# user_project_wrapper_0.analog_io[27] user_project_wrapper_0.IOVSS1 sg13_lv_pmos ad=1.824p pd=9.98u as=1.824p ps=9.98u w=9.6u l=0.13u
X1898 user_project_wrapper_0.IOVSS1 user_project_wrapper_0.sg13g2_IOPadIOVdd_2.sg13g2_Clamp_N43N43D4R_0.gate user_project_wrapper_0.IOVDD4 user_project_wrapper_0.IOVSS1 sg13_hv_nmos ad=1.408p pd=5.04u as=2.596p ps=5.58u w=4.4u l=0.6u
X1899 a_296625_189595# a_304090_197941# a_304196_197873# user_project_wrapper_0.IOVSS1 sg13_lv_nmos ad=0.361p pd=2.28u as=0.646p ps=4.48u w=1.9u l=0.16u
X1900 user_project_wrapper_0.VDD1 user_project_wrapper_0.sg13g2_IOPadVdd_2.sg13g2_RCClampInverter_noptap_0.out user_project_wrapper_0.IOVSS1 user_project_wrapper_0.IOVSS1 sg13_hv_nmos ad=2.596p pd=5.58u as=1.408p ps=5.04u w=4.4u l=0.6u
X1901 a_309917_199879# a_309516_194555# VDD3 VDD3 sg13_lv_pmos ad=0.19p pd=1.38u as=0.19p ps=1.38u w=1u l=0.7u
X1902 user_project_wrapper_0.analog_io[33] a_237844_355624# user_project_wrapper_0.IOVDD4 user_project_wrapper_0.IOVDD4 sg13_hv_pmos ad=3.9294p pd=7.84u as=2.1312p ps=7.3u w=6.66u l=0.6u
X1903 QDLL_TOP_0.VDD a_190389_101343# user_project_wrapper_0.analog_io[15] QDLL_TOP_0.VDD sg13_lv_pmos ad=0.2128p pd=1.5u as=0.2128p ps=1.5u w=1.12u l=0.13u
X1904 user_project_wrapper_0.analog_io[30] a_176644_355624# user_project_wrapper_0.IOVDD4 user_project_wrapper_0.IOVDD4 sg13_hv_pmos ad=3.9294p pd=7.84u as=2.1312p ps=7.3u w=6.66u l=0.6u
X1905 a_82770_125209# a_82667_125418# user_project_wrapper_0.VDD1 user_project_wrapper_0.VDD1 sg13_lv_pmos ad=0.2128p pd=1.5u as=0.3808p ps=2.92u w=1.12u l=0.13u
X1906 user_project_wrapper_0.sg13g2_IOPadIOVdd_3.sg13g2_Clamp_N43N43D4R_0.gate user_project_wrapper_0.sg13g2_IOPadIOVdd_3.sg13g2_RCClampResistor_0.p2 user_project_wrapper_0.IOVSS1 user_project_wrapper_0.IOVSS1 sg13_hv_nmos ad=1.71p pd=9.38u as=1.71p ps=9.38u w=9u l=0.5u
X1907 a_209905_329719# a_208939_329719# user_project_wrapper_0.IOVSS1 user_project_wrapper_0.IOVSS1 sg13_lv_nmos ad=0.19p pd=1.38u as=0.34p ps=2.68u w=1u l=0.13u
X1908 user_project_wrapper_0.IOVSS1 a_271172_100118# QDLL_TOP_0.VOUT user_project_wrapper_0.IOVSS1 sg13_lv_nmos ad=0.1406p pd=1.12u as=0.1406p ps=1.12u w=0.74u l=0.13u
X1909 a_311189_211724# a_296731_208493# a_313884_211353# user_project_wrapper_0.IOVSS1 sg13_lv_nmos ad=1.9p pd=10.38u as=1.9p ps=10.38u w=10u l=0.5u
X1910 a_296731_208493# a_296625_208423# VDD3 VDD3 sg13_lv_pmos ad=0.2603p pd=1.75u as=0.4658p ps=3.42u w=1.37u l=0.35u
X1911 user_project_wrapper_0.IOVDD4 a_156244_355624# user_project_wrapper_0.analog_io[29] user_project_wrapper_0.IOVDD4 sg13_hv_pmos ad=2.1312p pd=7.3u as=3.9294p ps=7.84u w=6.66u l=0.6u
X1912 a_296731_189665# a_296625_189595# VDD3 VDD3 sg13_lv_pmos ad=0.2603p pd=1.75u as=0.2603p ps=1.75u w=1.37u l=0.35u
X1913 VDD3 a_296625_189595# a_296731_189665# VDD3 sg13_lv_pmos ad=0.4658p pd=3.42u as=0.2603p ps=1.75u w=1.37u l=0.35u
X1914 user_project_wrapper_0.IOVSS1 user_project_wrapper_0.sg13g2_IOPadIOVdd_1.sg13g2_RCClampResistor_0.p2 user_project_wrapper_0.sg13g2_IOPadIOVdd_1.sg13g2_Clamp_N43N43D4R_0.gate user_project_wrapper_0.IOVSS1 sg13_hv_nmos ad=1.71p pd=9.38u as=1.71p ps=9.38u w=9u l=0.5u
X1915 user_project_wrapper_0.IOVSS1 a_176644_29676# user_project_wrapper_0.analog_io[12] user_project_wrapper_0.IOVSS1 sg13_hv_nmos ad=1.408p pd=5.04u as=2.596p ps=5.58u w=4.4u l=0.6u
X1916 IOVDD3 a_355624_278644# analog_io[26] IOVDD3 sg13_hv_pmos ad=3.1302p pd=14.26u as=3.9294p ps=7.84u w=6.66u l=0.6u
X1917 user_project_wrapper_0.analog_io[14] a_217444_41476# user_project_wrapper_0.IOVDD2 user_project_wrapper_0.IOVDD2 sg13_hv_pmos ad=3.9294p pd=7.84u as=2.1312p ps=7.3u w=6.66u l=0.6u
X1918 user_project_wrapper_0.IOVSS1 a_202114_326125# user_project_wrapper_0.analog_io[32] user_project_wrapper_0.IOVSS1 sg13_lv_pmos ad=1.824p pd=9.98u as=1.824p ps=9.98u w=9.6u l=0.13u
X1919 a_296731_189665# a_296625_189595# VDD3 VDD3 sg13_lv_pmos ad=0.2603p pd=1.75u as=0.2603p ps=1.75u w=1.37u l=0.35u
X1920 user_project_wrapper_0.IOVDD4 a_258244_355624# user_project_wrapper_0.analog_io[34] user_project_wrapper_0.IOVDD4 sg13_hv_pmos ad=2.1312p pd=7.3u as=3.9294p ps=7.84u w=6.66u l=0.6u
X1921 user_project_wrapper_0.IOVSS1 a_156244_369296# user_project_wrapper_0.analog_io[29] user_project_wrapper_0.IOVSS1 sg13_hv_nmos ad=2.068p pd=9.74u as=2.596p ps=5.58u w=4.4u l=0.6u
X1922 user_project_wrapper_0.sg13g2_IOPadAnalog_26.padres analog_io[25] user_project_wrapper_0.IOVSS1 rppd l=2u w=1u
X1923 user_project_wrapper_0.sg13g2_IOPadIOVdd_3.sg13g2_Clamp_N43N43D4R_0.gate user_project_wrapper_0.sg13g2_IOPadIOVdd_3.sg13g2_RCClampResistor_0.p2 user_project_wrapper_0.IOVSS1 user_project_wrapper_0.IOVSS1 sg13_hv_nmos ad=1.71p pd=9.38u as=1.71p ps=9.38u w=9u l=0.5u
X1924 a_35456_75355# a_39542_75025# user_project_wrapper_0.IOVSS1 rppd l=20u w=1u
X1925 user_project_wrapper_0.analog_io[16] a_258244_29676# user_project_wrapper_0.IOVSS1 user_project_wrapper_0.IOVSS1 sg13_hv_nmos ad=2.596p pd=5.58u as=1.408p ps=5.04u w=4.4u l=0.6u
X1926 analog_io[19] a_369296_135844# user_project_wrapper_0.IOVSS1 user_project_wrapper_0.IOVSS1 sg13_hv_nmos ad=2.596p pd=5.58u as=1.408p ps=5.04u w=4.4u l=0.6u
X1927 user_project_wrapper_0.IOVSS1 user_project_wrapper_0.sg13g2_IOPadVdd_2.sg13g2_RCClampInverter_noptap_0.out user_project_wrapper_0.VDD1 user_project_wrapper_0.IOVSS1 sg13_hv_nmos ad=1.408p pd=5.04u as=2.596p ps=5.58u w=4.4u l=0.6u
X1928 user_project_wrapper_0.analog_io[16] a_258244_41476# user_project_wrapper_0.IOVDD2 user_project_wrapper_0.IOVDD2 sg13_hv_pmos ad=3.9294p pd=7.84u as=2.1312p ps=7.3u w=6.66u l=0.6u
X1929 user_project_wrapper_0.analog_io[32] a_202114_326125# user_project_wrapper_0.IOVSS1 user_project_wrapper_0.IOVSS1 sg13_lv_nmos ad=0.912p pd=5.18u as=0.912p ps=5.18u w=4.8u l=0.13u
X1930 user_project_wrapper_0.sg13g2_IOPadAnalog_6.padres user_project_wrapper_0.analog_io[16] user_project_wrapper_0.IOVSS1 rppd l=2u w=1u
X1931 VDD3 a_296625_189595# a_296731_189665# VDD3 sg13_lv_pmos ad=0.4658p pd=3.42u as=0.2603p ps=1.75u w=1.37u l=0.35u
X1932 IOVDD3 user_project_wrapper_0.sg13g2_IOPadIOVdd_3.sg13g2_Clamp_N43N43D4R_0.gate user_project_wrapper_0.IOVSS1 user_project_wrapper_0.IOVSS1 sg13_hv_nmos ad=2.596p pd=5.58u as=1.408p ps=5.04u w=4.4u l=0.6u
X1933 IOVDD3 user_project_wrapper_0.sg13g2_IOPadIOVdd_3.sg13g2_Clamp_N43N43D4R_0.gate user_project_wrapper_0.IOVSS1 user_project_wrapper_0.IOVSS1 sg13_hv_nmos ad=2.596p pd=5.58u as=1.408p ps=5.04u w=4.4u l=0.6u
X1934 user_project_wrapper_0.IOVSS1 user_project_wrapper_0.sg13g2_IOPadIOVdd_1.sg13g2_RCClampResistor_0.p2 user_project_wrapper_0.sg13g2_IOPadIOVdd_1.sg13g2_Clamp_N43N43D4R_0.gate user_project_wrapper_0.IOVSS1 sg13_hv_nmos ad=1.71p pd=9.38u as=1.71p ps=9.38u w=9u l=0.5u
X1935 user_project_wrapper_0.analog_io[14] a_217444_41476# user_project_wrapper_0.IOVDD2 user_project_wrapper_0.IOVDD2 sg13_hv_pmos ad=3.9294p pd=7.84u as=2.1312p ps=7.3u w=6.66u l=0.6u
X1936 a_313884_185173# analog_io[20] a_311108_179669# user_project_wrapper_0.IOVSS1 sg13_lv_nmos ad=1.9p pd=10.38u as=1.9p ps=10.38u w=10u l=0.5u
X1937 VDD3 user_project_wrapper_0.sg13g2_IOPadVdd_0.sg13g2_RCClampInverter_noptap_0.out user_project_wrapper_0.IOVSS1 user_project_wrapper_0.IOVSS1 sg13_hv_nmos ad=2.596p pd=5.58u as=1.408p ps=5.04u w=4.4u l=0.6u
X1938 analog_io[20] a_355624_156244# IOVDD3 IOVDD3 sg13_hv_pmos ad=3.9294p pd=7.84u as=2.1312p ps=7.3u w=6.66u l=0.6u
X1939 a_189184_325263# a_188920_324155# user_project_wrapper_0.IOVSS1 user_project_wrapper_0.IOVSS1 sg13_lv_nmos ad=0.19p pd=1.38u as=0.34p ps=2.68u w=1u l=0.13u
X1940 VDD3 a_296625_189595# a_296731_189665# VDD3 sg13_lv_pmos ad=0.2603p pd=1.75u as=0.2603p ps=1.75u w=1.37u l=0.35u
X1941 user_project_wrapper_0.IOVDD1 user_project_wrapper_0.sg13g2_IOPadIOVdd_1.sg13g2_Clamp_N43N43D4R_0.gate user_project_wrapper_0.IOVSS1 user_project_wrapper_0.IOVSS1 sg13_hv_nmos ad=2.596p pd=5.58u as=1.408p ps=5.04u w=4.4u l=0.6u
X1942 a_296731_208493# a_296625_208423# VDD3 VDD3 sg13_lv_pmos ad=0.2603p pd=1.75u as=0.2603p ps=1.75u w=1.37u l=0.35u
X1943 user_project_wrapper_0.IOVSS1 user_project_wrapper_0.sg13g2_IOPadVdd_3.sg13g2_RCClampResistor_0.p2 user_project_wrapper_0.sg13g2_IOPadVdd_3.sg13g2_RCClampInverter_noptap_0.out user_project_wrapper_0.IOVSS1 sg13_hv_nmos ad=1.71p pd=9.38u as=1.71p ps=9.38u w=9u l=0.5u
X1944 IOVDD3 user_project_wrapper_0.sg13g2_IOPadIOVdd_3.sg13g2_RCClampResistor_0.p2 user_project_wrapper_0.sg13g2_IOPadIOVdd_3.sg13g2_Clamp_N43N43D4R_0.gate IOVDD3 sg13_hv_pmos ad=1.33p pd=7.38u as=1.33p ps=7.38u w=7u l=0.5u
X1945 user_project_wrapper_0.sg13g2_IOPadIOVdd_2.sg13g2_Clamp_N43N43D4R_0.gate user_project_wrapper_0.sg13g2_IOPadIOVdd_2.sg13g2_RCClampResistor_0.p2 user_project_wrapper_0.IOVDD4 user_project_wrapper_0.IOVDD4 sg13_hv_pmos ad=1.33p pd=7.38u as=1.33p ps=7.38u w=7u l=0.5u
X1946 user_project_wrapper_0.IOVSS1 a_79038_125686# a_79038_125686# user_project_wrapper_0.IOVSS1 sg13_lv_nmos ad=0.1428p pd=1.52u as=0.1428p ps=1.52u w=0.42u l=0.56u
X1947 analog_io[26] a_355624_278644# IOVDD3 IOVDD3 sg13_hv_pmos ad=3.9294p pd=7.84u as=2.1312p ps=7.3u w=6.66u l=0.6u
X1948 a_304196_197873# a_304090_197941# a_296625_189595# user_project_wrapper_0.IOVSS1 sg13_lv_nmos ad=0.361p pd=2.28u as=0.361p ps=2.28u w=1.9u l=0.16u
X1949 user_project_wrapper_0.IOVSS1 a_210307_324119# a_209940_324686# user_project_wrapper_0.IOVSS1 sg13_lv_nmos ad=0.34p pd=2.68u as=0.34p ps=2.68u w=1u l=0.65u
X1950 user_project_wrapper_0.IOVSS1 a_194279_327536# a_194687_324142# user_project_wrapper_0.IOVSS1 sg13_lv_pmos ad=1.824p pd=9.98u as=1.824p ps=9.98u w=9.6u l=0.13u
X1951 user_project_wrapper_0.sg13g2_IOPadVdd_2.sg13g2_RCClampInverter_noptap_0.out user_project_wrapper_0.sg13g2_IOPadVdd_2.sg13g2_RCClampResistor_0.p2 user_project_wrapper_0.VDD1 user_project_wrapper_0.VDD1 sg13_hv_pmos ad=1.33p pd=7.38u as=1.33p ps=7.38u w=7u l=0.5u
X1952 QDLL_TOP_0.VDD a_188184_101343# a_188296_101407# QDLL_TOP_0.VDD sg13_lv_pmos ad=0.2254p pd=1.53u as=0.34p ps=2.68u w=1u l=0.5u
X1953 user_project_wrapper_0.sg13g2_IOPadVdd_1.sg13g2_RCClampInverter_noptap_0.out user_project_wrapper_0.sg13g2_IOPadVdd_1.sg13g2_RCClampResistor_0.p2 user_project_wrapper_0.VDD2 user_project_wrapper_0.VDD2 sg13_hv_pmos ad=1.33p pd=7.38u as=1.33p ps=7.38u w=7u l=0.5u
X1954 analog_io[23] a_369296_237844# user_project_wrapper_0.IOVSS1 user_project_wrapper_0.IOVSS1 sg13_hv_nmos ad=2.596p pd=5.58u as=1.408p ps=5.04u w=4.4u l=0.6u
X1955 user_project_wrapper_0.IOVSS1 user_project_wrapper_0.sg13g2_IOPadVdd_3.sg13g2_RCClampInverter_noptap_0.out user_project_wrapper_0.IOVSS1 user_project_wrapper_0.IOVSS1 sg13_hv_nmos ad=1.408p pd=5.04u as=0 ps=0 w=4.4u l=0.6u
X1956 user_project_wrapper_0.IOVDD4 a_258244_355624# user_project_wrapper_0.analog_io[34] user_project_wrapper_0.IOVDD4 sg13_hv_pmos ad=3.1302p pd=14.26u as=3.9294p ps=7.84u w=6.66u l=0.6u
X1957 user_project_wrapper_0.IOVSS1 user_project_wrapper_0.sg13g2_IOPadVdd_2.sg13g2_RCClampInverter_noptap_0.out user_project_wrapper_0.VDD1 user_project_wrapper_0.IOVSS1 sg13_hv_nmos ad=1.408p pd=5.04u as=2.596p ps=5.58u w=4.4u l=0.6u
X1958 a_309917_194695# a_309516_194555# VDD3 VDD3 sg13_lv_pmos ad=0.19p pd=1.38u as=0.19p ps=1.38u w=1u l=0.7u
X1959 VDD3 a_309516_194555# a_309917_199879# VDD3 sg13_lv_pmos ad=0.19p pd=1.38u as=0.19p ps=1.38u w=1u l=0.7u
X1960 analog_io[23] a_355624_237844# IOVDD3 IOVDD3 sg13_hv_pmos ad=3.9294p pd=7.84u as=2.1312p ps=7.3u w=6.66u l=0.6u
X1961 user_project_wrapper_0.IOVSS1 user_project_wrapper_0.sg13g2_IOPadVdd_3.sg13g2_RCClampInverter_noptap_0.out user_project_wrapper_0.IOVSS1 user_project_wrapper_0.IOVSS1 sg13_hv_nmos ad=1.408p pd=5.04u as=0 ps=0 w=4.4u l=0.6u
X1962 VDD3 a_296625_189595# a_296731_189665# VDD3 sg13_lv_pmos ad=0.2603p pd=1.75u as=0.2603p ps=1.75u w=1.37u l=0.35u
X1963 user_project_wrapper_0.IOVSS1 a_194687_324142# user_project_wrapper_0.analog_io[30] user_project_wrapper_0.IOVSS1 sg13_lv_pmos ad=1.824p pd=9.98u as=1.824p ps=9.98u w=9.6u l=0.13u
X1964 a_202114_326125# a_205385_326221# user_project_wrapper_0.IOVSS1 user_project_wrapper_0.IOVSS1 sg13_lv_nmos ad=0.912p pd=5.18u as=0.912p ps=5.18u w=4.8u l=0.13u
X1965 user_project_wrapper_0.IOVSS1 user_project_wrapper_0.analog_io[33] dantenna l=1.26u w=27.78u
X1966 VDD3 a_309516_194555# a_309917_194695# VDD3 sg13_lv_pmos ad=0.19p pd=1.38u as=0.19p ps=1.38u w=1u l=0.7u
X1967 user_project_wrapper_0.IOVDD1 a_41476_115444# user_project_wrapper_0.analog_io[0] user_project_wrapper_0.IOVDD1 sg13_hv_pmos ad=2.1312p pd=7.3u as=3.9294p ps=7.84u w=6.66u l=0.6u
X1968 user_project_wrapper_0.IOVSS1 user_project_wrapper_0.sg13g2_IOPadIOVdd_1.sg13g2_Clamp_N43N43D4R_0.gate user_project_wrapper_0.IOVDD1 user_project_wrapper_0.IOVSS1 sg13_hv_nmos ad=1.408p pd=5.04u as=2.596p ps=5.58u w=4.4u l=0.6u
X1969 user_project_wrapper_0.IOVSS1 user_project_wrapper_0.sg13g2_IOPadIOVdd_2.sg13g2_Clamp_N43N43D4R_0.gate user_project_wrapper_0.IOVDD4 user_project_wrapper_0.IOVSS1 sg13_hv_nmos ad=1.408p pd=5.04u as=2.596p ps=5.58u w=4.4u l=0.6u
X1970 a_79025_124824# a_78220_123062# a_79038_123516# user_project_wrapper_0.VDD1 sg13_lv_pmos ad=1.7p pd=10.68u as=0.95p ps=5.38u w=5u l=0.3u
X1971 a_82859_239842# a_82118_239118# a_82846_240684# user_project_wrapper_0.VDD1 sg13_lv_pmos ad=0.95p pd=5.38u as=1.7p ps=10.68u w=5u l=0.3u
X1972 user_project_wrapper_0.IOVDD2 a_135844_41476# user_project_wrapper_0.analog_io[10] user_project_wrapper_0.IOVDD2 sg13_hv_pmos ad=2.1312p pd=7.3u as=3.9294p ps=7.84u w=6.66u l=0.6u
X1973 user_project_wrapper_0.IOVSS1 user_project_wrapper_0.IOVSS1 user_project_wrapper_0.IOVSS1 rppd l=0.5u w=0.5u
X1974 a_189729_99046# a_189395_99046# user_project_wrapper_0.IOVSS1 user_project_wrapper_0.IOVSS1 sg13_lv_nmos ad=0.1406p pd=1.12u as=0.2516p ps=2.16u w=0.74u l=0.13u
X1975 a_210109_325785# a_208367_325263# a_210007_325263# w_207887_326203# sg13_lv_pmos ad=0.38p pd=2.38u as=0.38p ps=2.38u w=2u l=0.13u
X1976 a_187364_324106# a_190047_324119# user_project_wrapper_0.IOVSS1 w_188806_323975# sg13_lv_pmos ad=0.38p pd=2.38u as=0.38p ps=2.38u w=2u l=0.13u
X1977 user_project_wrapper_0.analog_io[35] user_project_wrapper_0.sg13g2_IOPadAnalog_23.padres user_project_wrapper_0.IOVSS1 rppd l=2u w=1u
X1978 user_project_wrapper_0.analog_io[16] a_258244_41476# user_project_wrapper_0.IOVDD2 user_project_wrapper_0.IOVDD2 sg13_hv_pmos ad=3.9294p pd=7.84u as=2.1312p ps=7.3u w=6.66u l=0.6u
X1979 user_project_wrapper_0.analog_io[30] a_194687_324142# user_project_wrapper_0.IOVSS1 user_project_wrapper_0.IOVSS1 sg13_lv_nmos ad=0.912p pd=5.18u as=0.912p ps=5.18u w=4.8u l=0.13u
X1980 VDD3 a_296625_208423# a_296731_208493# VDD3 sg13_lv_pmos ad=0.2603p pd=1.75u as=0.2603p ps=1.75u w=1.37u l=0.35u
X1981 user_project_wrapper_0.analog_io[5] a_41476_217444# user_project_wrapper_0.IOVDD1 user_project_wrapper_0.IOVDD1 sg13_hv_pmos ad=3.9294p pd=7.84u as=2.1312p ps=7.3u w=6.66u l=0.6u
X1982 user_project_wrapper_0.analog_io[14] a_217444_41476# user_project_wrapper_0.IOVDD2 user_project_wrapper_0.IOVDD2 sg13_hv_pmos ad=3.9294p pd=7.84u as=2.1312p ps=7.3u w=6.66u l=0.6u
X1983 VDD3 a_309516_194555# a_309917_194695# VDD3 sg13_lv_pmos ad=0.19p pd=1.38u as=0.19p ps=1.38u w=1u l=0.7u
X1984 a_309917_194695# a_309516_194555# VDD3 VDD3 sg13_lv_pmos ad=0.19p pd=1.38u as=0.19p ps=1.38u w=1u l=0.7u
X1985 user_project_wrapper_0.IOVDD1 a_41476_197044# user_project_wrapper_0.analog_io[4] user_project_wrapper_0.IOVDD1 sg13_hv_pmos ad=2.1312p pd=7.3u as=3.9294p ps=7.84u w=6.66u l=0.6u
X1986 user_project_wrapper_0.IOVSS1 a_194687_324142# user_project_wrapper_0.analog_io[30] user_project_wrapper_0.IOVSS1 sg13_lv_pmos ad=1.824p pd=9.98u as=1.824p ps=9.98u w=9.6u l=0.13u
X1987 user_project_wrapper_0.VDD1 user_project_wrapper_0.sg13g2_IOPadVdd_2.sg13g2_RCClampInverter_noptap_0.out user_project_wrapper_0.IOVSS1 user_project_wrapper_0.IOVSS1 sg13_hv_nmos ad=2.596p pd=5.58u as=1.408p ps=5.04u w=4.4u l=0.6u
X1988 VDD3 a_296625_189595# a_296731_189665# VDD3 sg13_lv_pmos ad=0.2603p pd=1.75u as=0.2603p ps=1.75u w=1.37u l=0.35u
X1989 user_project_wrapper_0.analog_io[34] a_258244_355624# user_project_wrapper_0.IOVDD4 user_project_wrapper_0.IOVDD4 sg13_hv_pmos ad=3.9294p pd=7.84u as=2.1312p ps=7.3u w=6.66u l=0.6u
X1990 user_project_wrapper_0.analog_io[13] a_197044_29676# user_project_wrapper_0.IOVSS1 user_project_wrapper_0.IOVSS1 sg13_hv_nmos ad=2.596p pd=5.58u as=1.408p ps=5.04u w=4.4u l=0.6u
X1991 VDD3 a_296626_197740# a_296732_200582# VDD3 sg13_lv_pmos ad=1.33p pd=7.38u as=1.33p ps=7.38u w=7u l=0.7u
X1992 user_project_wrapper_0.IOVSS1 a_115444_369296# user_project_wrapper_0.analog_io[27] user_project_wrapper_0.IOVSS1 sg13_hv_nmos ad=1.408p pd=5.04u as=2.596p ps=5.58u w=4.4u l=0.6u
X1993 QDLL_TOP_0.VOUT a_278644_41476# user_project_wrapper_0.IOVDD2 user_project_wrapper_0.IOVDD2 sg13_hv_pmos ad=3.9294p pd=7.84u as=2.1312p ps=7.3u w=6.66u l=0.6u
X1994 VDD3 a_309516_194555# a_309917_199879# VDD3 sg13_lv_pmos ad=0.19p pd=1.38u as=0.19p ps=1.38u w=1u l=0.7u
X1995 user_project_wrapper_0.IOVSS1 user_project_wrapper_0.analog_io[7] dantenna l=27.78u w=1.26u
X1996 user_project_wrapper_0.analog_io[0] a_41476_115444# user_project_wrapper_0.IOVDD1 user_project_wrapper_0.IOVDD1 sg13_hv_pmos ad=3.9294p pd=7.84u as=2.1312p ps=7.3u w=6.66u l=0.6u
X1997 a_309917_194695# a_296731_189665# a_307232_196607# VDD3 sg13_lv_pmos ad=0.24415p pd=1.665u as=0.24415p ps=1.665u w=1.285u l=0.35u
X1998 a_190297_327491# a_189756_327491# user_project_wrapper_0.IOVSS1 user_project_wrapper_0.IOVSS1 sg13_lv_nmos ad=0.34p pd=2.68u as=0.34p ps=2.68u w=1u l=0.13u
X1999 user_project_wrapper_0.VDD2 user_project_wrapper_0.sg13g2_IOPadVdd_1.sg13g2_RCClampResistor_0.p2 user_project_wrapper_0.sg13g2_IOPadVdd_1.sg13g2_RCClampInverter_noptap_0.out user_project_wrapper_0.VDD2 sg13_hv_pmos ad=1.33p pd=7.38u as=1.33p ps=7.38u w=7u l=0.5u
X2000 user_project_wrapper_0.IOVSS1 user_project_wrapper_0.sg13g2_IOPadIOVdd_3.sg13g2_Clamp_N43N43D4R_0.gate IOVDD3 user_project_wrapper_0.IOVSS1 sg13_hv_nmos ad=1.408p pd=5.04u as=2.596p ps=5.58u w=4.4u l=0.6u
X2001 a_74035_364458# a_74365_360372# user_project_wrapper_0.IOVSS1 rppd l=20u w=1u
X2002 user_project_wrapper_0.IOVSS1 a_206201_328627# a_205385_326221# user_project_wrapper_0.IOVSS1 sg13_lv_pmos ad=1.824p pd=9.98u as=1.824p ps=9.98u w=9.6u l=0.13u
X2003 a_79025_126994# user_project_wrapper_0.sg13g2_IOPadAnalog_9.padres a_79038_126152# user_project_wrapper_0.VDD1 sg13_lv_pmos ad=1.7p pd=10.68u as=0.95p ps=5.38u w=5u l=0.3u
X2004 user_project_wrapper_0.IOVDD4 a_237844_355624# user_project_wrapper_0.analog_io[33] user_project_wrapper_0.IOVDD4 sg13_hv_pmos ad=2.1312p pd=7.3u as=3.9294p ps=7.84u w=6.66u l=0.6u
X2005 a_296625_189595# a_301940_196388# a_296732_197880# VDD3 sg13_lv_pmos ad=0.7695p pd=4.43u as=1.377p ps=8.78u w=4.05u l=0.5u
X2006 a_88274_129426# a_86507_129255# a_88274_129061# user_project_wrapper_0.IOVSS1 sg13_lv_nmos ad=0.2516p pd=2.16u as=0.1406p ps=1.12u w=0.74u l=0.13u
X2007 user_project_wrapper_0.IOVSS1 a_369296_237844# analog_io[23] user_project_wrapper_0.IOVSS1 sg13_hv_nmos ad=1.408p pd=5.04u as=2.596p ps=5.58u w=4.4u l=0.6u
X2008 user_project_wrapper_0.IOVDD4 a_176644_355624# user_project_wrapper_0.analog_io[30] user_project_wrapper_0.IOVDD4 sg13_hv_pmos ad=2.1312p pd=7.3u as=3.9294p ps=7.84u w=6.66u l=0.6u
X2009 a_309917_194695# a_309516_194555# VDD3 VDD3 sg13_lv_pmos ad=0.19p pd=1.38u as=0.19p ps=1.38u w=1u l=0.7u
X2010 user_project_wrapper_0.IOVSS1 a_301186_192011# a_296731_189665# user_project_wrapper_0.IOVSS1 sg13_lv_nmos ad=0.912p pd=5.18u as=0.912p ps=5.18u w=4.8u l=1.06u
X2011 user_project_wrapper_0.analog_io[35] a_213870_324142# user_project_wrapper_0.IOVSS1 user_project_wrapper_0.IOVSS1 sg13_lv_nmos ad=0.912p pd=5.18u as=0.912p ps=5.18u w=4.8u l=0.13u
X2012 user_project_wrapper_0.sg13g2_IOPadVdd_0.sg13g2_RCClampInverter_noptap_0.out user_project_wrapper_0.sg13g2_IOPadVdd_0.sg13g2_RCClampResistor_0.p2 VDD3 VDD3 sg13_hv_pmos ad=1.33p pd=7.38u as=1.33p ps=7.38u w=7u l=0.5u
X2013 VDD3 a_311108_179669# analog_io[20] user_project_wrapper_0.IOVSS1 sg13_lv_nmos ad=3.4p pd=20.68u as=3.4p ps=20.68u w=10u l=0.15u
X2014 user_project_wrapper_0.sg13g2_IOPadVdd_2.sg13g2_RCClampInverter_noptap_0.out user_project_wrapper_0.sg13g2_IOPadVdd_2.sg13g2_RCClampResistor_0.p2 user_project_wrapper_0.VDD1 user_project_wrapper_0.VDD1 sg13_hv_pmos ad=1.33p pd=7.38u as=1.33p ps=7.38u w=7u l=0.5u
X2015 user_project_wrapper_0.IOVSS1 user_project_wrapper_0.sg13g2_IOPadIOVdd_1.sg13g2_Clamp_N43N43D4R_0.gate user_project_wrapper_0.IOVDD1 user_project_wrapper_0.IOVSS1 sg13_hv_nmos ad=1.408p pd=5.04u as=2.596p ps=5.58u w=4.4u l=0.6u
X2016 user_project_wrapper_0.sg13g2_IOPadIOVdd_2.sg13g2_Clamp_N43N43D4R_0.gate user_project_wrapper_0.sg13g2_IOPadIOVdd_2.sg13g2_RCClampResistor_0.p2 user_project_wrapper_0.IOVDD4 user_project_wrapper_0.IOVDD4 sg13_hv_pmos ad=1.33p pd=7.38u as=1.33p ps=7.38u w=7u l=0.5u
X2017 analog_io[20] a_355624_156244# IOVDD3 IOVDD3 sg13_hv_pmos ad=3.9294p pd=7.84u as=2.1312p ps=7.3u w=6.66u l=0.6u
X2018 user_project_wrapper_0.IOVSS1 user_project_wrapper_0.sg13g2_IOPadVdd_3.sg13g2_RCClampInverter_noptap_0.out user_project_wrapper_0.IOVSS1 user_project_wrapper_0.IOVSS1 sg13_hv_nmos ad=1.408p pd=5.04u as=0 ps=0 w=4.4u l=0.6u
X2019 user_project_wrapper_0.sg13g2_IOPadVdd_2.sg13g2_RCClampInverter_noptap_0.out user_project_wrapper_0.sg13g2_IOPadVdd_2.sg13g2_RCClampResistor_0.p2 user_project_wrapper_0.VDD1 user_project_wrapper_0.VDD1 sg13_hv_pmos ad=1.33p pd=7.38u as=1.33p ps=7.38u w=7u l=0.5u
X2020 user_project_wrapper_0.IOVSS1 a_202114_326125# user_project_wrapper_0.analog_io[32] user_project_wrapper_0.IOVSS1 sg13_lv_nmos ad=0.912p pd=5.18u as=0.912p ps=5.18u w=4.8u l=0.13u
X2021 user_project_wrapper_0.IOVSS1 user_project_wrapper_0.analog_io[12] dantenna l=1.26u w=27.78u
X2022 user_project_wrapper_0.IOVSS1 user_project_wrapper_0.sg13g2_IOPadAnalog_21.padres a_209041_327491# user_project_wrapper_0.IOVSS1 sg13_lv_nmos ad=0.34p pd=2.68u as=0.19p ps=1.38u w=1u l=0.13u
X2023 user_project_wrapper_0.IOVDD2 a_197044_41476# user_project_wrapper_0.analog_io[13] user_project_wrapper_0.IOVDD2 sg13_hv_pmos ad=2.1312p pd=7.3u as=3.9294p ps=7.84u w=6.66u l=0.6u
X2024 a_86507_127725# a_85052_125418# user_project_wrapper_0.IOVSS1 user_project_wrapper_0.IOVSS1 sg13_lv_nmos ad=0.2516p pd=2.16u as=0.2516p ps=2.16u w=0.74u l=0.13u
X2025 user_project_wrapper_0.IOVSS1 a_278644_29676# QDLL_TOP_0.VOUT user_project_wrapper_0.IOVSS1 sg13_hv_nmos ad=2.068p pd=9.74u as=2.596p ps=5.58u w=4.4u l=0.6u
X2026 user_project_wrapper_0.analog_io[32] a_217444_369296# user_project_wrapper_0.IOVSS1 user_project_wrapper_0.IOVSS1 sg13_hv_nmos ad=2.596p pd=5.58u as=1.408p ps=5.04u w=4.4u l=0.6u
X2027 user_project_wrapper_0.IOVSS1 a_190297_327491# a_190926_328013# w_188704_327938# sg13_lv_pmos ad=0.68p pd=4.68u as=0.38p ps=2.38u w=2u l=0.13u
X2028 a_296731_208493# a_301186_192011# user_project_wrapper_0.IOVSS1 user_project_wrapper_0.IOVSS1 sg13_lv_nmos ad=0.912p pd=5.18u as=0.912p ps=5.18u w=4.8u l=1.06u
X2029 user_project_wrapper_0.IOVSS1 a_182931_326125# user_project_wrapper_0.analog_io[27] user_project_wrapper_0.IOVSS1 sg13_lv_pmos ad=1.824p pd=9.98u as=1.824p ps=9.98u w=9.6u l=0.13u
X2030 user_project_wrapper_0.IOVSS1 user_project_wrapper_0.sg13g2_IOPadVdd_3.sg13g2_RCClampResistor_0.p2 user_project_wrapper_0.sg13g2_IOPadVdd_3.sg13g2_RCClampInverter_noptap_0.out user_project_wrapper_0.IOVSS1 sg13_hv_pmos ad=1.33p pd=7.38u as=1.33p ps=7.38u w=7u l=0.5u
X2031 user_project_wrapper_0.IOVSS1 a_237844_29676# user_project_wrapper_0.analog_io[15] user_project_wrapper_0.IOVSS1 sg13_hv_nmos ad=1.408p pd=5.04u as=2.596p ps=5.58u w=4.4u l=0.6u
X2032 a_304196_197873# a_304889_198885# a_304995_198817# user_project_wrapper_0.IOVSS1 sg13_lv_nmos ad=0.209p pd=1.48u as=0.374p ps=2.88u w=1.1u l=0.15u
X2033 QDLL_TOP_0.VDD a_190389_101343# user_project_wrapper_0.analog_io[15] QDLL_TOP_0.VDD sg13_lv_pmos ad=0.2128p pd=1.5u as=0.2128p ps=1.5u w=1.12u l=0.13u
X2034 user_project_wrapper_0.IOVSS1 user_project_wrapper_0.sg13g2_IOPadIOVdd_2.sg13g2_Clamp_N43N43D4R_0.gate user_project_wrapper_0.IOVDD4 user_project_wrapper_0.IOVSS1 sg13_hv_nmos ad=1.408p pd=5.04u as=2.596p ps=5.58u w=4.4u l=0.6u
X2035 analog_io[18] a_369296_115444# user_project_wrapper_0.IOVSS1 user_project_wrapper_0.IOVSS1 sg13_hv_nmos ad=2.596p pd=5.58u as=1.408p ps=5.04u w=4.4u l=0.6u
X2036 a_87434_129426# a_86594_129426# user_project_wrapper_0.VDD1 user_project_wrapper_0.VDD1 sg13_lv_pmos ad=0.2128p pd=1.5u as=0.3808p ps=2.92u w=1.12u l=0.13u
X2037 a_210007_327491# a_209684_327491# a_209905_328013# w_207887_327938# sg13_lv_pmos ad=0.38p pd=2.38u as=0.38p ps=2.38u w=2u l=0.13u
X2038 user_project_wrapper_0.analog_io[1] a_41476_135844# user_project_wrapper_0.IOVDD1 user_project_wrapper_0.IOVDD1 sg13_hv_pmos ad=3.9294p pd=7.84u as=2.1312p ps=7.3u w=6.66u l=0.6u
X2039 user_project_wrapper_0.IOVSS1 user_project_wrapper_0.IOVDD4 dpantenna l=27.78u w=1.26u
X2040 user_project_wrapper_0.IOVDD2 user_project_wrapper_0.sg13g2_IOPadIOVdd_0.sg13g2_Clamp_N43N43D4R_0.gate user_project_wrapper_0.IOVSS1 user_project_wrapper_0.IOVSS1 sg13_hv_nmos ad=3.256p pd=10.28u as=1.408p ps=5.04u w=4.4u l=0.6u
X2041 user_project_wrapper_0.IOVSS1 user_project_wrapper_0.sg13g2_IOPadVdd_2.sg13g2_RCClampInverter_noptap_0.out user_project_wrapper_0.VDD1 user_project_wrapper_0.IOVSS1 sg13_hv_nmos ad=1.408p pd=5.04u as=2.596p ps=5.58u w=4.4u l=0.6u
X2042 user_project_wrapper_0.IOVSS1 a_271172_100118# QDLL_TOP_0.VOUT user_project_wrapper_0.IOVSS1 sg13_lv_nmos ad=0.1406p pd=1.12u as=0.1406p ps=1.12u w=0.74u l=0.13u
X2043 user_project_wrapper_0.IOVDD4 a_217444_355624# user_project_wrapper_0.analog_io[32] user_project_wrapper_0.IOVDD4 sg13_hv_pmos ad=2.1312p pd=7.3u as=3.9294p ps=7.84u w=6.66u l=0.6u
X2044 a_304995_198817# a_307232_196607# user_project_wrapper_0.IOVSS1 user_project_wrapper_0.IOVSS1 sg13_lv_nmos ad=0.6327p pd=3.71u as=0.6327p ps=3.71u w=3.33u l=0.2u
X2045 user_project_wrapper_0.analog_io[27] user_project_wrapper_0.IOVDD4 dpantenna l=1.26u w=27.78u
X2046 user_project_wrapper_0.IOVSS1 user_project_wrapper_0.sg13g2_IOPadVdd_3.sg13g2_RCClampResistor_0.p2 user_project_wrapper_0.sg13g2_IOPadVdd_3.sg13g2_RCClampInverter_noptap_0.out user_project_wrapper_0.IOVSS1 sg13_hv_nmos ad=1.71p pd=9.38u as=1.71p ps=9.38u w=9u l=0.5u
X2047 a_190824_327491# a_189184_327491# a_190722_327491# user_project_wrapper_0.IOVSS1 sg13_lv_nmos ad=0.19p pd=1.38u as=0.19p ps=1.38u w=1u l=0.13u
X2048 a_360372_78985# a_364458_79315# user_project_wrapper_0.IOVSS1 rppd l=20u w=1u
X2049 a_191196_92557# a_191751_90472# user_project_wrapper_0.IOVSS1 rppd l=10u w=1u
X2050 a_209041_328605# a_208939_329719# a_208939_328605# w_207887_327938# sg13_lv_pmos ad=0.38p pd=2.38u as=0.38p ps=2.38u w=2u l=0.13u
X2051 user_project_wrapper_0.IOVDD1 a_41476_115444# user_project_wrapper_0.analog_io[0] user_project_wrapper_0.IOVDD1 sg13_hv_pmos ad=3.1302p pd=14.26u as=3.9294p ps=7.84u w=6.66u l=0.6u
X2052 a_303055_364458# a_302725_360372# user_project_wrapper_0.IOVSS1 rppd l=20u w=1u
X2053 a_296625_189595# a_301940_196388# a_296732_197880# VDD3 sg13_lv_pmos ad=0.7695p pd=4.43u as=0.7695p ps=4.43u w=4.05u l=0.5u
X2054 QDLL_TOP_0.VOUT a_278644_41476# user_project_wrapper_0.IOVDD2 user_project_wrapper_0.IOVDD2 sg13_hv_pmos ad=3.9294p pd=7.84u as=2.1312p ps=7.3u w=6.66u l=0.6u
X2055 a_190501_326377# a_189184_326377# user_project_wrapper_0.IOVSS1 w_188704_326203# sg13_lv_pmos ad=0.68p pd=4.68u as=0.68p ps=4.68u w=2u l=0.13u
X2056 user_project_wrapper_0.analog_io[32] a_217444_355624# user_project_wrapper_0.IOVDD4 user_project_wrapper_0.IOVDD4 sg13_hv_pmos ad=3.9294p pd=7.84u as=2.1312p ps=7.3u w=6.66u l=0.6u
X2057 user_project_wrapper_0.IOVSS1 a_202114_326125# user_project_wrapper_0.analog_io[32] user_project_wrapper_0.IOVSS1 sg13_lv_pmos ad=1.824p pd=9.98u as=1.824p ps=9.98u w=9.6u l=0.13u
X2058 user_project_wrapper_0.IOVSS1 a_182931_326125# user_project_wrapper_0.analog_io[27] user_project_wrapper_0.IOVSS1 sg13_lv_pmos ad=1.824p pd=9.98u as=1.824p ps=9.98u w=9.6u l=0.13u
X2059 user_project_wrapper_0.IOVSS1 user_project_wrapper_0.sg13g2_IOPadIOVdd_0.sg13g2_Clamp_N43N43D4R_0.gate user_project_wrapper_0.IOVDD2 user_project_wrapper_0.IOVSS1 sg13_hv_nmos ad=1.408p pd=5.04u as=2.596p ps=5.58u w=4.4u l=0.6u
X2060 user_project_wrapper_0.IOVDD2 user_project_wrapper_0.sg13g2_IOPadIOVdd_0.sg13g2_Clamp_N43N43D4R_0.gate user_project_wrapper_0.IOVSS1 user_project_wrapper_0.IOVSS1 sg13_hv_nmos ad=2.596p pd=5.58u as=1.408p ps=5.04u w=4.4u l=0.6u
X2061 user_project_wrapper_0.IOVSS1 user_project_wrapper_0.sg13g2_IOPadAnalog_0.padres dantenna l=0.64u w=3.1u
X2062 a_194193_328627# a_189672_324776# user_project_wrapper_0.IOVSS1 user_project_wrapper_0.IOVSS1 sg13_lv_nmos ad=1.632p pd=10.28u as=1.632p ps=10.28u w=4.8u l=0.13u
X2063 user_project_wrapper_0.IOVSS1 user_project_wrapper_0.sg13g2_IOPadIOVdd_2.sg13g2_RCClampResistor_0.p2 user_project_wrapper_0.sg13g2_IOPadIOVdd_2.sg13g2_Clamp_N43N43D4R_0.gate user_project_wrapper_0.IOVSS1 sg13_hv_nmos ad=1.71p pd=9.38u as=1.71p ps=9.38u w=9u l=0.5u
X2064 a_304196_200821# a_304090_197941# a_296625_208423# user_project_wrapper_0.IOVSS1 sg13_lv_nmos ad=0.361p pd=2.28u as=0.361p ps=2.28u w=1.9u l=0.16u
X2065 a_35456_299095# a_39542_298765# user_project_wrapper_0.IOVSS1 rppd l=20u w=1u
X2066 user_project_wrapper_0.analog_io[15] a_237844_41476# user_project_wrapper_0.IOVDD2 user_project_wrapper_0.IOVDD2 sg13_hv_pmos ad=3.9294p pd=7.84u as=3.1302p ps=14.26u w=6.66u l=0.6u
X2067 user_project_wrapper_0.IOVSS1 user_project_wrapper_0.sg13g2_IOPadVdd_2.sg13g2_RCClampInverter_noptap_0.out user_project_wrapper_0.VDD1 user_project_wrapper_0.IOVSS1 sg13_hv_nmos ad=1.408p pd=5.04u as=2.596p ps=5.58u w=4.4u l=0.6u
X2068 analog_io[22] a_369296_197044# user_project_wrapper_0.IOVSS1 user_project_wrapper_0.IOVSS1 sg13_hv_nmos ad=2.596p pd=5.58u as=1.408p ps=5.04u w=4.4u l=0.6u
X2069 analog_io[18] a_355624_115444# IOVDD3 IOVDD3 sg13_hv_pmos ad=3.9294p pd=7.84u as=2.1312p ps=7.3u w=6.66u l=0.6u
X2070 a_296732_197880# a_301940_196388# a_296625_189595# VDD3 sg13_lv_pmos ad=1.377p pd=8.78u as=0.7695p ps=4.43u w=4.05u l=0.5u
X2071 user_project_wrapper_0.IOVSS1 a_307232_196607# a_304995_198817# user_project_wrapper_0.IOVSS1 sg13_lv_nmos ad=0.6327p pd=3.71u as=0.6327p ps=3.71u w=3.33u l=0.2u
X2072 user_project_wrapper_0.IOVSS1 user_project_wrapper_0.IOVSS1 user_project_wrapper_0.IOVSS1 rppd l=0.5u w=0.5u
X2073 user_project_wrapper_0.IOVSS1 user_project_wrapper_0.sg13g2_IOPadVdd_0.sg13g2_RCClampInverter_noptap_0.out VDD3 user_project_wrapper_0.IOVSS1 sg13_hv_nmos ad=1.408p pd=5.04u as=2.596p ps=5.58u w=4.4u l=0.6u
X2074 user_project_wrapper_0.IOVSS1 user_project_wrapper_0.sg13g2_IOPadIOVdd_0.sg13g2_Clamp_N43N43D4R_0.gate user_project_wrapper_0.IOVDD2 user_project_wrapper_0.IOVSS1 sg13_hv_nmos ad=1.408p pd=5.04u as=2.596p ps=5.58u w=4.4u l=0.6u
X2075 user_project_wrapper_0.analog_io[35] a_213870_324142# user_project_wrapper_0.IOVSS1 user_project_wrapper_0.IOVSS1 sg13_lv_pmos ad=1.824p pd=9.98u as=1.824p ps=9.98u w=9.6u l=0.13u
X2076 user_project_wrapper_0.IOVSS1 a_182931_326125# user_project_wrapper_0.analog_io[27] user_project_wrapper_0.IOVSS1 sg13_lv_pmos ad=1.824p pd=9.98u as=1.824p ps=9.98u w=9.6u l=0.13u
X2077 user_project_wrapper_0.analog_io[32] a_202114_326125# user_project_wrapper_0.IOVSS1 user_project_wrapper_0.IOVSS1 sg13_lv_nmos ad=0.912p pd=5.18u as=0.912p ps=5.18u w=4.8u l=0.13u
X2078 a_190722_328605# a_189756_328605# user_project_wrapper_0.IOVSS1 w_188704_327938# sg13_lv_pmos ad=0.38p pd=2.38u as=0.68p ps=4.68u w=2u l=0.13u
X2079 user_project_wrapper_0.IOVSS1 user_project_wrapper_0.sg13g2_IOPadIOVdd_0.sg13g2_Clamp_N43N43D4R_0.gate user_project_wrapper_0.IOVDD2 user_project_wrapper_0.IOVSS1 sg13_hv_nmos ad=1.408p pd=5.04u as=2.596p ps=5.58u w=4.4u l=0.6u
X2080 QDLL_TOP_0.VDD a_190389_101343# user_project_wrapper_0.analog_io[15] QDLL_TOP_0.VDD sg13_lv_pmos ad=0.2128p pd=1.5u as=0.2128p ps=1.5u w=1.12u l=0.13u
X2081 user_project_wrapper_0.sg13g2_IOPadIOVdd_3.sg13g2_Clamp_N43N43D4R_0.gate user_project_wrapper_0.sg13g2_IOPadIOVdd_3.sg13g2_RCClampResistor_0.p2 user_project_wrapper_0.IOVSS1 user_project_wrapper_0.IOVSS1 sg13_hv_nmos ad=1.71p pd=9.38u as=3.06p ps=18.68u w=9u l=0.5u
X2082 user_project_wrapper_0.sg13g2_IOPadVdd_0.sg13g2_RCClampInverter_noptap_0.out user_project_wrapper_0.sg13g2_IOPadVdd_0.sg13g2_RCClampResistor_0.p2 VDD3 VDD3 sg13_hv_pmos ad=1.33p pd=7.38u as=1.33p ps=7.38u w=7u l=0.5u
X2083 user_project_wrapper_0.IOVSS1 a_156244_369296# user_project_wrapper_0.analog_io[29] user_project_wrapper_0.IOVSS1 sg13_hv_nmos ad=1.408p pd=5.04u as=2.596p ps=5.58u w=4.4u l=0.6u
X2084 QDLL_TOP_0.VOUT a_278644_41476# user_project_wrapper_0.IOVDD2 user_project_wrapper_0.IOVDD2 sg13_hv_pmos ad=3.9294p pd=7.84u as=2.1312p ps=7.3u w=6.66u l=0.6u
X2085 a_304196_200821# a_304889_199957# a_304995_198817# user_project_wrapper_0.IOVSS1 sg13_lv_nmos ad=0.209p pd=1.48u as=0.209p ps=1.48u w=1.1u l=0.15u
X2086 user_project_wrapper_0.analog_io[34] a_258244_355624# user_project_wrapper_0.IOVDD4 user_project_wrapper_0.IOVDD4 sg13_hv_pmos ad=3.9294p pd=7.84u as=2.1312p ps=7.3u w=6.66u l=0.6u
X2087 analog_io[23] a_355624_217444# IOVDD3 IOVDD3 sg13_hv_pmos ad=3.9294p pd=7.84u as=2.1312p ps=7.3u w=6.66u l=0.6u
X2088 a_307232_196607# a_296731_208493# a_309917_199879# VDD3 sg13_lv_pmos ad=0.24415p pd=1.665u as=0.24415p ps=1.665u w=1.285u l=0.35u
X2089 a_296731_208493# a_296625_208423# VDD3 VDD3 sg13_lv_pmos ad=0.2603p pd=1.75u as=0.2603p ps=1.75u w=1.37u l=0.35u
X2090 a_299755_364458# a_299425_360372# user_project_wrapper_0.IOVSS1 rppd l=20u w=1u
X2091 user_project_wrapper_0.IOVSS1 a_271172_100118# QDLL_TOP_0.VOUT user_project_wrapper_0.IOVSS1 sg13_lv_nmos ad=0.2516p pd=2.16u as=0.1406p ps=1.12u w=0.74u l=0.13u
X2092 a_93204_129062# a_93461_128591# user_project_wrapper_0.VDD1 user_project_wrapper_0.VDD1 sg13_lv_pmos ad=0.3808p pd=2.92u as=0.2128p ps=1.5u w=1.12u l=0.13u
X2093 user_project_wrapper_0.analog_io[16] a_258244_29676# user_project_wrapper_0.IOVSS1 user_project_wrapper_0.IOVSS1 sg13_hv_nmos ad=2.596p pd=5.58u as=1.408p ps=5.04u w=4.4u l=0.6u
X2094 user_project_wrapper_0.IOVDD4 a_115444_355624# user_project_wrapper_0.analog_io[27] user_project_wrapper_0.IOVDD4 sg13_hv_pmos ad=3.1302p pd=14.26u as=3.9294p ps=7.84u w=6.66u l=0.6u
X2095 user_project_wrapper_0.IOVSS1 a_369296_115444# analog_io[18] user_project_wrapper_0.IOVSS1 sg13_hv_nmos ad=1.408p pd=5.04u as=2.596p ps=5.58u w=4.4u l=0.6u
X2096 a_307232_196607# a_296731_189665# a_309917_194695# VDD3 sg13_lv_pmos ad=0.24415p pd=1.665u as=0.24415p ps=1.665u w=1.285u l=0.35u
X2097 user_project_wrapper_0.IOVSS1 a_202114_326125# user_project_wrapper_0.analog_io[32] user_project_wrapper_0.IOVSS1 sg13_lv_pmos ad=1.824p pd=9.98u as=1.824p ps=9.98u w=9.6u l=0.13u
X2098 user_project_wrapper_0.IOVSS1 user_project_wrapper_0.sg13g2_IOPadVdd_1.sg13g2_RCClampResistor_0.p2 user_project_wrapper_0.IOVSS1 user_project_wrapper_0.IOVSS1 sg13_hv_nmos ad=1.71p pd=9.38u as=0 ps=0 w=9u l=9.5u
X2099 QDLL_TOP_0.VDD a_188184_99046# a_188296_99070# QDLL_TOP_0.VDD sg13_lv_pmos ad=0.2254p pd=1.53u as=0.34p ps=2.68u w=1u l=0.5u
X2100 user_project_wrapper_0.IOVSS1 user_project_wrapper_0.sg13g2_IOPadIOVdd_1.sg13g2_Clamp_N43N43D4R_0.gate user_project_wrapper_0.IOVDD1 user_project_wrapper_0.IOVSS1 sg13_hv_nmos ad=1.408p pd=5.04u as=2.596p ps=5.58u w=4.4u l=0.6u
X2101 user_project_wrapper_0.IOVDD2 a_237844_41476# user_project_wrapper_0.analog_io[15] user_project_wrapper_0.IOVDD2 sg13_hv_pmos ad=3.1302p pd=14.26u as=3.9294p ps=7.84u w=6.66u l=0.6u
X2102 IOVDD3 a_355624_278644# analog_io[26] IOVDD3 sg13_hv_pmos ad=2.1312p pd=7.3u as=3.9294p ps=7.84u w=6.66u l=0.6u
X2103 user_project_wrapper_0.IOVSS1 a_209480_327491# a_210109_328013# w_207887_327938# sg13_lv_pmos ad=0.68p pd=4.68u as=0.38p ps=2.38u w=2u l=0.13u
X2104 user_project_wrapper_0.analog_io[14] a_217444_29676# user_project_wrapper_0.IOVSS1 user_project_wrapper_0.IOVSS1 sg13_hv_nmos ad=2.596p pd=5.58u as=1.408p ps=5.04u w=4.4u l=0.6u
X2105 user_project_wrapper_0.IOVSS1 user_project_wrapper_0.sg13g2_IOPadIOVdd_1.sg13g2_Clamp_N43N43D4R_0.gate user_project_wrapper_0.IOVDD1 user_project_wrapper_0.IOVSS1 sg13_hv_nmos ad=1.408p pd=5.04u as=2.596p ps=5.58u w=4.4u l=0.6u
X2106 a_190926_325263# a_190501_325263# a_190824_325263# user_project_wrapper_0.IOVSS1 sg13_lv_nmos ad=0.19p pd=1.38u as=0.19p ps=1.38u w=1u l=0.13u
X2107 user_project_wrapper_0.IOVSS1 a_202114_326125# user_project_wrapper_0.analog_io[32] user_project_wrapper_0.IOVSS1 sg13_lv_pmos ad=1.824p pd=9.98u as=1.824p ps=9.98u w=9.6u l=0.13u
X2108 user_project_wrapper_0.IOVSS1 user_project_wrapper_0.sg13g2_IOPadVdd_3.sg13g2_RCClampResistor_0.p2 user_project_wrapper_0.sg13g2_IOPadVdd_3.sg13g2_RCClampInverter_noptap_0.out user_project_wrapper_0.IOVSS1 sg13_hv_pmos ad=1.33p pd=7.38u as=1.33p ps=7.38u w=7u l=0.5u
X2109 a_296731_208493# a_296625_208423# VDD3 VDD3 sg13_lv_pmos ad=0.2603p pd=1.75u as=0.2603p ps=1.75u w=1.37u l=0.35u
X2110 user_project_wrapper_0.sg13g2_IOPadIOVdd_3.sg13g2_Clamp_N43N43D4R_0.gate user_project_wrapper_0.sg13g2_IOPadIOVdd_3.sg13g2_RCClampResistor_0.p2 user_project_wrapper_0.IOVSS1 user_project_wrapper_0.IOVSS1 sg13_hv_nmos ad=1.71p pd=9.38u as=3.06p ps=18.68u w=9u l=0.5u
X2111 a_35456_304375# a_39542_304045# user_project_wrapper_0.IOVSS1 rppd l=20u w=1u
X2112 user_project_wrapper_0.analog_io[30] a_194687_324142# user_project_wrapper_0.IOVSS1 user_project_wrapper_0.IOVSS1 sg13_lv_nmos ad=0.912p pd=5.18u as=0.912p ps=5.18u w=4.8u l=0.13u
X2113 VDD3 a_309516_194555# a_309917_194695# VDD3 sg13_lv_pmos ad=0.19p pd=1.38u as=0.19p ps=1.38u w=1u l=0.7u
X2114 a_301186_192011# a_301186_192011# user_project_wrapper_0.IOVSS1 user_project_wrapper_0.IOVSS1 sg13_lv_nmos ad=1.632p pd=10.28u as=1.632p ps=10.28u w=4.8u l=1.06u
X2115 VDD3 user_project_wrapper_0.sg13g2_IOPadVdd_0.sg13g2_RCClampInverter_noptap_0.out user_project_wrapper_0.IOVSS1 user_project_wrapper_0.IOVSS1 sg13_hv_nmos ad=2.596p pd=5.58u as=1.408p ps=5.04u w=4.4u l=0.6u
X2116 user_project_wrapper_0.analog_io[6] user_project_wrapper_0.IOVDD1 dpantenna l=27.78u w=1.26u
X2117 a_304196_197873# a_304889_198885# a_304995_198817# user_project_wrapper_0.IOVSS1 sg13_lv_nmos ad=0.209p pd=1.48u as=0.209p ps=1.48u w=1.1u l=0.15u
X2118 user_project_wrapper_0.IOVSS1 user_project_wrapper_0.sg13g2_IOPadVdd_3.sg13g2_RCClampInverter_noptap_0.out user_project_wrapper_0.IOVSS1 user_project_wrapper_0.IOVSS1 sg13_hv_nmos ad=1.408p pd=5.04u as=0 ps=0 w=4.4u l=0.6u
X2119 VDD3 a_296625_189595# a_296731_189665# VDD3 sg13_lv_pmos ad=0.2603p pd=1.75u as=0.2603p ps=1.75u w=1.37u l=0.35u
X2120 a_202114_326125# a_205385_326221# user_project_wrapper_0.IOVSS1 user_project_wrapper_0.IOVSS1 sg13_lv_nmos ad=0.912p pd=5.18u as=0.912p ps=5.18u w=4.8u l=0.13u
X2121 user_project_wrapper_0.analog_io[10] a_135844_41476# user_project_wrapper_0.IOVDD2 user_project_wrapper_0.IOVDD2 sg13_hv_pmos ad=3.9294p pd=7.84u as=2.1312p ps=7.3u w=6.66u l=0.6u
X2122 a_135844_41476# user_project_wrapper_0.IOVDD2 user_project_wrapper_0.IOVDD2 rppd l=12.9u w=0.5u
X2123 user_project_wrapper_0.IOVSS1 a_82859_239376# a_82859_239376# user_project_wrapper_0.IOVSS1 sg13_lv_nmos ad=0.1428p pd=1.52u as=0.1428p ps=1.52u w=0.42u l=0.56u
X2124 user_project_wrapper_0.IOVSS1 user_project_wrapper_0.sg13g2_IOPadIOVdd_0.sg13g2_Clamp_N43N43D4R_0.gate user_project_wrapper_0.IOVDD2 user_project_wrapper_0.IOVSS1 sg13_hv_nmos ad=1.408p pd=5.04u as=2.596p ps=5.58u w=4.4u l=0.6u
X2125 user_project_wrapper_0.IOVDD2 a_197044_41476# user_project_wrapper_0.analog_io[13] user_project_wrapper_0.IOVDD2 sg13_hv_pmos ad=2.1312p pd=7.3u as=3.9294p ps=7.84u w=6.66u l=0.6u
X2126 a_208939_328605# user_project_wrapper_0.IOVSS1 user_project_wrapper_0.IOVSS1 user_project_wrapper_0.IOVSS1 sg13_lv_nmos ad=0.19p pd=1.38u as=0.34p ps=2.68u w=1u l=0.13u
X2127 user_project_wrapper_0.IOVSS1 user_project_wrapper_0.sg13g2_IOPadIOVdd_3.sg13g2_Clamp_N43N43D4R_0.gate IOVDD3 user_project_wrapper_0.IOVSS1 sg13_hv_nmos ad=1.408p pd=5.04u as=2.596p ps=5.58u w=4.4u l=0.6u
X2128 user_project_wrapper_0.IOVDD4 a_258244_355624# user_project_wrapper_0.analog_io[34] user_project_wrapper_0.IOVDD4 sg13_hv_pmos ad=2.1312p pd=7.3u as=3.9294p ps=7.84u w=6.66u l=0.6u
X2129 a_296732_200582# a_296626_197740# VDD3 VDD3 sg13_lv_pmos ad=1.33p pd=7.38u as=2.38p ps=14.68u w=7u l=0.7u
X2130 a_296731_208493# a_296625_208423# VDD3 VDD3 sg13_lv_pmos ad=0.2603p pd=1.75u as=0.2603p ps=1.75u w=1.37u l=0.35u
X2131 VDD3 a_309516_194555# a_309917_199879# VDD3 sg13_lv_pmos ad=0.19p pd=1.38u as=0.19p ps=1.38u w=1u l=0.7u
X2132 user_project_wrapper_0.IOVDD1 a_41476_217444# user_project_wrapper_0.analog_io[5] user_project_wrapper_0.IOVDD1 sg13_hv_pmos ad=2.1312p pd=7.3u as=3.9294p ps=7.84u w=6.66u l=0.6u
X2133 user_project_wrapper_0.IOVDD1 a_41476_237844# user_project_wrapper_0.analog_io[6] user_project_wrapper_0.IOVDD1 sg13_hv_pmos ad=2.1312p pd=7.3u as=3.9294p ps=7.84u w=6.66u l=0.6u
X2134 user_project_wrapper_0.IOVSS1 user_project_wrapper_0.sg13g2_IOPadVdd_1.sg13g2_RCClampInverter_noptap_0.out user_project_wrapper_0.VDD2 user_project_wrapper_0.IOVSS1 sg13_hv_nmos ad=1.408p pd=5.04u as=2.596p ps=5.58u w=4.4u l=0.6u
X2135 user_project_wrapper_0.IOVSS1 a_85052_125418# a_85977_125209# user_project_wrapper_0.IOVSS1 sg13_lv_nmos ad=0.2516p pd=2.16u as=0.1406p ps=1.12u w=0.74u l=0.13u
X2136 IOVDD3 a_355624_217444# analog_io[23] IOVDD3 sg13_hv_pmos ad=2.1312p pd=7.3u as=3.9294p ps=7.84u w=6.66u l=0.6u
X2137 user_project_wrapper_0.IOVSS1 user_project_wrapper_0.sg13g2_IOPadIOVdd_2.sg13g2_RCClampResistor_0.p2 user_project_wrapper_0.sg13g2_IOPadIOVdd_2.sg13g2_Clamp_N43N43D4R_0.gate user_project_wrapper_0.IOVSS1 sg13_hv_nmos ad=1.71p pd=9.38u as=1.71p ps=9.38u w=9u l=0.5u
X2138 user_project_wrapper_0.IOVSS1 user_project_wrapper_0.sg13g2_IOPadIOVdd_2.sg13g2_Clamp_N43N43D4R_0.gate user_project_wrapper_0.IOVDD4 user_project_wrapper_0.IOVSS1 sg13_hv_nmos ad=1.408p pd=5.04u as=2.596p ps=5.58u w=4.4u l=0.6u
X2139 QDLL_TOP_0.VOUT a_278644_41476# user_project_wrapper_0.IOVDD2 user_project_wrapper_0.IOVDD2 sg13_hv_pmos ad=3.9294p pd=7.84u as=2.1312p ps=7.3u w=6.66u l=0.6u
X2140 user_project_wrapper_0.IOVSS1 user_project_wrapper_0.sg13g2_IOPadVdd_3.sg13g2_RCClampInverter_noptap_0.out user_project_wrapper_0.IOVSS1 user_project_wrapper_0.IOVSS1 sg13_hv_nmos ad=2.596p pd=5.58u as=0 ps=0 w=4.4u l=0.6u
X2141 user_project_wrapper_0.sg13g2_IOPadVdd_2.sg13g2_RCClampInverter_noptap_0.out user_project_wrapper_0.sg13g2_IOPadVdd_2.sg13g2_RCClampResistor_0.p2 user_project_wrapper_0.VDD1 user_project_wrapper_0.VDD1 sg13_hv_pmos ad=1.33p pd=7.38u as=1.33p ps=7.38u w=7u l=0.5u
X2142 analog_io[19] a_355624_135844# IOVDD3 IOVDD3 sg13_hv_pmos ad=3.9294p pd=7.84u as=2.1312p ps=7.3u w=6.66u l=0.6u
X2143 user_project_wrapper_0.IOVSS1 user_project_wrapper_0.sg13g2_IOPadVdd_3.sg13g2_RCClampInverter_noptap_0.out user_project_wrapper_0.IOVSS1 user_project_wrapper_0.IOVSS1 sg13_hv_nmos ad=2.596p pd=5.58u as=0 ps=0 w=4.4u l=0.6u
X2144 user_project_wrapper_0.IOVSS1 user_project_wrapper_0.sg13g2_IOPadVdd_3.sg13g2_RCClampInverter_noptap_0.out user_project_wrapper_0.IOVSS1 user_project_wrapper_0.IOVSS1 sg13_hv_nmos ad=2.596p pd=5.58u as=0 ps=0 w=4.4u l=0.6u
X2145 user_project_wrapper_0.IOVSS1 a_135844_29676# user_project_wrapper_0.analog_io[10] user_project_wrapper_0.IOVSS1 sg13_hv_nmos ad=1.408p pd=5.04u as=2.596p ps=5.58u w=4.4u l=0.6u
X2146 a_309917_194695# a_309516_194555# VDD3 VDD3 sg13_lv_pmos ad=0.19p pd=1.38u as=0.19p ps=1.38u w=1u l=0.7u
X2147 VDD3 a_311108_179669# analog_io[20] user_project_wrapper_0.IOVSS1 sg13_lv_nmos ad=3.4p pd=20.68u as=3.4p ps=20.68u w=10u l=0.15u
X2148 VDD3 a_296625_208423# a_296731_208493# VDD3 sg13_lv_pmos ad=0.4658p pd=3.42u as=0.2603p ps=1.75u w=1.37u l=0.35u
X2149 user_project_wrapper_0.IOVSS1 user_project_wrapper_0.IOVSS1 user_project_wrapper_0.IOVSS1 rhigh l=4u w=0.5u
X2150 user_project_wrapper_0.IOVSS1 a_194687_324142# user_project_wrapper_0.analog_io[30] user_project_wrapper_0.IOVSS1 sg13_lv_pmos ad=1.824p pd=9.98u as=1.824p ps=9.98u w=9.6u l=0.13u
X2151 user_project_wrapper_0.VDD1 user_project_wrapper_0.sg13g2_IOPadVdd_2.sg13g2_RCClampInverter_noptap_0.out user_project_wrapper_0.IOVSS1 user_project_wrapper_0.IOVSS1 sg13_hv_nmos ad=2.596p pd=5.58u as=1.408p ps=5.04u w=4.4u l=0.6u
X2152 a_304196_200821# a_304090_197941# a_296625_208423# user_project_wrapper_0.IOVSS1 sg13_lv_nmos ad=0.361p pd=2.28u as=0.361p ps=2.28u w=1.9u l=0.16u
X2153 user_project_wrapper_0.IOVDD1 user_project_wrapper_0.sg13g2_IOPadIOVdd_1.sg13g2_Clamp_N43N43D4R_0.gate user_project_wrapper_0.IOVSS1 user_project_wrapper_0.IOVSS1 sg13_hv_nmos ad=2.596p pd=5.58u as=1.408p ps=5.04u w=4.4u l=0.6u
X2154 user_project_wrapper_0.IOVSS1 a_217444_369296# user_project_wrapper_0.analog_io[32] user_project_wrapper_0.IOVSS1 sg13_hv_nmos ad=1.408p pd=5.04u as=2.596p ps=5.58u w=4.4u l=0.6u
X2155 user_project_wrapper_0.sg13g2_IOPadVdd_0.sg13g2_RCClampInverter_noptap_0.out user_project_wrapper_0.sg13g2_IOPadVdd_0.sg13g2_RCClampResistor_0.p2 VDD3 VDD3 sg13_hv_pmos ad=1.33p pd=7.38u as=1.33p ps=7.38u w=7u l=0.5u
X2156 user_project_wrapper_0.analog_io[16] a_258244_29676# user_project_wrapper_0.IOVSS1 user_project_wrapper_0.IOVSS1 sg13_hv_nmos ad=2.596p pd=5.58u as=1.408p ps=5.04u w=4.4u l=0.6u
X2157 a_296625_208423# a_304090_197941# a_304196_200821# user_project_wrapper_0.IOVSS1 sg13_lv_nmos ad=0.361p pd=2.28u as=0.361p ps=2.28u w=1.9u l=0.16u
X2158 user_project_wrapper_0.IOVSS1 user_project_wrapper_0.sg13g2_IOPadIOVdd_3.sg13g2_Clamp_N43N43D4R_0.gate IOVDD3 user_project_wrapper_0.IOVSS1 sg13_hv_nmos ad=1.408p pd=5.04u as=2.596p ps=5.58u w=4.4u l=0.6u
X2159 user_project_wrapper_0.analog_io[30] a_176644_369296# user_project_wrapper_0.IOVSS1 user_project_wrapper_0.IOVSS1 sg13_hv_nmos ad=2.596p pd=5.58u as=1.408p ps=5.04u w=4.4u l=0.6u
X2160 a_190319_102855# a_190218_102763# user_project_wrapper_0.IOVSS1 user_project_wrapper_0.IOVSS1 sg13_lv_nmos ad=0.17462p pd=1.185u as=0.374p ps=2.46u w=0.55u l=0.13u
X2161 user_project_wrapper_0.IOVSS1 a_369296_278644# analog_io[26] user_project_wrapper_0.IOVSS1 sg13_hv_nmos ad=1.408p pd=5.04u as=2.596p ps=5.58u w=4.4u l=0.6u
X2162 user_project_wrapper_0.IOVDD2 user_project_wrapper_0.sg13g2_IOPadIOVdd_0.sg13g2_Clamp_N43N43D4R_0.gate user_project_wrapper_0.IOVSS1 user_project_wrapper_0.IOVSS1 sg13_hv_nmos ad=2.596p pd=5.58u as=1.408p ps=5.04u w=4.4u l=0.6u
X2163 IOVDD3 a_355624_197044# analog_io[22] IOVDD3 sg13_hv_pmos ad=2.1312p pd=7.3u as=3.9294p ps=7.84u w=6.66u l=0.6u
X2164 analog_io[25] a_355624_258244# IOVDD3 IOVDD3 sg13_hv_pmos ad=3.9294p pd=7.84u as=2.1312p ps=7.3u w=6.66u l=0.6u
X2165 user_project_wrapper_0.analog_io[14] a_217444_29676# user_project_wrapper_0.IOVSS1 user_project_wrapper_0.IOVSS1 sg13_hv_nmos ad=2.596p pd=5.58u as=1.408p ps=5.04u w=4.4u l=0.6u
X2166 QDLL_TOP_0.VOUT user_project_wrapper_0.sg13g2_IOPadAnalog_6.padres a_186431_100948# user_project_wrapper_0.IOVSS1 sg13_lv_nmos ad=0.68p pd=4.68u as=0.68p ps=4.68u w=2u l=0.13u
X2167 user_project_wrapper_0.IOVSS1 user_project_wrapper_0.sg13g2_IOPadIOVdd_0.sg13g2_RCClampResistor_0.p2 user_project_wrapper_0.IOVSS1 user_project_wrapper_0.IOVSS1 sg13_hv_nmos ad=1.71p pd=9.38u as=0 ps=0 w=9u l=9.5u
X2168 user_project_wrapper_0.analog_io[14] a_217444_41476# user_project_wrapper_0.IOVDD2 user_project_wrapper_0.IOVDD2 sg13_hv_pmos ad=3.9294p pd=7.84u as=2.1312p ps=7.3u w=6.66u l=0.6u
X2169 VDD3 user_project_wrapper_0.sg13g2_IOPadVdd_0.sg13g2_RCClampInverter_noptap_0.out user_project_wrapper_0.IOVSS1 user_project_wrapper_0.IOVSS1 sg13_hv_nmos ad=2.596p pd=5.58u as=1.408p ps=5.04u w=4.4u l=0.6u
X2170 VDD3 a_296625_208423# a_296731_208493# VDD3 sg13_lv_pmos ad=0.2603p pd=1.75u as=0.2603p ps=1.75u w=1.37u l=0.35u
X2171 user_project_wrapper_0.VDD1 user_project_wrapper_0.sg13g2_IOPadVdd_2.sg13g2_RCClampInverter_noptap_0.out user_project_wrapper_0.IOVSS1 user_project_wrapper_0.IOVSS1 sg13_hv_nmos ad=2.596p pd=5.58u as=1.408p ps=5.04u w=4.4u l=0.6u
X2172 user_project_wrapper_0.sg13g2_IOPadAnalog_29.padres IOVDD3 dpantenna l=4.98u w=0.64u
X2173 user_project_wrapper_0.IOVSS1 a_301186_192011# a_296731_208493# user_project_wrapper_0.IOVSS1 sg13_lv_nmos ad=0.912p pd=5.18u as=0.912p ps=5.18u w=4.8u l=1.06u
X2174 user_project_wrapper_0.IOVDD1 user_project_wrapper_0.sg13g2_IOPadIOVdd_1.sg13g2_RCClampResistor_0.p2 user_project_wrapper_0.sg13g2_IOPadIOVdd_1.sg13g2_Clamp_N43N43D4R_0.gate user_project_wrapper_0.IOVDD1 sg13_hv_pmos ad=1.33p pd=7.38u as=1.33p ps=7.38u w=7u l=0.5u
X2175 analog_io[23] a_355624_217444# IOVDD3 IOVDD3 sg13_hv_pmos ad=3.9294p pd=7.84u as=2.1312p ps=7.3u w=6.66u l=0.6u
X2176 analog_io[23] a_311108_215937# VDD3 user_project_wrapper_0.IOVSS1 sg13_lv_nmos ad=3.4p pd=20.68u as=3.4p ps=20.68u w=10u l=0.15u
X2177 IOVDD3 user_project_wrapper_0.sg13g2_IOPadIOVdd_3.sg13g2_Clamp_N43N43D4R_0.gate user_project_wrapper_0.IOVSS1 user_project_wrapper_0.IOVSS1 sg13_hv_nmos ad=2.596p pd=5.58u as=1.408p ps=5.04u w=4.4u l=0.6u
X2178 user_project_wrapper_0.IOVSS1 user_project_wrapper_0.sg13g2_IOPadIOVdd_2.sg13g2_RCClampResistor_0.p2 user_project_wrapper_0.sg13g2_IOPadIOVdd_2.sg13g2_Clamp_N43N43D4R_0.gate user_project_wrapper_0.IOVSS1 sg13_hv_nmos ad=1.71p pd=9.38u as=1.71p ps=9.38u w=9u l=0.5u
X2179 user_project_wrapper_0.IOVDD2 user_project_wrapper_0.sg13g2_IOPadIOVdd_0.sg13g2_Clamp_N43N43D4R_0.gate user_project_wrapper_0.IOVSS1 user_project_wrapper_0.IOVSS1 sg13_hv_nmos ad=2.596p pd=5.58u as=1.408p ps=5.04u w=4.4u l=0.6u
X2180 IOVDD3 user_project_wrapper_0.sg13g2_IOPadIOVdd_3.sg13g2_Clamp_N43N43D4R_0.gate user_project_wrapper_0.IOVSS1 user_project_wrapper_0.IOVSS1 sg13_hv_nmos ad=2.596p pd=5.58u as=1.408p ps=5.04u w=4.4u l=0.6u
X2181 a_210621_329719# TOP_ROILIFNEURON_0.MEM user_project_wrapper_0.IOVSS1 rppd l=0.5u w=0.5u
X2182 user_project_wrapper_0.IOVDD2 a_258244_41476# user_project_wrapper_0.analog_io[16] user_project_wrapper_0.IOVDD2 sg13_hv_pmos ad=2.1312p pd=7.3u as=3.9294p ps=7.84u w=6.66u l=0.6u
X2183 VDD3 user_project_wrapper_0.sg13g2_IOPadVdd_0.sg13g2_RCClampInverter_noptap_0.out user_project_wrapper_0.IOVSS1 user_project_wrapper_0.IOVSS1 sg13_hv_nmos ad=2.596p pd=5.58u as=1.408p ps=5.04u w=4.4u l=0.6u
X2184 analog_io[23] IOVDD3 dpantenna l=27.78u w=1.26u
X2185 user_project_wrapper_0.IOVDD2 user_project_wrapper_0.sg13g2_IOPadIOVdd_0.sg13g2_RCClampResistor_0.p2 user_project_wrapper_0.sg13g2_IOPadIOVdd_0.sg13g2_Clamp_N43N43D4R_0.gate user_project_wrapper_0.IOVDD2 sg13_hv_pmos ad=1.33p pd=7.38u as=1.33p ps=7.38u w=7u l=0.5u
X2186 user_project_wrapper_0.IOVSS1 user_project_wrapper_0.sg13g2_IOPadVdd_3.sg13g2_RCClampInverter_noptap_0.out user_project_wrapper_0.IOVSS1 user_project_wrapper_0.IOVSS1 sg13_hv_nmos ad=1.408p pd=5.04u as=0 ps=0 w=4.4u l=0.6u
X2187 user_project_wrapper_0.IOVSS1 user_project_wrapper_0.sg13g2_IOPadVdd_3.sg13g2_RCClampInverter_noptap_0.out user_project_wrapper_0.IOVSS1 user_project_wrapper_0.IOVSS1 sg13_hv_nmos ad=1.408p pd=5.04u as=0 ps=0 w=4.4u l=0.6u
X2188 user_project_wrapper_0.IOVSS1 a_82859_241546# a_82859_241546# user_project_wrapper_0.IOVSS1 sg13_lv_nmos ad=0.1428p pd=1.52u as=0.1428p ps=1.52u w=0.42u l=0.56u
X2189 user_project_wrapper_0.IOVSS1 a_29676_237844# user_project_wrapper_0.IOVSS1 rppd l=3.54u w=0.5u
X2190 a_190721_331163# a_191754_330987# user_project_wrapper_0.IOVSS1 rhigh l=4u w=0.5u
X2191 user_project_wrapper_0.IOVSS1 user_project_wrapper_0.sg13g2_IOPadVdd_3.sg13g2_RCClampInverter_noptap_0.out user_project_wrapper_0.IOVSS1 user_project_wrapper_0.IOVSS1 sg13_hv_nmos ad=1.408p pd=5.04u as=0 ps=0 w=4.4u l=0.6u
X2192 user_project_wrapper_0.IOVSS1 a_182931_326125# user_project_wrapper_0.analog_io[27] user_project_wrapper_0.IOVSS1 sg13_lv_pmos ad=1.824p pd=9.98u as=1.824p ps=9.98u w=9.6u l=0.13u
X2193 VDD3 a_309516_194555# a_309917_199879# VDD3 sg13_lv_pmos ad=0.19p pd=1.38u as=0.19p ps=1.38u w=1u l=0.7u
X2194 user_project_wrapper_0.analog_io[30] a_176644_355624# user_project_wrapper_0.IOVDD4 user_project_wrapper_0.IOVDD4 sg13_hv_pmos ad=3.9294p pd=7.84u as=2.1312p ps=7.3u w=6.66u l=0.6u
X2195 user_project_wrapper_0.IOVSS1 user_project_wrapper_0.sg13g2_IOPadVdd_0.sg13g2_RCClampInverter_noptap_0.out VDD3 user_project_wrapper_0.IOVSS1 sg13_hv_nmos ad=1.408p pd=5.04u as=2.596p ps=5.58u w=4.4u l=0.6u
X2196 a_304196_200821# a_304889_199957# a_304995_198817# user_project_wrapper_0.IOVSS1 sg13_lv_nmos ad=0.209p pd=1.48u as=0.374p ps=2.88u w=1.1u l=0.15u
X2197 user_project_wrapper_0.IOVDD1 a_41476_135844# user_project_wrapper_0.analog_io[1] user_project_wrapper_0.IOVDD1 sg13_hv_pmos ad=2.1312p pd=7.3u as=3.9294p ps=7.84u w=6.66u l=0.6u
X2198 user_project_wrapper_0.analog_io[4] a_41476_197044# user_project_wrapper_0.IOVDD1 user_project_wrapper_0.IOVDD1 sg13_hv_pmos ad=3.9294p pd=7.84u as=2.1312p ps=7.3u w=6.66u l=0.6u
X2199 user_project_wrapper_0.IOVSS1 user_project_wrapper_0.sg13g2_IOPadVdd_1.sg13g2_RCClampInverter_noptap_0.out user_project_wrapper_0.VDD2 user_project_wrapper_0.IOVSS1 sg13_hv_nmos ad=1.408p pd=5.04u as=2.596p ps=5.58u w=4.4u l=0.6u
X2200 IOVDD3 a_355624_135844# analog_io[19] IOVDD3 sg13_hv_pmos ad=3.1302p pd=14.26u as=3.9294p ps=7.84u w=6.66u l=0.6u
X2201 user_project_wrapper_0.analog_io[35] a_278644_355624# user_project_wrapper_0.IOVDD4 user_project_wrapper_0.IOVDD4 sg13_hv_pmos ad=3.9294p pd=7.84u as=2.1312p ps=7.3u w=6.66u l=0.6u
X2202 a_85359_125209# a_85211_124842# a_85257_125209# user_project_wrapper_0.VDD1 sg13_lv_pmos ad=0.2128p pd=1.5u as=0.2128p ps=1.5u w=1.12u l=0.13u
X2203 user_project_wrapper_0.IOVSS1 user_project_wrapper_0.sg13g2_IOPadVdd_1.sg13g2_RCClampResistor_0.p2 user_project_wrapper_0.IOVSS1 user_project_wrapper_0.IOVSS1 sg13_hv_nmos ad=1.71p pd=9.38u as=0 ps=0 w=9u l=9.5u
X2204 a_296732_200582# a_301940_196388# a_296625_208423# VDD3 sg13_lv_pmos ad=0.7695p pd=4.43u as=0.7695p ps=4.43u w=4.05u l=0.5u
X2205 a_296732_197880# a_296626_197740# VDD3 VDD3 sg13_lv_pmos ad=1.33p pd=7.38u as=2.38p ps=14.68u w=7u l=0.7u
X2206 user_project_wrapper_0.sg13g2_IOPadVdd_0.sg13g2_RCClampInverter_noptap_0.out user_project_wrapper_0.sg13g2_IOPadVdd_0.sg13g2_RCClampResistor_0.p2 VDD3 VDD3 sg13_hv_pmos ad=1.33p pd=7.38u as=1.33p ps=7.38u w=7u l=0.5u
X2207 user_project_wrapper_0.IOVDD1 user_project_wrapper_0.sg13g2_IOPadIOVdd_1.sg13g2_Clamp_N43N43D4R_0.gate user_project_wrapper_0.IOVSS1 user_project_wrapper_0.IOVSS1 sg13_hv_nmos ad=2.596p pd=5.58u as=1.408p ps=5.04u w=4.4u l=0.6u
X2208 IOVDD3 a_355624_237844# analog_io[23] IOVDD3 sg13_hv_pmos ad=2.1312p pd=7.3u as=3.9294p ps=7.84u w=6.66u l=0.6u
X2209 a_80635_364458# a_80305_360372# user_project_wrapper_0.IOVSS1 rppd l=20u w=1u
X2210 VDD3 a_296625_189595# a_296731_189665# VDD3 sg13_lv_pmos ad=0.2603p pd=1.75u as=0.2603p ps=1.75u w=1.37u l=0.35u
X2211 user_project_wrapper_0.IOVDD4 a_258244_355624# user_project_wrapper_0.analog_io[34] user_project_wrapper_0.IOVDD4 sg13_hv_pmos ad=2.1312p pd=7.3u as=3.9294p ps=7.84u w=6.66u l=0.6u
X2212 user_project_wrapper_0.sg13g2_IOPadVdd_2.sg13g2_RCClampInverter_noptap_0.out user_project_wrapper_0.sg13g2_IOPadVdd_2.sg13g2_RCClampResistor_0.p2 user_project_wrapper_0.VDD1 user_project_wrapper_0.VDD1 sg13_hv_pmos ad=1.33p pd=7.38u as=1.33p ps=7.38u w=7u l=0.5u
X2213 a_190297_326377# a_189756_326377# user_project_wrapper_0.IOVSS1 w_188704_326203# sg13_lv_pmos ad=0.68p pd=4.68u as=0.68p ps=4.68u w=2u l=0.13u
X2214 user_project_wrapper_0.IOVSS1 user_project_wrapper_0.sg13g2_IOPadVdd_1.sg13g2_RCClampInverter_noptap_0.out user_project_wrapper_0.VDD2 user_project_wrapper_0.IOVSS1 sg13_hv_nmos ad=1.408p pd=5.04u as=2.596p ps=5.58u w=4.4u l=0.6u
X2215 analog_io[20] a_355624_156244# IOVDD3 IOVDD3 sg13_hv_pmos ad=3.9294p pd=7.84u as=3.1302p ps=14.26u w=6.66u l=0.6u
X2216 user_project_wrapper_0.IOVSS1 a_182931_326125# user_project_wrapper_0.analog_io[27] user_project_wrapper_0.IOVSS1 sg13_lv_pmos ad=1.824p pd=9.98u as=1.824p ps=9.98u w=9.6u l=0.13u
X2217 user_project_wrapper_0.IOVSS1 user_project_wrapper_0.sg13g2_IOPadVdd_3.sg13g2_RCClampInverter_noptap_0.out user_project_wrapper_0.IOVSS1 user_project_wrapper_0.IOVSS1 sg13_hv_nmos ad=2.596p pd=5.58u as=0 ps=0 w=4.4u l=0.6u
X2218 a_186960_110495# a_186397_108409# user_project_wrapper_0.IOVSS1 rppd l=10u w=1u
X2219 a_309917_194695# a_309516_194555# VDD3 VDD3 sg13_lv_pmos ad=0.19p pd=1.38u as=0.19p ps=1.38u w=1u l=0.7u
X2220 user_project_wrapper_0.IOVSS1 a_202114_326125# user_project_wrapper_0.analog_io[32] user_project_wrapper_0.IOVSS1 sg13_lv_nmos ad=0.912p pd=5.18u as=0.912p ps=5.18u w=4.8u l=0.13u
X2221 user_project_wrapper_0.IOVSS1 user_project_wrapper_0.sg13g2_IOPadIOVdd_0.sg13g2_Clamp_N43N43D4R_0.gate user_project_wrapper_0.IOVDD2 user_project_wrapper_0.IOVSS1 sg13_hv_nmos ad=1.408p pd=5.04u as=2.596p ps=5.58u w=4.4u l=0.6u
X2222 a_296731_189665# a_296625_189595# VDD3 VDD3 sg13_lv_pmos ad=0.2603p pd=1.75u as=0.2603p ps=1.75u w=1.37u l=0.35u
X2223 VDD3 a_296625_208423# a_296731_208493# VDD3 sg13_lv_pmos ad=0.2603p pd=1.75u as=0.2603p ps=1.75u w=1.37u l=0.35u
X2224 analog_io[23] a_314793_198352# user_project_wrapper_0.IOVSS1 user_project_wrapper_0.IOVSS1 sg13_lv_nmos ad=1.02p pd=6.68u as=1.02p ps=6.68u w=3u l=1u
X2225 user_project_wrapper_0.analog_io[14] a_217444_41476# user_project_wrapper_0.IOVDD2 user_project_wrapper_0.IOVDD2 sg13_hv_pmos ad=3.9294p pd=7.84u as=2.1312p ps=7.3u w=6.66u l=0.6u
X2226 user_project_wrapper_0.IOVDD1 a_41476_135844# user_project_wrapper_0.IOVDD1 rppd l=12.9u w=0.5u
X2227 user_project_wrapper_0.IOVSS1 user_project_wrapper_0.sg13g2_IOPadVdd_0.sg13g2_RCClampInverter_noptap_0.out VDD3 user_project_wrapper_0.IOVSS1 sg13_hv_nmos ad=1.408p pd=5.04u as=2.596p ps=5.58u w=4.4u l=0.6u
X2228 user_project_wrapper_0.IOVSS1 a_182931_326125# user_project_wrapper_0.analog_io[27] user_project_wrapper_0.IOVSS1 sg13_lv_pmos ad=1.824p pd=9.98u as=1.824p ps=9.98u w=9.6u l=0.13u
X2229 analog_io[23] a_369296_237844# user_project_wrapper_0.IOVSS1 user_project_wrapper_0.IOVSS1 sg13_hv_nmos ad=2.596p pd=5.58u as=1.408p ps=5.04u w=4.4u l=0.6u
X2230 user_project_wrapper_0.IOVDD4 a_176644_355624# user_project_wrapper_0.analog_io[30] user_project_wrapper_0.IOVDD4 sg13_hv_pmos ad=3.1302p pd=14.26u as=3.9294p ps=7.84u w=6.66u l=0.6u
X2231 user_project_wrapper_0.IOVSS1 a_208017_326341# a_209041_326377# w_207887_326203# sg13_lv_pmos ad=0.68p pd=4.68u as=0.38p ps=2.38u w=2u l=0.13u
X2232 a_313884_211353# analog_io[23] a_311108_215937# user_project_wrapper_0.IOVSS1 sg13_lv_nmos ad=1.9p pd=10.38u as=1.9p ps=10.38u w=10u l=0.5u
X2233 QDLL_TOP_0.VDD a_190389_101343# user_project_wrapper_0.analog_io[15] QDLL_TOP_0.VDD sg13_lv_pmos ad=0.2128p pd=1.5u as=0.2128p ps=1.5u w=1.12u l=0.13u
X2234 VDD3 a_296625_208423# a_296731_208493# VDD3 sg13_lv_pmos ad=0.2603p pd=1.75u as=0.2603p ps=1.75u w=1.37u l=0.35u
X2235 user_project_wrapper_0.uo_PAD[3] user_project_wrapper_0.sg13g2_IOPadOut4mA$1_0.sg13g2_GateLevelUpInv_noptap$1$1_0.pgate user_project_wrapper_0.IOVDD1 user_project_wrapper_0.IOVDD1 sg13_hv_pmos ad=3.9294p pd=7.84u as=3.1302p ps=14.26u w=6.66u l=0.6u
X2236 user_project_wrapper_0.IOVSS1 user_project_wrapper_0.analog_io[29] dantenna l=1.26u w=27.78u
X2237 a_189858_325785# a_189756_326377# a_189756_325263# w_188704_326203# sg13_lv_pmos ad=0.38p pd=2.38u as=0.38p ps=2.38u w=2u l=0.13u
X2238 user_project_wrapper_0.analog_io[15] a_237844_41476# user_project_wrapper_0.IOVDD2 user_project_wrapper_0.IOVDD2 sg13_hv_pmos ad=3.9294p pd=7.84u as=2.1312p ps=7.3u w=6.66u l=0.6u
X2239 user_project_wrapper_0.IOVSS1 a_271172_100118# QDLL_TOP_0.VOUT user_project_wrapper_0.IOVSS1 sg13_lv_nmos ad=0.1406p pd=1.12u as=0.1406p ps=1.12u w=0.74u l=0.13u
X2240 a_93204_129062# a_87105_130835# user_project_wrapper_0.VDD1 user_project_wrapper_0.VDD1 sg13_lv_pmos ad=0.2128p pd=1.5u as=0.3808p ps=2.92u w=1.12u l=0.13u
X2241 a_296731_189665# a_296625_189595# VDD3 VDD3 sg13_lv_pmos ad=0.2603p pd=1.75u as=0.2603p ps=1.75u w=1.37u l=0.35u
X2242 user_project_wrapper_0.analog_io[32] a_217444_369296# user_project_wrapper_0.IOVSS1 user_project_wrapper_0.IOVSS1 sg13_hv_nmos ad=2.596p pd=5.58u as=1.408p ps=5.04u w=4.4u l=0.6u
X2243 VDD3 a_309516_194555# a_309917_194695# VDD3 sg13_lv_pmos ad=0.19p pd=1.38u as=0.19p ps=1.38u w=1u l=0.7u
X2244 user_project_wrapper_0.IOVSS1 user_project_wrapper_0.sg13g2_IOPadIOVdd_2.sg13g2_RCClampResistor_0.p2 user_project_wrapper_0.sg13g2_IOPadIOVdd_2.sg13g2_Clamp_N43N43D4R_0.gate user_project_wrapper_0.IOVSS1 sg13_hv_nmos ad=1.71p pd=9.38u as=1.71p ps=9.38u w=9u l=0.5u
X2245 user_project_wrapper_0.sg13g2_IOPadOut4mA$1_1.sg13g2_GateLevelUpInv_noptap$1$1_0.ngate a_57810_281517# user_project_wrapper_0.IOVSS1 user_project_wrapper_0.IOVSS1 sg13_hv_nmos ad=0.646p pd=4.48u as=0.646p ps=4.48u w=1.9u l=0.45u
X2246 user_project_wrapper_0.IOVSS1 a_202114_326125# user_project_wrapper_0.analog_io[32] user_project_wrapper_0.IOVSS1 sg13_lv_pmos ad=1.824p pd=9.98u as=1.824p ps=9.98u w=9.6u l=0.13u
X2247 user_project_wrapper_0.IOVSS1 user_project_wrapper_0.sg13g2_IOPadAnalog_17.padres a_189286_327491# user_project_wrapper_0.IOVSS1 sg13_lv_nmos ad=0.34p pd=2.68u as=0.19p ps=1.38u w=1u l=0.13u
X2248 user_project_wrapper_0.IOVSS1 user_project_wrapper_0.sg13g2_IOPadVdd_1.sg13g2_RCClampInverter_noptap_0.out user_project_wrapper_0.VDD2 user_project_wrapper_0.IOVSS1 sg13_hv_nmos ad=1.408p pd=5.04u as=2.596p ps=5.58u w=4.4u l=0.6u
X2249 user_project_wrapper_0.IOVSS1 a_135844_369296# user_project_wrapper_0.analog_io[28] user_project_wrapper_0.IOVSS1 sg13_hv_nmos ad=1.408p pd=5.04u as=2.596p ps=5.58u w=4.4u l=0.6u
X2250 QDLL_TOP_0.VOUT a_278644_29676# user_project_wrapper_0.IOVSS1 user_project_wrapper_0.IOVSS1 sg13_hv_nmos ad=2.596p pd=5.58u as=1.408p ps=5.04u w=4.4u l=0.6u
X2251 user_project_wrapper_0.IOVDD1 user_project_wrapper_0.sg13g2_IOPadIOVdd_1.sg13g2_RCClampResistor_0.p2 user_project_wrapper_0.sg13g2_IOPadIOVdd_1.sg13g2_Clamp_N43N43D4R_0.gate user_project_wrapper_0.IOVDD1 sg13_hv_pmos ad=1.33p pd=7.38u as=1.33p ps=7.38u w=7u l=0.5u
X2252 a_313884_185173# a_314793_197200# user_project_wrapper_0.IOVSS1 user_project_wrapper_0.IOVSS1 sg13_lv_nmos ad=0.57p pd=3.38u as=0.57p ps=3.38u w=3u l=1u
X2253 user_project_wrapper_0.IOVSS1 user_project_wrapper_0.sg13g2_IOPadVdd_3.sg13g2_RCClampInverter_noptap_0.out user_project_wrapper_0.IOVSS1 user_project_wrapper_0.IOVSS1 sg13_hv_nmos ad=1.408p pd=5.04u as=0 ps=0 w=4.4u l=0.6u
X2254 a_83389_128838# a_83079_128838# user_project_wrapper_0.IOVSS1 user_project_wrapper_0.IOVSS1 sg13_lv_nmos ad=0.1406p pd=1.12u as=0.2516p ps=2.16u w=0.74u l=0.13u
X2255 user_project_wrapper_0.IOVDD2 a_258244_41476# user_project_wrapper_0.analog_io[16] user_project_wrapper_0.IOVDD2 sg13_hv_pmos ad=2.1312p pd=7.3u as=3.9294p ps=7.84u w=6.66u l=0.6u
X2256 user_project_wrapper_0.analog_io[35] a_213870_324142# user_project_wrapper_0.IOVSS1 user_project_wrapper_0.IOVSS1 sg13_lv_pmos ad=1.824p pd=9.98u as=1.824p ps=9.98u w=9.6u l=0.13u
X2257 user_project_wrapper_0.IOVSS1 a_202114_326125# user_project_wrapper_0.analog_io[32] user_project_wrapper_0.IOVSS1 sg13_lv_pmos ad=1.824p pd=9.98u as=1.824p ps=9.98u w=9.6u l=0.13u
X2258 a_190824_326377# a_190501_326377# a_190722_326377# w_188704_326203# sg13_lv_pmos ad=0.38p pd=2.38u as=0.38p ps=2.38u w=2u l=0.13u
X2259 user_project_wrapper_0.IOVSS1 a_182931_326125# user_project_wrapper_0.analog_io[27] user_project_wrapper_0.IOVSS1 sg13_lv_pmos ad=1.824p pd=9.98u as=1.824p ps=9.98u w=9.6u l=0.13u
X2260 a_296731_208493# a_296625_208423# VDD3 VDD3 sg13_lv_pmos ad=0.2603p pd=1.75u as=0.2603p ps=1.75u w=1.37u l=0.35u
X2261 a_194687_324142# a_194279_327536# user_project_wrapper_0.IOVSS1 user_project_wrapper_0.IOVSS1 sg13_lv_nmos ad=0.912p pd=5.18u as=0.912p ps=5.18u w=4.8u l=0.13u
X2262 user_project_wrapper_0.analog_io[0] a_29676_115444# user_project_wrapper_0.IOVSS1 user_project_wrapper_0.IOVSS1 sg13_hv_nmos ad=2.596p pd=5.58u as=1.408p ps=5.04u w=4.4u l=0.6u
X2263 IOVDD3 a_355624_156244# analog_io[20] IOVDD3 sg13_hv_pmos ad=2.1312p pd=7.3u as=3.9294p ps=7.84u w=6.66u l=0.6u
X2264 a_194687_324142# a_194279_327536# user_project_wrapper_0.IOVSS1 user_project_wrapper_0.IOVSS1 sg13_lv_nmos ad=0.912p pd=5.18u as=0.912p ps=5.18u w=4.8u l=0.13u
X2265 user_project_wrapper_0.IOVSS1 a_237844_29676# user_project_wrapper_0.analog_io[15] user_project_wrapper_0.IOVSS1 sg13_hv_nmos ad=2.068p pd=9.74u as=2.596p ps=5.58u w=4.4u l=0.6u
X2266 a_304995_198817# a_304889_199957# a_304196_200821# user_project_wrapper_0.IOVSS1 sg13_lv_nmos ad=0.374p pd=2.88u as=0.209p ps=1.48u w=1.1u l=0.15u
X2267 a_296731_208493# a_296625_208423# VDD3 VDD3 sg13_lv_pmos ad=0.2603p pd=1.75u as=0.2603p ps=1.75u w=1.37u l=0.35u
X2268 user_project_wrapper_0.IOVDD4 a_217444_355624# user_project_wrapper_0.analog_io[32] user_project_wrapper_0.IOVDD4 sg13_hv_pmos ad=2.1312p pd=7.3u as=3.9294p ps=7.84u w=6.66u l=0.6u
X2269 user_project_wrapper_0.IOVSS1 user_project_wrapper_0.sg13g2_IOPadIOVdd_0.sg13g2_RCClampResistor_0.p2 user_project_wrapper_0.IOVSS1 user_project_wrapper_0.IOVSS1 sg13_hv_nmos ad=1.71p pd=9.38u as=0 ps=0 w=9u l=9.5u
X2270 a_311189_185546# a_296731_189665# a_313884_185173# user_project_wrapper_0.IOVSS1 sg13_lv_nmos ad=1.9p pd=10.38u as=1.9p ps=10.38u w=10u l=0.5u
X2271 user_project_wrapper_0.IOVSS1 a_314793_201808# a_309516_194555# user_project_wrapper_0.IOVSS1 sg13_lv_nmos ad=1.14p pd=6.38u as=2.04p ps=12.68u w=6u l=6.4u
X2272 user_project_wrapper_0.IOVSS1 a_186202_326221# a_182931_326125# user_project_wrapper_0.IOVSS1 sg13_lv_pmos ad=1.824p pd=9.98u as=1.824p ps=9.98u w=9.6u l=0.13u
X2273 user_project_wrapper_0.analog_io[32] a_202114_326125# user_project_wrapper_0.IOVSS1 user_project_wrapper_0.IOVSS1 sg13_lv_nmos ad=0.912p pd=5.18u as=0.912p ps=5.18u w=4.8u l=0.13u
X2274 user_project_wrapper_0.sg13g2_IOPadVdd_0.sg13g2_RCClampInverter_noptap_0.out user_project_wrapper_0.sg13g2_IOPadVdd_0.sg13g2_RCClampResistor_0.p2 VDD3 VDD3 sg13_hv_pmos ad=1.33p pd=7.38u as=1.33p ps=7.38u w=7u l=0.5u
X2275 a_189286_328605# a_189184_329719# a_189184_328605# w_188704_327938# sg13_lv_pmos ad=0.38p pd=2.38u as=0.38p ps=2.38u w=2u l=0.13u
X2276 user_project_wrapper_0.analog_io[32] a_202114_326125# user_project_wrapper_0.IOVSS1 user_project_wrapper_0.IOVSS1 sg13_lv_nmos ad=0.912p pd=5.18u as=0.912p ps=5.18u w=4.8u l=0.13u
X2277 a_304995_198817# a_304889_198885# a_304196_197873# user_project_wrapper_0.IOVSS1 sg13_lv_nmos ad=0.209p pd=1.48u as=0.209p ps=1.48u w=1.1u l=0.15u
X2278 user_project_wrapper_0.IOVSS1 QDLL_TOP_0.VOUT a_187914_99087# user_project_wrapper_0.IOVSS1 sg13_lv_nmos ad=79.8f pd=0.8u as=0.1428p ps=1.52u w=0.42u l=0.13u
X2279 user_project_wrapper_0.IOVSS1 user_project_wrapper_0.sg13g2_IOPadOut4mA$1_0.sg13g2_GateLevelUpInv_noptap$1$1_0.ngate user_project_wrapper_0.uo_PAD[3] user_project_wrapper_0.IOVSS1 sg13_hv_nmos ad=2.068p pd=9.74u as=2.596p ps=5.58u w=4.4u l=0.6u
X2280 IOVDD3 a_355624_258244# analog_io[25] IOVDD3 sg13_hv_pmos ad=2.1312p pd=7.3u as=3.9294p ps=7.84u w=6.66u l=0.6u
X2281 user_project_wrapper_0.analog_io[32] a_217444_355624# user_project_wrapper_0.IOVDD4 user_project_wrapper_0.IOVDD4 sg13_hv_pmos ad=3.9294p pd=7.84u as=2.1312p ps=7.3u w=6.66u l=0.6u
X2282 user_project_wrapper_0.IOVDD1 user_project_wrapper_0.sg13g2_IOPadIOVdd_1.sg13g2_Clamp_N43N43D4R_0.gate user_project_wrapper_0.IOVSS1 user_project_wrapper_0.IOVSS1 sg13_hv_nmos ad=2.596p pd=5.58u as=1.408p ps=5.04u w=4.4u l=0.6u
X2283 user_project_wrapper_0.IOVSS1 user_project_wrapper_0.sg13g2_IOPadVdd_3.sg13g2_RCClampInverter_noptap_0.out user_project_wrapper_0.IOVSS1 user_project_wrapper_0.IOVSS1 sg13_hv_nmos ad=1.408p pd=5.04u as=0 ps=0 w=4.4u l=0.6u
X2284 user_project_wrapper_0.IOVSS1 a_202114_326125# user_project_wrapper_0.analog_io[32] user_project_wrapper_0.IOVSS1 sg13_lv_pmos ad=1.824p pd=9.98u as=1.824p ps=9.98u w=9.6u l=0.13u
X2285 user_project_wrapper_0.IOVSS1 user_project_wrapper_0.sg13g2_IOPadIOVdd_0.sg13g2_Clamp_N43N43D4R_0.gate user_project_wrapper_0.IOVDD2 user_project_wrapper_0.IOVSS1 sg13_hv_nmos ad=1.408p pd=5.04u as=2.596p ps=5.58u w=4.4u l=0.6u
X2286 VDD3 user_project_wrapper_0.sg13g2_IOPadVdd_0.sg13g2_RCClampInverter_noptap_0.out user_project_wrapper_0.IOVSS1 user_project_wrapper_0.IOVSS1 sg13_hv_nmos ad=2.596p pd=5.58u as=1.408p ps=5.04u w=4.4u l=0.6u
X2287 user_project_wrapper_0.IOVSS1 user_project_wrapper_0.analog_io[0] dantenna l=27.78u w=1.26u
X2288 a_296731_189665# a_296625_189595# VDD3 VDD3 sg13_lv_pmos ad=0.2603p pd=1.75u as=0.2603p ps=1.75u w=1.37u l=0.35u
X2289 user_project_wrapper_0.IOVSS1 a_197044_29676# user_project_wrapper_0.analog_io[13] user_project_wrapper_0.IOVSS1 sg13_hv_nmos ad=1.408p pd=5.04u as=2.596p ps=5.58u w=4.4u l=0.6u
X2290 user_project_wrapper_0.IOVSS1 user_project_wrapper_0.sg13g2_IOPadVdd_3.sg13g2_RCClampInverter_noptap_0.out user_project_wrapper_0.IOVSS1 user_project_wrapper_0.IOVSS1 sg13_hv_nmos ad=2.596p pd=5.58u as=0 ps=0 w=4.4u l=0.6u
X2291 user_project_wrapper_0.IOVSS1 user_project_wrapper_0.sg13g2_IOPadVdd_3.sg13g2_RCClampInverter_noptap_0.out user_project_wrapper_0.IOVSS1 user_project_wrapper_0.IOVSS1 sg13_hv_nmos ad=2.596p pd=5.58u as=0 ps=0 w=4.4u l=0.6u
X2292 user_project_wrapper_0.analog_io[34] a_258244_355624# user_project_wrapper_0.IOVDD4 user_project_wrapper_0.IOVDD4 sg13_hv_pmos ad=3.9294p pd=7.84u as=2.1312p ps=7.3u w=6.66u l=0.6u
X2293 user_project_wrapper_0.analog_io[30] a_194687_324142# user_project_wrapper_0.IOVSS1 user_project_wrapper_0.IOVSS1 sg13_lv_nmos ad=0.912p pd=5.18u as=0.912p ps=5.18u w=4.8u l=0.13u
X2294 user_project_wrapper_0.analog_io[4] a_41476_197044# user_project_wrapper_0.IOVDD1 user_project_wrapper_0.IOVDD1 sg13_hv_pmos ad=3.9294p pd=7.84u as=2.1312p ps=7.3u w=6.66u l=0.6u
X2295 user_project_wrapper_0.IOVSS1 user_project_wrapper_0.sg13g2_IOPadVdd_1.sg13g2_RCClampInverter_noptap_0.out user_project_wrapper_0.VDD2 user_project_wrapper_0.IOVSS1 sg13_hv_nmos ad=1.408p pd=5.04u as=2.596p ps=5.58u w=4.4u l=0.6u
X2296 VDD3 a_296625_189595# a_296731_189665# VDD3 sg13_lv_pmos ad=0.2603p pd=1.75u as=0.2603p ps=1.75u w=1.37u l=0.35u
X2297 QDLL_TOP_0.VOUT a_278644_29676# user_project_wrapper_0.IOVSS1 user_project_wrapper_0.IOVSS1 sg13_hv_nmos ad=2.596p pd=5.58u as=1.408p ps=5.04u w=4.4u l=0.6u
X2298 user_project_wrapper_0.IOVSS1 user_project_wrapper_0.IOVSS1 user_project_wrapper_0.IOVSS1 rppd l=0.5u w=0.5u
X2299 QDLL_TOP_0.VOUT a_278644_41476# user_project_wrapper_0.IOVDD2 user_project_wrapper_0.IOVDD2 sg13_hv_pmos ad=3.9294p pd=7.84u as=2.1312p ps=7.3u w=6.66u l=0.6u
X2300 a_83925_130212# a_83398_130212# user_project_wrapper_0.VDD1 user_project_wrapper_0.VDD1 sg13_lv_pmos ad=0.3808p pd=2.92u as=0.3808p ps=2.92u w=1.12u l=0.13u
X2301 VDD3 a_309516_194555# a_309917_199879# VDD3 sg13_lv_pmos ad=0.19p pd=1.38u as=0.19p ps=1.38u w=1u l=0.7u
X2302 a_35456_80635# a_39542_80305# user_project_wrapper_0.IOVSS1 rppd l=20u w=1u
X2303 a_296731_189665# a_296625_189595# VDD3 VDD3 sg13_lv_pmos ad=0.2603p pd=1.75u as=0.2603p ps=1.75u w=1.37u l=0.35u
X2304 VDD3 a_296625_189595# a_296731_189665# VDD3 sg13_lv_pmos ad=0.2603p pd=1.75u as=0.2603p ps=1.75u w=1.37u l=0.35u
X2305 a_309917_194695# a_309516_194555# VDD3 VDD3 sg13_lv_pmos ad=0.19p pd=1.38u as=0.19p ps=1.38u w=1u l=0.7u
X2306 VDD3 a_309516_194555# a_309917_194695# VDD3 sg13_lv_pmos ad=0.19p pd=1.38u as=0.19p ps=1.38u w=1u l=0.7u
X2307 user_project_wrapper_0.analog_io[15] a_237844_41476# user_project_wrapper_0.IOVDD2 user_project_wrapper_0.IOVDD2 sg13_hv_pmos ad=3.9294p pd=7.84u as=2.1312p ps=7.3u w=6.66u l=0.6u
X2308 a_304995_198817# a_304889_199957# a_304196_200821# user_project_wrapper_0.IOVSS1 sg13_lv_nmos ad=0.209p pd=1.48u as=0.209p ps=1.48u w=1.1u l=0.15u
X2309 a_309917_199879# a_309516_194555# VDD3 VDD3 sg13_lv_pmos ad=0.19p pd=1.38u as=0.19p ps=1.38u w=1u l=0.7u
X2310 VDD3 a_309516_194555# a_309917_199879# VDD3 sg13_lv_pmos ad=0.19p pd=1.38u as=0.19p ps=1.38u w=1u l=0.7u
X2311 a_369296_258244# user_project_wrapper_0.IOVSS1 user_project_wrapper_0.IOVSS1 rppd l=3.54u w=0.5u
X2312 user_project_wrapper_0.sg13g2_IOPadVdd_2.sg13g2_RCClampInverter_noptap_0.out user_project_wrapper_0.sg13g2_IOPadVdd_2.sg13g2_RCClampResistor_0.p2 user_project_wrapper_0.IOVSS1 user_project_wrapper_0.IOVSS1 sg13_hv_nmos ad=1.71p pd=9.38u as=1.71p ps=9.38u w=9u l=0.5u
X2313 user_project_wrapper_0.IOVSS1 user_project_wrapper_0.sg13g2_IOPadIOVdd_0.sg13g2_Clamp_N43N43D4R_0.gate user_project_wrapper_0.IOVDD2 user_project_wrapper_0.IOVSS1 sg13_hv_nmos ad=1.408p pd=5.04u as=2.596p ps=5.58u w=4.4u l=0.6u
X2314 IOVDD3 a_355624_217444# analog_io[23] IOVDD3 sg13_hv_pmos ad=2.1312p pd=7.3u as=3.9294p ps=7.84u w=6.66u l=0.6u
X2315 user_project_wrapper_0.analog_io[28] a_135844_355624# user_project_wrapper_0.IOVDD4 user_project_wrapper_0.IOVDD4 sg13_hv_pmos ad=3.9294p pd=7.84u as=2.1312p ps=7.3u w=6.66u l=0.6u
X2316 user_project_wrapper_0.analog_io[14] a_217444_29676# user_project_wrapper_0.IOVSS1 user_project_wrapper_0.IOVSS1 sg13_hv_nmos ad=2.596p pd=5.58u as=1.408p ps=5.04u w=4.4u l=0.6u
X2317 a_309516_194555# a_309516_194555# VDD3 VDD3 sg13_lv_pmos ad=0.19p pd=1.38u as=0.19p ps=1.38u w=1u l=0.7u
X2318 user_project_wrapper_0.IOVSS1 user_project_wrapper_0.sg13g2_IOPadVdd_3.sg13g2_RCClampInverter_noptap_0.out user_project_wrapper_0.IOVSS1 user_project_wrapper_0.IOVSS1 sg13_hv_nmos ad=1.408p pd=5.04u as=0 ps=0 w=4.4u l=0.6u
X2319 user_project_wrapper_0.IOVSS1 user_project_wrapper_0.sg13g2_IOPadVdd_3.sg13g2_RCClampInverter_noptap_0.out user_project_wrapper_0.IOVSS1 user_project_wrapper_0.IOVSS1 sg13_hv_nmos ad=1.408p pd=5.04u as=0 ps=0 w=4.4u l=0.6u
X2320 a_79025_133911# a_78824_133051# user_project_wrapper_0.VDD1 user_project_wrapper_0.VDD1 sg13_lv_pmos ad=1.7p pd=10.68u as=1.7p ps=10.68u w=5u l=0.15u
X2321 a_307232_196607# a_296731_208493# a_309917_199879# VDD3 sg13_lv_pmos ad=0.24415p pd=1.665u as=0.24415p ps=1.665u w=1.285u l=0.35u
X2322 a_296625_189595# a_301940_196388# a_296732_197880# VDD3 sg13_lv_pmos ad=0.7695p pd=4.43u as=1.377p ps=8.78u w=4.05u l=0.5u
X2323 user_project_wrapper_0.IOVDD2 a_197044_41476# user_project_wrapper_0.analog_io[13] user_project_wrapper_0.IOVDD2 sg13_hv_pmos ad=3.1302p pd=14.26u as=3.9294p ps=7.84u w=6.66u l=0.6u
X2324 user_project_wrapper_0.sg13g2_IOPadVdd_0.sg13g2_RCClampInverter_noptap_0.out user_project_wrapper_0.sg13g2_IOPadVdd_0.sg13g2_RCClampResistor_0.p2 VDD3 VDD3 sg13_hv_pmos ad=1.33p pd=7.38u as=1.33p ps=7.38u w=7u l=0.5u
X2325 QDLL_TOP_0.VDD a_189729_101343# a_190389_101343# QDLL_TOP_0.VDD sg13_lv_pmos ad=0.2128p pd=1.5u as=0.2128p ps=1.5u w=1.12u l=0.13u
X2326 a_208469_330241# a_208367_325263# a_208367_329719# w_207883_330166# sg13_lv_pmos ad=0.38p pd=2.38u as=0.38p ps=2.38u w=2u l=0.13u
X2327 user_project_wrapper_0.IOVSS1 user_project_wrapper_0.sg13g2_IOPadVdd_0.sg13g2_RCClampInverter_noptap_0.out VDD3 user_project_wrapper_0.IOVSS1 sg13_hv_nmos ad=1.408p pd=5.04u as=2.596p ps=5.58u w=4.4u l=0.6u
X2328 a_296731_208493# a_296625_208423# VDD3 VDD3 sg13_lv_pmos ad=0.2603p pd=1.75u as=0.2603p ps=1.75u w=1.37u l=0.35u
X2329 IOVDD3 a_355624_197044# analog_io[22] IOVDD3 sg13_hv_pmos ad=2.1312p pd=7.3u as=3.9294p ps=7.84u w=6.66u l=0.6u
X2330 a_360372_75685# a_364458_76015# user_project_wrapper_0.IOVSS1 rppd l=20u w=1u
X2331 user_project_wrapper_0.IOVSS1 user_project_wrapper_0.sg13g2_IOPadIOVdd_3.sg13g2_Clamp_N43N43D4R_0.gate IOVDD3 user_project_wrapper_0.IOVSS1 sg13_hv_nmos ad=1.408p pd=5.04u as=2.596p ps=5.58u w=4.4u l=0.6u
X2332 VDD3 a_296625_189595# a_296731_189665# VDD3 sg13_lv_pmos ad=0.2603p pd=1.75u as=0.2603p ps=1.75u w=1.37u l=0.35u
X2333 user_project_wrapper_0.IOVSS1 user_project_wrapper_0.sg13g2_IOPadIOVdd_3.sg13g2_Clamp_N43N43D4R_0.gate IOVDD3 user_project_wrapper_0.IOVSS1 sg13_hv_nmos ad=1.408p pd=5.04u as=2.596p ps=5.58u w=4.4u l=0.6u
X2334 user_project_wrapper_0.IOVSS1 a_29676_197044# user_project_wrapper_0.analog_io[4] user_project_wrapper_0.IOVSS1 sg13_hv_nmos ad=1.408p pd=5.04u as=2.596p ps=5.58u w=4.4u l=0.6u
X2335 user_project_wrapper_0.analog_io[7] a_29676_258244# user_project_wrapper_0.IOVSS1 user_project_wrapper_0.IOVSS1 sg13_hv_nmos ad=2.596p pd=5.58u as=1.408p ps=5.04u w=4.4u l=0.6u
X2336 user_project_wrapper_0.sg13g2_IOPadVdd_2.sg13g2_RCClampInverter_noptap_0.out user_project_wrapper_0.sg13g2_IOPadVdd_2.sg13g2_RCClampResistor_0.p2 user_project_wrapper_0.VDD1 user_project_wrapper_0.VDD1 sg13_hv_pmos ad=1.33p pd=7.38u as=1.33p ps=7.38u w=7u l=0.5u
X2337 a_187852_92557# a_188408_90472# user_project_wrapper_0.IOVSS1 rppd l=10u w=1u
X2338 analog_io[23] a_369296_217444# user_project_wrapper_0.IOVSS1 user_project_wrapper_0.IOVSS1 sg13_hv_nmos ad=2.596p pd=5.58u as=1.408p ps=5.04u w=4.4u l=0.6u
X2339 user_project_wrapper_0.IOVDD4 user_project_wrapper_0.sg13g2_IOPadIOVdd_2.sg13g2_Clamp_N43N43D4R_0.gate user_project_wrapper_0.IOVSS1 user_project_wrapper_0.IOVSS1 sg13_hv_nmos ad=2.596p pd=5.58u as=1.408p ps=5.04u w=4.4u l=0.6u
X2340 user_project_wrapper_0.analog_io[30] a_176644_355624# user_project_wrapper_0.IOVDD4 user_project_wrapper_0.IOVDD4 sg13_hv_pmos ad=3.9294p pd=7.84u as=2.1312p ps=7.3u w=6.66u l=0.6u
X2341 a_304995_198817# a_304889_198885# a_304196_197873# user_project_wrapper_0.IOVSS1 sg13_lv_nmos ad=0.374p pd=2.88u as=0.209p ps=1.48u w=1.1u l=0.15u
X2342 user_project_wrapper_0.IOVDD4 user_project_wrapper_0.sg13g2_IOPadIOVdd_2.sg13g2_Clamp_N43N43D4R_0.gate user_project_wrapper_0.IOVSS1 user_project_wrapper_0.IOVSS1 sg13_hv_nmos ad=2.596p pd=5.58u as=1.408p ps=5.04u w=4.4u l=0.6u
X2343 VDD3 a_296625_208423# a_296731_208493# VDD3 sg13_lv_pmos ad=0.4658p pd=3.42u as=0.2603p ps=1.75u w=1.37u l=0.35u
X2344 user_project_wrapper_0.IOVSS1 user_project_wrapper_0.sg13g2_IOPadIOVdd_1.sg13g2_Clamp_N43N43D4R_0.gate user_project_wrapper_0.IOVDD1 user_project_wrapper_0.IOVSS1 sg13_hv_nmos ad=1.408p pd=5.04u as=2.596p ps=5.58u w=4.4u l=0.6u
X2345 user_project_wrapper_0.IOVSS1 user_project_wrapper_0.sg13g2_IOPadVdd_3.sg13g2_RCClampInverter_noptap_0.out user_project_wrapper_0.IOVSS1 user_project_wrapper_0.IOVSS1 sg13_hv_nmos ad=2.596p pd=5.58u as=0 ps=0 w=4.4u l=0.6u
X2346 user_project_wrapper_0.IOVSS1 a_188834_326341# a_189858_328013# w_188704_327938# sg13_lv_pmos ad=0.68p pd=4.68u as=0.38p ps=2.38u w=2u l=0.13u
X2347 user_project_wrapper_0.IOVSS1 user_project_wrapper_0.sg13g2_IOPadVdd_0.sg13g2_RCClampInverter_noptap_0.out VDD3 user_project_wrapper_0.IOVSS1 sg13_hv_nmos ad=1.408p pd=5.04u as=2.596p ps=5.58u w=4.4u l=0.6u
X2348 a_309917_199879# a_296731_208493# a_307232_196607# VDD3 sg13_lv_pmos ad=0.24415p pd=1.665u as=0.24415p ps=1.665u w=1.285u l=0.35u
X2349 user_project_wrapper_0.IOVSS1 user_project_wrapper_0.IOVSS1 user_project_wrapper_0.IOVSS1 rppd l=0.5u w=0.5u
X2350 user_project_wrapper_0.IOVSS1 a_217444_369296# user_project_wrapper_0.analog_io[32] user_project_wrapper_0.IOVSS1 sg13_hv_nmos ad=1.408p pd=5.04u as=2.596p ps=5.58u w=4.4u l=0.6u
X2351 user_project_wrapper_0.IOVSS1 a_182931_326125# user_project_wrapper_0.analog_io[27] user_project_wrapper_0.IOVSS1 sg13_lv_pmos ad=1.824p pd=9.98u as=1.824p ps=9.98u w=9.6u l=0.13u
X2352 user_project_wrapper_0.IOVDD2 a_156244_41476# user_project_wrapper_0.analog_io[11] user_project_wrapper_0.IOVDD2 sg13_hv_pmos ad=2.1312p pd=7.3u as=3.9294p ps=7.84u w=6.66u l=0.6u
X2353 user_project_wrapper_0.analog_io[30] a_176644_369296# user_project_wrapper_0.IOVSS1 user_project_wrapper_0.IOVSS1 sg13_hv_nmos ad=2.596p pd=5.58u as=1.408p ps=5.04u w=4.4u l=0.6u
X2354 user_project_wrapper_0.IOVSS1 user_project_wrapper_0.sg13g2_IOPadVdd_1.sg13g2_RCClampInverter_noptap_0.out user_project_wrapper_0.VDD2 user_project_wrapper_0.IOVSS1 sg13_hv_nmos ad=1.408p pd=5.04u as=2.596p ps=5.58u w=4.4u l=0.6u
X2355 user_project_wrapper_0.IOVSS1 user_project_wrapper_0.sg13g2_IOPadOut4mA$1_0.c2p a_58798_179249# user_project_wrapper_0.IOVSS1 sg13_lv_nmos ad=0.935p pd=6.18u as=0.935p ps=6.18u w=2.75u l=0.13u
X2356 analog_io[26] a_369296_278644# user_project_wrapper_0.IOVSS1 user_project_wrapper_0.IOVSS1 sg13_hv_nmos ad=2.596p pd=5.58u as=1.408p ps=5.04u w=4.4u l=0.6u
X2357 user_project_wrapper_0.analog_io[1] a_41476_135844# user_project_wrapper_0.IOVDD1 user_project_wrapper_0.IOVDD1 sg13_hv_pmos ad=3.9294p pd=7.84u as=2.1312p ps=7.3u w=6.66u l=0.6u
X2358 a_309516_194555# a_309516_194555# VDD3 VDD3 sg13_lv_pmos ad=0.19p pd=1.38u as=0.19p ps=1.38u w=1u l=0.7u
X2359 analog_io[22] a_355624_197044# IOVDD3 IOVDD3 sg13_hv_pmos ad=3.9294p pd=7.84u as=2.1312p ps=7.3u w=6.66u l=0.6u
X2360 user_project_wrapper_0.IOVSS1 a_182931_326125# user_project_wrapper_0.analog_io[27] user_project_wrapper_0.IOVSS1 sg13_lv_pmos ad=1.824p pd=9.98u as=1.824p ps=9.98u w=9.6u l=0.13u
X2361 VDD3 a_296625_189595# a_296731_189665# VDD3 sg13_lv_pmos ad=0.2603p pd=1.75u as=0.2603p ps=1.75u w=1.37u l=0.35u
X2362 user_project_wrapper_0.IOVDD1 a_41476_258244# user_project_wrapper_0.analog_io[7] user_project_wrapper_0.IOVDD1 sg13_hv_pmos ad=3.1302p pd=14.26u as=3.9294p ps=7.84u w=6.66u l=0.6u
X2363 a_360372_78985# a_364458_78655# user_project_wrapper_0.IOVSS1 rppd l=20u w=1u
X2364 user_project_wrapper_0.IOVDD4 user_project_wrapper_0.sg13g2_IOPadIOVdd_2.sg13g2_RCClampResistor_0.p2 user_project_wrapper_0.sg13g2_IOPadIOVdd_2.sg13g2_Clamp_N43N43D4R_0.gate user_project_wrapper_0.IOVDD4 sg13_hv_pmos ad=1.33p pd=7.38u as=1.33p ps=7.38u w=7u l=0.5u
X2365 user_project_wrapper_0.sg13g2_IOPadIn$1_1.sg13g2_LevelDown_noptap$1_0.sg13g2_SecondaryProtection$1$1_0.core user_project_wrapper_0.IOVDD1 dpantenna l=0.64u w=4.98u
X2366 QDLL_TOP_0.VDD a_190389_101343# user_project_wrapper_0.analog_io[15] QDLL_TOP_0.VDD sg13_lv_pmos ad=0.2128p pd=1.5u as=0.2128p ps=1.5u w=1.12u l=0.13u
X2367 user_project_wrapper_0.IOVSS1 user_project_wrapper_0.sg13g2_IOPadVdd_3.sg13g2_RCClampInverter_noptap_0.out user_project_wrapper_0.IOVSS1 user_project_wrapper_0.IOVSS1 sg13_hv_nmos ad=2.596p pd=5.58u as=0 ps=0 w=4.4u l=0.6u
X2368 IOVDD3 a_355624_135844# analog_io[19] IOVDD3 sg13_hv_pmos ad=2.1312p pd=7.3u as=3.9294p ps=7.84u w=6.66u l=0.6u
X2369 user_project_wrapper_0.analog_io[14] a_217444_29676# user_project_wrapper_0.IOVSS1 user_project_wrapper_0.IOVSS1 sg13_hv_nmos ad=2.596p pd=5.58u as=1.408p ps=5.04u w=4.4u l=0.6u
X2370 user_project_wrapper_0.IOVDD1 user_project_wrapper_0.sg13g2_IOPadIOVdd_1.sg13g2_Clamp_N43N43D4R_0.gate user_project_wrapper_0.IOVSS1 user_project_wrapper_0.IOVSS1 sg13_hv_nmos ad=2.596p pd=5.58u as=1.408p ps=5.04u w=4.4u l=0.6u
X2371 user_project_wrapper_0.analog_io[10] user_project_wrapper_0.IOVDD2 dpantenna l=1.26u w=27.78u
X2372 user_project_wrapper_0.IOVSS1 a_29676_237844# user_project_wrapper_0.analog_io[6] user_project_wrapper_0.IOVSS1 sg13_hv_nmos ad=1.408p pd=5.04u as=2.596p ps=5.58u w=4.4u l=0.6u
X2373 a_309917_194695# a_309516_194555# VDD3 VDD3 sg13_lv_pmos ad=0.19p pd=1.38u as=0.19p ps=1.38u w=1u l=0.7u
X2374 a_35456_301075# a_39542_300745# user_project_wrapper_0.IOVSS1 rppd l=20u w=1u
X2375 user_project_wrapper_0.analog_io[32] a_202114_326125# user_project_wrapper_0.IOVSS1 user_project_wrapper_0.IOVSS1 sg13_lv_nmos ad=0.912p pd=5.18u as=0.912p ps=5.18u w=4.8u l=0.13u
X2376 user_project_wrapper_0.analog_io[30] a_176644_355624# user_project_wrapper_0.IOVDD4 user_project_wrapper_0.IOVDD4 sg13_hv_pmos ad=3.9294p pd=7.84u as=2.1312p ps=7.3u w=6.66u l=0.6u
X2377 QDLL_TOP_0.VOUT a_278644_41476# user_project_wrapper_0.IOVDD2 user_project_wrapper_0.IOVDD2 sg13_hv_pmos ad=3.9294p pd=7.84u as=2.1312p ps=7.3u w=6.66u l=0.6u
X2378 user_project_wrapper_0.IOVSS1 a_182931_326125# user_project_wrapper_0.analog_io[27] user_project_wrapper_0.IOVSS1 sg13_lv_pmos ad=1.824p pd=9.98u as=1.824p ps=9.98u w=9.6u l=0.13u
X2379 analog_io[19] a_369296_135844# user_project_wrapper_0.IOVSS1 user_project_wrapper_0.IOVSS1 sg13_hv_nmos ad=2.596p pd=5.58u as=1.408p ps=5.04u w=4.4u l=0.6u
X2380 user_project_wrapper_0.analog_io[1] a_41476_135844# user_project_wrapper_0.IOVDD1 user_project_wrapper_0.IOVDD1 sg13_hv_pmos ad=3.9294p pd=7.84u as=2.1312p ps=7.3u w=6.66u l=0.6u
X2381 IOVDD3 a_355624_217444# analog_io[23] IOVDD3 sg13_hv_pmos ad=2.1312p pd=7.3u as=3.9294p ps=7.84u w=6.66u l=0.6u
X2382 user_project_wrapper_0.analog_io[15] a_237844_41476# user_project_wrapper_0.IOVDD2 user_project_wrapper_0.IOVDD2 sg13_hv_pmos ad=3.9294p pd=7.84u as=2.1312p ps=7.3u w=6.66u l=0.6u
X2383 a_314697_196700# a_314793_201808# a_315347_192648# user_project_wrapper_0.IOVSS1 sg13_lv_nmos ad=2.04p pd=12.68u as=1.14p ps=6.38u w=6u l=6.4u
X2384 a_304995_198817# a_304889_198885# a_304196_197873# user_project_wrapper_0.IOVSS1 sg13_lv_nmos ad=0.209p pd=1.48u as=0.209p ps=1.48u w=1.1u l=0.15u
X2385 user_project_wrapper_0.IOVDD1 user_project_wrapper_0.sg13g2_IOPadIOVdd_1.sg13g2_Clamp_N43N43D4R_0.gate user_project_wrapper_0.IOVSS1 user_project_wrapper_0.IOVSS1 sg13_hv_nmos ad=2.596p pd=5.58u as=1.408p ps=5.04u w=4.4u l=0.6u
X2386 a_309917_199879# a_309516_194555# VDD3 VDD3 sg13_lv_pmos ad=0.19p pd=1.38u as=0.19p ps=1.38u w=1u l=0.7u
X2387 user_project_wrapper_0.analog_io[35] a_278644_355624# user_project_wrapper_0.IOVDD4 user_project_wrapper_0.IOVDD4 sg13_hv_pmos ad=3.9294p pd=7.84u as=2.1312p ps=7.3u w=6.66u l=0.6u
X2388 a_194687_324142# a_194279_327536# user_project_wrapper_0.IOVSS1 user_project_wrapper_0.IOVSS1 sg13_lv_nmos ad=0.912p pd=5.18u as=0.912p ps=5.18u w=4.8u l=0.13u
X2389 user_project_wrapper_0.analog_io[27] a_115444_355624# user_project_wrapper_0.IOVDD4 user_project_wrapper_0.IOVDD4 sg13_hv_pmos ad=3.9294p pd=7.84u as=2.1312p ps=7.3u w=6.66u l=0.6u
X2390 user_project_wrapper_0.IOVSS1 user_project_wrapper_0.sg13g2_IOPadVdd_0.sg13g2_RCClampInverter_noptap_0.out VDD3 user_project_wrapper_0.IOVSS1 sg13_hv_nmos ad=1.408p pd=5.04u as=2.596p ps=5.58u w=4.4u l=0.6u
X2391 a_313884_211353# analog_io[23] a_311108_215937# user_project_wrapper_0.IOVSS1 sg13_lv_nmos ad=1.9p pd=10.38u as=1.9p ps=10.38u w=10u l=0.5u
X2392 user_project_wrapper_0.IOVSS1 a_186202_326221# a_182931_326125# user_project_wrapper_0.IOVSS1 sg13_lv_pmos ad=1.824p pd=9.98u as=1.824p ps=9.98u w=9.6u l=0.13u
X2393 user_project_wrapper_0.IOVSS1 user_project_wrapper_0.sg13g2_IOPadVdd_3.sg13g2_RCClampInverter_noptap_0.out user_project_wrapper_0.IOVSS1 user_project_wrapper_0.IOVSS1 sg13_hv_nmos ad=1.408p pd=5.04u as=0 ps=0 w=4.4u l=0.6u
X2394 user_project_wrapper_0.IOVSS1 a_258244_29676# user_project_wrapper_0.analog_io[16] user_project_wrapper_0.IOVSS1 sg13_hv_nmos ad=1.408p pd=5.04u as=2.596p ps=5.58u w=4.4u l=0.6u
X2395 user_project_wrapper_0.IOVDD4 a_258244_355624# user_project_wrapper_0.analog_io[34] user_project_wrapper_0.IOVDD4 sg13_hv_pmos ad=2.1312p pd=7.3u as=3.9294p ps=7.84u w=6.66u l=0.6u
X2396 a_314793_201808# a_314697_196700# VDD3 VDD3 sg13_lv_pmos ad=1.14p pd=6.38u as=1.14p ps=6.38u w=6u l=2.5u
X2397 a_121765_39542# a_122095_35456# user_project_wrapper_0.IOVSS1 rppd l=20u w=1u
X2398 user_project_wrapper_0.IOVSS1 user_project_wrapper_0.sg13g2_IOPadVdd_3.sg13g2_RCClampInverter_noptap_0.out user_project_wrapper_0.IOVSS1 user_project_wrapper_0.IOVSS1 sg13_hv_nmos ad=2.596p pd=5.58u as=0 ps=0 w=4.4u l=0.6u
X2399 user_project_wrapper_0.analog_io[33] a_237844_369296# user_project_wrapper_0.IOVSS1 user_project_wrapper_0.IOVSS1 sg13_hv_nmos ad=2.596p pd=5.58u as=1.408p ps=5.04u w=4.4u l=0.6u
X2400 a_309917_194695# a_309516_194555# VDD3 VDD3 sg13_lv_pmos ad=0.19p pd=1.38u as=0.19p ps=1.38u w=1u l=0.7u
X2401 analog_io[23] a_369296_217444# user_project_wrapper_0.IOVSS1 user_project_wrapper_0.IOVSS1 sg13_hv_nmos ad=2.596p pd=5.58u as=1.408p ps=5.04u w=4.4u l=0.6u
X2402 user_project_wrapper_0.IOVSS1 a_369296_156244# analog_io[20] user_project_wrapper_0.IOVSS1 sg13_hv_nmos ad=1.408p pd=5.04u as=2.596p ps=5.58u w=4.4u l=0.6u
X2403 user_project_wrapper_0.VDD2 user_project_wrapper_0.sg13g2_IOPadVdd_1.sg13g2_RCClampInverter_noptap_0.out user_project_wrapper_0.IOVSS1 user_project_wrapper_0.IOVSS1 sg13_hv_nmos ad=2.596p pd=5.58u as=1.408p ps=5.04u w=4.4u l=0.6u
X2404 analog_io[23] a_311108_215937# VDD3 user_project_wrapper_0.IOVSS1 sg13_lv_nmos ad=3.4p pd=20.68u as=3.4p ps=20.68u w=10u l=0.15u
X2405 IOVDD3 user_project_wrapper_0.sg13g2_IOPadIOVdd_3.sg13g2_Clamp_N43N43D4R_0.gate user_project_wrapper_0.IOVSS1 user_project_wrapper_0.IOVSS1 sg13_hv_nmos ad=2.596p pd=5.58u as=1.408p ps=5.04u w=4.4u l=0.6u
X2406 user_project_wrapper_0.IOVDD1 user_project_wrapper_0.sg13g2_IOPadIOVdd_1.sg13g2_Clamp_N43N43D4R_0.gate user_project_wrapper_0.IOVSS1 user_project_wrapper_0.IOVSS1 sg13_hv_nmos ad=2.596p pd=5.58u as=1.408p ps=5.04u w=4.4u l=0.6u
X2407 user_project_wrapper_0.IOVSS1 a_202114_326125# user_project_wrapper_0.analog_io[32] user_project_wrapper_0.IOVSS1 sg13_lv_pmos ad=1.824p pd=9.98u as=1.824p ps=9.98u w=9.6u l=0.13u
X2408 a_296731_208493# a_296625_208423# VDD3 VDD3 sg13_lv_pmos ad=0.2603p pd=1.75u as=0.2603p ps=1.75u w=1.37u l=0.35u
X2409 user_project_wrapper_0.IOVSS1 user_project_wrapper_0.sg13g2_IOPadIOVdd_1.sg13g2_Clamp_N43N43D4R_0.gate user_project_wrapper_0.IOVDD1 user_project_wrapper_0.IOVSS1 sg13_hv_nmos ad=1.408p pd=5.04u as=2.596p ps=5.58u w=4.4u l=0.6u
X2410 a_296731_189665# a_296625_189595# VDD3 VDD3 sg13_lv_pmos ad=0.2603p pd=1.75u as=0.2603p ps=1.75u w=1.37u l=0.35u
X2411 user_project_wrapper_0.IOVSS1 a_210645_324119# a_210307_324119# user_project_wrapper_0.IOVSS1 sg13_lv_nmos ad=0.34p pd=2.68u as=0.34p ps=2.68u w=1u l=0.65u
X2412 user_project_wrapper_0.IOVSS1 user_project_wrapper_0.IOVSS1 user_project_wrapper_0.IOVSS1 rhigh l=4u w=0.5u
X2413 a_296731_208493# a_296625_208423# VDD3 VDD3 sg13_lv_pmos ad=0.2603p pd=1.75u as=0.2603p ps=1.75u w=1.37u l=0.35u
X2414 a_89953_127531# a_89114_127896# user_project_wrapper_0.VDD1 user_project_wrapper_0.VDD1 sg13_lv_pmos ad=0.3808p pd=2.92u as=0.3808p ps=2.92u w=1.12u l=0.13u
X2415 user_project_wrapper_0.IOVSS1 user_project_wrapper_0.sg13g2_IOPadVdd_0.sg13g2_RCClampResistor_0.p2 user_project_wrapper_0.IOVSS1 user_project_wrapper_0.IOVSS1 sg13_hv_nmos ad=1.71p pd=9.38u as=0 ps=0 w=9u l=9.5u
X2416 VDD3 a_296626_197740# a_296732_200582# VDD3 sg13_lv_pmos ad=1.33p pd=7.38u as=1.33p ps=7.38u w=7u l=0.7u
X2417 user_project_wrapper_0.IOVSS1 a_188834_327918# a_189286_326377# w_188704_326203# sg13_lv_pmos ad=0.68p pd=4.68u as=0.38p ps=2.38u w=2u l=0.13u
X2418 user_project_wrapper_0.IOVSS1 a_186202_326221# a_182931_326125# user_project_wrapper_0.IOVSS1 sg13_lv_pmos ad=1.824p pd=9.98u as=1.824p ps=9.98u w=9.6u l=0.13u
X2419 a_309917_194695# a_309516_194555# VDD3 VDD3 sg13_lv_pmos ad=0.19p pd=1.38u as=0.19p ps=1.38u w=1u l=0.7u
X2420 user_project_wrapper_0.analog_io[7] a_41476_258244# user_project_wrapper_0.IOVDD1 user_project_wrapper_0.IOVDD1 sg13_hv_pmos ad=3.9294p pd=7.84u as=3.1302p ps=14.26u w=6.66u l=0.6u
X2421 user_project_wrapper_0.analog_io[30] a_194687_324142# user_project_wrapper_0.IOVSS1 user_project_wrapper_0.IOVSS1 sg13_lv_nmos ad=0.912p pd=5.18u as=0.912p ps=5.18u w=4.8u l=0.13u
X2422 a_314793_197200# a_314793_197200# user_project_wrapper_0.IOVSS1 user_project_wrapper_0.IOVSS1 sg13_lv_nmos ad=1.02p pd=6.68u as=1.02p ps=6.68u w=3u l=1u
X2423 user_project_wrapper_0.IOVDD4 user_project_wrapper_0.sg13g2_IOPadIOVdd_2.sg13g2_RCClampResistor_0.p2 user_project_wrapper_0.sg13g2_IOPadIOVdd_2.sg13g2_Clamp_N43N43D4R_0.gate user_project_wrapper_0.IOVDD4 sg13_hv_pmos ad=1.33p pd=7.38u as=1.33p ps=7.38u w=7u l=0.5u
X2424 a_311189_185546# a_296731_189665# a_313884_185173# user_project_wrapper_0.IOVSS1 sg13_lv_nmos ad=1.9p pd=10.38u as=1.9p ps=10.38u w=10u l=0.5u
X2425 a_309917_199879# a_309516_194555# VDD3 VDD3 sg13_lv_pmos ad=0.19p pd=1.38u as=0.19p ps=1.38u w=1u l=0.7u
X2426 user_project_wrapper_0.analog_io[30] a_194687_324142# user_project_wrapper_0.IOVSS1 user_project_wrapper_0.IOVSS1 sg13_lv_nmos ad=0.912p pd=5.18u as=0.912p ps=5.18u w=4.8u l=0.13u
X2427 user_project_wrapper_0.analog_io[15] a_190389_101343# user_project_wrapper_0.IOVSS1 user_project_wrapper_0.IOVSS1 sg13_lv_nmos ad=0.1406p pd=1.12u as=0.1406p ps=1.12u w=0.74u l=0.13u
X2428 user_project_wrapper_0.IOVSS1 user_project_wrapper_0.IOVSS1 user_project_wrapper_0.IOVSS1 rppd l=0.5u w=0.5u
X2429 user_project_wrapper_0.IOVSS1 a_209869_324119# a_209638_324119# user_project_wrapper_0.IOVSS1 sg13_lv_nmos ad=0.19p pd=1.38u as=0.34p ps=2.68u w=1u l=0.13u
X2430 a_191438_329719# a_191234_329719# user_project_wrapper_0.IOVSS1 w_188700_330166# sg13_lv_pmos ad=0.68p pd=4.68u as=0.38p ps=2.38u w=2u l=0.13u
X2431 a_202114_326125# a_205385_326221# user_project_wrapper_0.IOVSS1 user_project_wrapper_0.IOVSS1 sg13_lv_nmos ad=0.912p pd=5.18u as=0.912p ps=5.18u w=4.8u l=0.13u
X2432 user_project_wrapper_0.IOVSS1 user_project_wrapper_0.sg13g2_IOPadIOVdd_3.sg13g2_Clamp_N43N43D4R_0.gate IOVDD3 user_project_wrapper_0.IOVSS1 sg13_hv_nmos ad=1.408p pd=5.04u as=2.596p ps=5.58u w=4.4u l=0.6u
X2433 user_project_wrapper_0.VDD1 user_project_wrapper_0.sg13g2_IOPadVdd_2.sg13g2_RCClampInverter_noptap_0.out user_project_wrapper_0.IOVSS1 user_project_wrapper_0.IOVSS1 sg13_hv_nmos ad=2.596p pd=5.58u as=1.408p ps=5.04u w=4.4u l=0.6u
X2434 user_project_wrapper_0.IOVSS1 user_project_wrapper_0.IOVSS1 user_project_wrapper_0.IOVSS1 rppd l=0.5u w=0.5u
X2435 a_296731_189665# a_296625_189595# VDD3 VDD3 sg13_lv_pmos ad=0.2603p pd=1.75u as=0.2603p ps=1.75u w=1.37u l=0.35u
X2436 user_project_wrapper_0.IOVDD4 a_176644_355624# user_project_wrapper_0.analog_io[30] user_project_wrapper_0.IOVDD4 sg13_hv_pmos ad=2.1312p pd=7.3u as=3.9294p ps=7.84u w=6.66u l=0.6u
X2437 user_project_wrapper_0.analog_io[13] a_197044_41476# user_project_wrapper_0.IOVDD2 user_project_wrapper_0.IOVDD2 sg13_hv_pmos ad=3.9294p pd=7.84u as=2.1312p ps=7.3u w=6.66u l=0.6u
X2438 QDLL_TOP_0.VDD a_271172_100118# QDLL_TOP_0.VOUT QDLL_TOP_0.VDD sg13_lv_pmos ad=0.2128p pd=1.5u as=0.2128p ps=1.5u w=1.12u l=0.13u
X2439 a_210621_328605# TOP_ROILIFNEURON_0.MEM user_project_wrapper_0.IOVSS1 rppd l=0.5u w=0.5u
X2440 QDLL_TOP_0.VOUT a_278644_29676# user_project_wrapper_0.IOVSS1 user_project_wrapper_0.IOVSS1 sg13_hv_nmos ad=2.596p pd=5.58u as=1.408p ps=5.04u w=4.4u l=0.6u
X2441 VDD3 a_296625_189595# a_296731_189665# VDD3 sg13_lv_pmos ad=0.4658p pd=3.42u as=0.2603p ps=1.75u w=1.37u l=0.35u
X2442 VDD3 user_project_wrapper_0.sg13g2_IOPadVdd_0.sg13g2_RCClampInverter_noptap_0.out user_project_wrapper_0.IOVSS1 user_project_wrapper_0.IOVSS1 sg13_hv_nmos ad=2.596p pd=5.58u as=1.408p ps=5.04u w=4.4u l=0.6u
X2443 user_project_wrapper_0.VDD2 user_project_wrapper_0.sg13g2_IOPadVdd_1.sg13g2_RCClampInverter_noptap_0.out user_project_wrapper_0.IOVSS1 user_project_wrapper_0.IOVSS1 sg13_hv_nmos ad=2.596p pd=5.58u as=1.408p ps=5.04u w=4.4u l=0.6u
X2444 user_project_wrapper_0.analog_io[15] a_237844_29676# user_project_wrapper_0.IOVSS1 user_project_wrapper_0.IOVSS1 sg13_hv_nmos ad=2.596p pd=5.58u as=1.408p ps=5.04u w=4.4u l=0.6u
X2445 user_project_wrapper_0.IOVSS1 user_project_wrapper_0.sg13g2_IOPadIOVdd_3.sg13g2_Clamp_N43N43D4R_0.gate IOVDD3 user_project_wrapper_0.IOVSS1 sg13_hv_nmos ad=1.408p pd=5.04u as=2.596p ps=5.58u w=4.4u l=0.6u
X2446 user_project_wrapper_0.IOVSS1 user_project_wrapper_0.IOVSS1 user_project_wrapper_0.IOVSS1 rppd l=0.5u w=0.5u
X2447 a_309917_199879# a_309516_194555# VDD3 VDD3 sg13_lv_pmos ad=0.19p pd=1.38u as=0.19p ps=1.38u w=1u l=0.7u
X2448 a_304995_198817# a_307232_196607# user_project_wrapper_0.IOVSS1 user_project_wrapper_0.IOVSS1 sg13_lv_nmos ad=0.6327p pd=3.71u as=0.6327p ps=3.71u w=3.33u l=0.2u
X2449 user_project_wrapper_0.VDD2 user_project_wrapper_0.sg13g2_IOPadVdd_1.sg13g2_RCClampInverter_noptap_0.out user_project_wrapper_0.IOVSS1 user_project_wrapper_0.IOVSS1 sg13_hv_nmos ad=2.596p pd=5.58u as=1.408p ps=5.04u w=4.4u l=0.6u
X2450 a_89114_129061# a_88274_129426# user_project_wrapper_0.IOVSS1 user_project_wrapper_0.IOVSS1 sg13_lv_nmos ad=0.1406p pd=1.12u as=0.2516p ps=2.16u w=0.74u l=0.13u
X2451 VDD3 a_309516_194555# a_309917_194695# VDD3 sg13_lv_pmos ad=0.19p pd=1.38u as=0.19p ps=1.38u w=1u l=0.7u
X2452 VDD3 a_311108_179669# analog_io[20] user_project_wrapper_0.IOVSS1 sg13_lv_nmos ad=3.4p pd=20.68u as=3.4p ps=20.68u w=10u l=0.15u
X2453 a_298435_364458# a_298105_360372# user_project_wrapper_0.IOVSS1 rppd l=20u w=1u
X2454 user_project_wrapper_0.IOVSS1 user_project_wrapper_0.sg13g2_IOPadVdd_3.sg13g2_RCClampInverter_noptap_0.out user_project_wrapper_0.IOVSS1 user_project_wrapper_0.IOVSS1 sg13_hv_nmos ad=1.408p pd=5.04u as=0 ps=0 w=4.4u l=0.6u
X2455 user_project_wrapper_0.IOVSS1 user_project_wrapper_0.sg13g2_IOPadIOVdd_1.sg13g2_Clamp_N43N43D4R_0.gate user_project_wrapper_0.IOVDD1 user_project_wrapper_0.IOVSS1 sg13_hv_nmos ad=1.408p pd=5.04u as=2.596p ps=5.58u w=4.4u l=0.6u
X2456 user_project_wrapper_0.IOVSS1 user_project_wrapper_0.ui_PAD[31] dantenna l=27.78u w=1.26u
X2457 user_project_wrapper_0.IOVSS1 a_197044_29676# user_project_wrapper_0.analog_io[13] user_project_wrapper_0.IOVSS1 sg13_hv_nmos ad=2.068p pd=9.74u as=2.596p ps=5.58u w=4.4u l=0.6u
X2458 VDD3 a_309516_194555# a_309516_194555# VDD3 sg13_lv_pmos ad=0.19p pd=1.38u as=0.19p ps=1.38u w=1u l=0.7u
X2459 user_project_wrapper_0.IOVDD1 a_41476_258244# user_project_wrapper_0.analog_io[7] user_project_wrapper_0.IOVDD1 sg13_hv_pmos ad=2.1312p pd=7.3u as=3.9294p ps=7.84u w=6.66u l=0.6u
X2460 user_project_wrapper_0.VDD2 user_project_wrapper_0.sg13g2_IOPadVdd_1.sg13g2_RCClampResistor_0.p2 user_project_wrapper_0.sg13g2_IOPadVdd_1.sg13g2_RCClampInverter_noptap_0.out user_project_wrapper_0.VDD2 sg13_hv_pmos ad=1.33p pd=7.38u as=1.33p ps=7.38u w=7u l=0.5u
X2461 user_project_wrapper_0.uo_PAD[8] user_project_wrapper_0.IOVDD1 dpantenna l=27.78u w=1.26u
X2462 a_296731_208493# a_296625_208423# VDD3 VDD3 sg13_lv_pmos ad=0.2603p pd=1.75u as=0.4658p ps=3.42u w=1.37u l=0.35u
X2463 a_213870_324142# a_213462_327536# user_project_wrapper_0.IOVSS1 user_project_wrapper_0.IOVSS1 sg13_lv_pmos ad=1.824p pd=9.98u as=1.824p ps=9.98u w=9.6u l=0.13u
X2464 user_project_wrapper_0.analog_io[32] user_project_wrapper_0.sg13g2_IOPadAnalog_20.padres user_project_wrapper_0.IOVSS1 rppd l=2u w=1u
X2465 a_156244_41476# user_project_wrapper_0.IOVDD2 user_project_wrapper_0.IOVDD2 rppd l=12.9u w=0.5u
X2466 user_project_wrapper_0.IOVDD4 user_project_wrapper_0.sg13g2_IOPadIOVdd_2.sg13g2_Clamp_N43N43D4R_0.gate user_project_wrapper_0.IOVSS1 user_project_wrapper_0.IOVSS1 sg13_hv_nmos ad=3.256p pd=10.28u as=1.408p ps=5.04u w=4.4u l=0.6u
X2467 user_project_wrapper_0.analog_io[11] a_156244_41476# user_project_wrapper_0.IOVDD2 user_project_wrapper_0.IOVDD2 sg13_hv_pmos ad=3.9294p pd=7.84u as=2.1312p ps=7.3u w=6.66u l=0.6u
X2468 a_309917_199879# user_project_wrapper_0.sg13g2_IOPadAnalog_29.padres a_311846_195517# VDD3 sg13_lv_pmos ad=0.24415p pd=1.665u as=0.24415p ps=1.665u w=1.285u l=0.35u
X2469 a_189756_327491# user_project_wrapper_0.IOVSS1 user_project_wrapper_0.IOVSS1 w_188704_327938# sg13_lv_pmos ad=0.38p pd=2.38u as=0.68p ps=4.68u w=2u l=0.13u
X2470 QDLL_TOP_0.VDD user_project_wrapper_0.sg13g2_IOPadAnalog_6.padres a_268697_100118# QDLL_TOP_0.VDD sg13_lv_pmos ad=0.1523p pd=1.38u as=0.1428p ps=1.52u w=0.42u l=0.13u
X2471 analog_io[20] a_355624_156244# IOVDD3 IOVDD3 sg13_hv_pmos ad=3.9294p pd=7.84u as=2.1312p ps=7.3u w=6.66u l=0.6u
X2472 user_project_wrapper_0.IOVDD2 user_project_wrapper_0.sg13g2_IOPadIOVdd_0.sg13g2_Clamp_N43N43D4R_0.gate user_project_wrapper_0.IOVSS1 user_project_wrapper_0.IOVSS1 sg13_hv_nmos ad=2.596p pd=5.58u as=1.408p ps=5.04u w=4.4u l=0.6u
X2473 user_project_wrapper_0.IOVDD1 user_project_wrapper_0.sg13g2_IOPadIOVdd_1.sg13g2_RCClampResistor_0.p2 user_project_wrapper_0.sg13g2_IOPadIOVdd_1.sg13g2_Clamp_N43N43D4R_0.gate user_project_wrapper_0.IOVDD1 sg13_hv_pmos ad=1.33p pd=7.38u as=1.33p ps=7.38u w=7u l=0.5u
X2474 user_project_wrapper_0.IOVDD4 user_project_wrapper_0.sg13g2_IOPadIOVdd_2.sg13g2_Clamp_N43N43D4R_0.gate user_project_wrapper_0.IOVSS1 user_project_wrapper_0.IOVSS1 sg13_hv_nmos ad=2.596p pd=5.58u as=1.408p ps=5.04u w=4.4u l=0.6u
X2475 a_85591_241748# user_project_wrapper_0.sg13g2_IOPadIn$1_1.p2c a_85591_241383# user_project_wrapper_0.IOVSS1 sg13_lv_nmos ad=0.2516p pd=2.16u as=0.1406p ps=1.12u w=0.74u l=0.13u
X2476 user_project_wrapper_0.IOVSS1 user_project_wrapper_0.sg13g2_IOPadVdd_3.sg13g2_RCClampInverter_noptap_0.out user_project_wrapper_0.IOVSS1 user_project_wrapper_0.IOVSS1 sg13_hv_nmos ad=2.596p pd=5.58u as=0 ps=0 w=4.4u l=0.6u
X2477 user_project_wrapper_0.IOVDD4 user_project_wrapper_0.sg13g2_IOPadIOVdd_2.sg13g2_Clamp_N43N43D4R_0.gate user_project_wrapper_0.IOVSS1 user_project_wrapper_0.IOVSS1 sg13_hv_nmos ad=2.596p pd=5.58u as=1.408p ps=5.04u w=4.4u l=0.6u
X2478 user_project_wrapper_0.sg13g2_IOPadVdd_2.sg13g2_RCClampInverter_noptap_0.out user_project_wrapper_0.sg13g2_IOPadVdd_2.sg13g2_RCClampResistor_0.p2 user_project_wrapper_0.IOVSS1 user_project_wrapper_0.IOVSS1 sg13_hv_nmos ad=1.71p pd=9.38u as=3.06p ps=18.68u w=9u l=0.5u
X2479 user_project_wrapper_0.IOVDD2 user_project_wrapper_0.sg13g2_IOPadIOVdd_0.sg13g2_Clamp_N43N43D4R_0.gate user_project_wrapper_0.IOVSS1 user_project_wrapper_0.IOVSS1 sg13_hv_nmos ad=2.596p pd=5.58u as=1.408p ps=5.04u w=4.4u l=0.6u
X2480 user_project_wrapper_0.IOVSS1 user_project_wrapper_0.sg13g2_IOPadVdd_3.sg13g2_RCClampResistor_0.p2 user_project_wrapper_0.sg13g2_IOPadVdd_3.sg13g2_RCClampInverter_noptap_0.out user_project_wrapper_0.IOVSS1 sg13_hv_pmos ad=1.33p pd=7.38u as=1.33p ps=7.38u w=7u l=0.5u
X2481 user_project_wrapper_0.IOVDD2 a_258244_41476# user_project_wrapper_0.analog_io[16] user_project_wrapper_0.IOVDD2 sg13_hv_pmos ad=3.1302p pd=14.26u as=3.9294p ps=7.84u w=6.66u l=0.6u
X2482 user_project_wrapper_0.IOVSS1 a_29676_217444# user_project_wrapper_0.analog_io[5] user_project_wrapper_0.IOVSS1 sg13_hv_nmos ad=1.408p pd=5.04u as=2.596p ps=5.58u w=4.4u l=0.6u
X2483 user_project_wrapper_0.IOVSS1 a_301186_192011# a_296731_189665# user_project_wrapper_0.IOVSS1 sg13_lv_nmos ad=0.912p pd=5.18u as=0.912p ps=5.18u w=4.8u l=1.06u
X2484 user_project_wrapper_0.analog_io[27] a_182931_326125# user_project_wrapper_0.IOVSS1 user_project_wrapper_0.IOVSS1 sg13_lv_nmos ad=0.912p pd=5.18u as=0.912p ps=5.18u w=4.8u l=0.13u
X2485 analog_io[25] a_355624_258244# IOVDD3 IOVDD3 sg13_hv_pmos ad=3.9294p pd=7.84u as=2.1312p ps=7.3u w=6.66u l=0.6u
X2486 a_311108_179669# analog_io[20] a_313884_185173# user_project_wrapper_0.IOVSS1 sg13_lv_nmos ad=1.9p pd=10.38u as=3.4p ps=20.68u w=10u l=0.5u
X2487 a_296732_200582# a_301940_196388# a_296625_208423# VDD3 sg13_lv_pmos ad=0.7695p pd=4.43u as=0.7695p ps=4.43u w=4.05u l=0.5u
X2488 a_304196_200821# a_304889_199957# a_304995_198817# user_project_wrapper_0.IOVSS1 sg13_lv_nmos ad=0.209p pd=1.48u as=0.209p ps=1.48u w=1.1u l=0.15u
X2489 user_project_wrapper_0.IOVDD2 a_217444_41476# user_project_wrapper_0.analog_io[14] user_project_wrapper_0.IOVDD2 sg13_hv_pmos ad=2.1312p pd=7.3u as=3.9294p ps=7.84u w=6.66u l=0.6u
X2490 user_project_wrapper_0.IOVDD2 user_project_wrapper_0.sg13g2_IOPadIOVdd_0.sg13g2_Clamp_N43N43D4R_0.gate user_project_wrapper_0.IOVSS1 user_project_wrapper_0.IOVSS1 sg13_hv_nmos ad=2.596p pd=5.58u as=1.408p ps=5.04u w=4.4u l=0.6u
X2491 VDD3 a_296625_208423# a_296731_208493# VDD3 sg13_lv_pmos ad=0.4658p pd=3.42u as=0.2603p ps=1.75u w=1.37u l=0.35u
X2492 user_project_wrapper_0.IOVSS1 user_project_wrapper_0.IOVSS1 user_project_wrapper_0.IOVSS1 rppd l=0.5u w=0.5u
X2493 user_project_wrapper_0.VDD1 user_project_wrapper_0.sg13g2_IOPadVdd_2.sg13g2_RCClampInverter_noptap_0.out user_project_wrapper_0.IOVSS1 user_project_wrapper_0.IOVSS1 sg13_hv_nmos ad=2.596p pd=5.58u as=1.408p ps=5.04u w=4.4u l=0.6u
X2494 user_project_wrapper_0.IOVSS1 user_project_wrapper_0.sg13g2_IOPadIOVdd_2.sg13g2_Clamp_N43N43D4R_0.gate user_project_wrapper_0.IOVDD4 user_project_wrapper_0.IOVSS1 sg13_hv_nmos ad=1.408p pd=5.04u as=2.596p ps=5.58u w=4.4u l=0.6u
X2495 user_project_wrapper_0.IOVSS1 user_project_wrapper_0.sg13g2_IOPadVdd_0.sg13g2_RCClampInverter_noptap_0.out VDD3 user_project_wrapper_0.IOVSS1 sg13_hv_nmos ad=1.408p pd=5.04u as=2.596p ps=5.58u w=4.4u l=0.6u
X2496 user_project_wrapper_0.IOVSS1 a_156244_29676# user_project_wrapper_0.analog_io[11] user_project_wrapper_0.IOVSS1 sg13_hv_nmos ad=1.408p pd=5.04u as=2.596p ps=5.58u w=4.4u l=0.6u
X2497 user_project_wrapper_0.IOVDD2 user_project_wrapper_0.sg13g2_IOPadIOVdd_0.sg13g2_Clamp_N43N43D4R_0.gate user_project_wrapper_0.IOVSS1 user_project_wrapper_0.IOVSS1 sg13_hv_nmos ad=2.596p pd=5.58u as=2.068p ps=9.74u w=4.4u l=0.6u
X2498 user_project_wrapper_0.analog_io[14] a_190389_99046# user_project_wrapper_0.IOVSS1 user_project_wrapper_0.IOVSS1 sg13_lv_nmos ad=0.1406p pd=1.12u as=0.1406p ps=1.12u w=0.74u l=0.13u
X2499 user_project_wrapper_0.IOVDD2 a_156244_41476# user_project_wrapper_0.analog_io[11] user_project_wrapper_0.IOVDD2 sg13_hv_pmos ad=2.1312p pd=7.3u as=3.9294p ps=7.84u w=6.66u l=0.6u
X2500 IOVDD3 user_project_wrapper_0.sg13g2_IOPadIOVdd_3.sg13g2_Clamp_N43N43D4R_0.gate user_project_wrapper_0.IOVSS1 user_project_wrapper_0.IOVSS1 sg13_hv_nmos ad=2.596p pd=5.58u as=1.408p ps=5.04u w=4.4u l=0.6u
X2501 VDD3 a_296625_208423# a_296731_208493# VDD3 sg13_lv_pmos ad=0.2603p pd=1.75u as=0.2603p ps=1.75u w=1.37u l=0.35u
X2502 user_project_wrapper_0.IOVDD4 a_115444_355624# user_project_wrapper_0.analog_io[27] user_project_wrapper_0.IOVDD4 sg13_hv_pmos ad=2.1312p pd=7.3u as=3.9294p ps=7.84u w=6.66u l=0.6u
X2503 user_project_wrapper_0.VDD1 a_82667_125418# a_83592_125209# user_project_wrapper_0.VDD1 sg13_lv_pmos ad=0.3808p pd=2.92u as=0.2128p ps=1.5u w=1.12u l=0.13u
X2504 VDD3 a_296625_189595# a_296731_189665# VDD3 sg13_lv_pmos ad=0.2603p pd=1.75u as=0.2603p ps=1.75u w=1.37u l=0.35u
X2505 a_210621_329719# a_210417_329719# user_project_wrapper_0.IOVSS1 w_207883_330166# sg13_lv_pmos ad=0.68p pd=4.68u as=0.38p ps=2.38u w=2u l=0.13u
X2506 user_project_wrapper_0.IOVSS1 a_369296_258244# analog_io[25] user_project_wrapper_0.IOVSS1 sg13_hv_nmos ad=1.408p pd=5.04u as=2.596p ps=5.58u w=4.4u l=0.6u
X2507 user_project_wrapper_0.IOVDD1 user_project_wrapper_0.sg13g2_IOPadIOVdd_1.sg13g2_Clamp_N43N43D4R_0.gate user_project_wrapper_0.IOVSS1 user_project_wrapper_0.IOVSS1 sg13_hv_nmos ad=2.596p pd=5.58u as=1.408p ps=5.04u w=4.4u l=0.6u
X2508 user_project_wrapper_0.IOVSS1 user_project_wrapper_0.sg13g2_IOPadVdd_3.sg13g2_RCClampInverter_noptap_0.out user_project_wrapper_0.IOVSS1 user_project_wrapper_0.IOVSS1 sg13_hv_nmos ad=2.596p pd=5.58u as=0 ps=0 w=4.4u l=0.6u
X2509 user_project_wrapper_0.analog_io[13] user_project_wrapper_0.IOVDD2 dpantenna l=1.26u w=27.78u
X2510 a_309917_194695# a_296731_189665# a_307232_196607# VDD3 sg13_lv_pmos ad=0.24415p pd=1.665u as=0.24415p ps=1.665u w=1.285u l=0.35u
X2511 a_298765_39542# a_298435_35456# user_project_wrapper_0.IOVSS1 rppd l=20u w=1u
X2512 analog_io[20] a_369296_176644# user_project_wrapper_0.IOVSS1 user_project_wrapper_0.IOVSS1 sg13_hv_nmos ad=2.596p pd=5.58u as=2.068p ps=9.74u w=4.4u l=0.6u
X2513 user_project_wrapper_0.sg13g2_IOPadIOVdd_3.sg13g2_Clamp_N43N43D4R_0.gate user_project_wrapper_0.sg13g2_IOPadIOVdd_3.sg13g2_RCClampResistor_0.p2 IOVDD3 IOVDD3 sg13_hv_pmos ad=1.33p pd=7.38u as=2.38p ps=14.68u w=7u l=0.5u
X2514 user_project_wrapper_0.analog_io[33] a_237844_355624# user_project_wrapper_0.IOVDD4 user_project_wrapper_0.IOVDD4 sg13_hv_pmos ad=3.9294p pd=7.84u as=2.1312p ps=7.3u w=6.66u l=0.6u
X2515 a_79025_137844# a_78824_137391# user_project_wrapper_0.VDD1 user_project_wrapper_0.VDD1 sg13_lv_pmos ad=0.95p pd=5.38u as=1.7p ps=10.68u w=5u l=0.15u
X2516 user_project_wrapper_0.analog_io[32] a_202114_326125# user_project_wrapper_0.IOVSS1 user_project_wrapper_0.IOVSS1 sg13_lv_nmos ad=0.912p pd=5.18u as=0.912p ps=5.18u w=4.8u l=0.13u
X2517 user_project_wrapper_0.analog_io[15] a_237844_41476# user_project_wrapper_0.IOVDD2 user_project_wrapper_0.IOVDD2 sg13_hv_pmos ad=3.9294p pd=7.84u as=2.1312p ps=7.3u w=6.66u l=0.6u
X2518 a_186431_99272# user_project_wrapper_0.analog_io[13] user_project_wrapper_0.IOVSS1 user_project_wrapper_0.IOVSS1 sg13_lv_nmos ad=1.19p pd=7.68u as=1.19p ps=7.68u w=3.5u l=0.18u
X2519 user_project_wrapper_0.IOVDD1 user_project_wrapper_0.sg13g2_IOPadIOVdd_1.sg13g2_RCClampResistor_0.p2 user_project_wrapper_0.sg13g2_IOPadIOVdd_1.sg13g2_Clamp_N43N43D4R_0.gate user_project_wrapper_0.IOVDD1 sg13_hv_pmos ad=1.33p pd=7.38u as=1.33p ps=7.38u w=7u l=0.5u
X2520 user_project_wrapper_0.IOVSS1 a_307232_196607# a_307232_196607# user_project_wrapper_0.IOVSS1 sg13_lv_nmos ad=0.6327p pd=3.71u as=0.6327p ps=3.71u w=3.33u l=0.2u
X2521 VDD3 user_project_wrapper_0.sg13g2_IOPadVdd_0.sg13g2_RCClampInverter_noptap_0.out user_project_wrapper_0.IOVSS1 user_project_wrapper_0.IOVSS1 sg13_hv_nmos ad=2.596p pd=5.58u as=1.408p ps=5.04u w=4.4u l=0.6u
X2522 VDD3 a_296625_189595# a_296731_189665# VDD3 sg13_lv_pmos ad=0.2603p pd=1.75u as=0.2603p ps=1.75u w=1.37u l=0.35u
X2523 user_project_wrapper_0.IOVSS1 a_301186_192011# a_296731_189665# user_project_wrapper_0.IOVSS1 sg13_lv_nmos ad=0.912p pd=5.18u as=0.912p ps=5.18u w=4.8u l=1.06u
X2524 user_project_wrapper_0.IOVSS1 a_182931_326125# user_project_wrapper_0.analog_io[27] user_project_wrapper_0.IOVSS1 sg13_lv_pmos ad=1.824p pd=9.98u as=1.824p ps=9.98u w=9.6u l=0.13u
X2525 IOVDD3 a_355624_135844# analog_io[19] IOVDD3 sg13_hv_pmos ad=2.1312p pd=7.3u as=3.9294p ps=7.84u w=6.66u l=0.6u
X2526 analog_io[22] a_355624_197044# IOVDD3 IOVDD3 sg13_hv_pmos ad=3.9294p pd=7.84u as=2.1312p ps=7.3u w=6.66u l=0.6u
X2527 a_304196_200821# a_304889_199957# a_304995_198817# user_project_wrapper_0.IOVSS1 sg13_lv_nmos ad=0.209p pd=1.48u as=0.209p ps=1.48u w=1.1u l=0.15u
X2528 a_298105_39542# a_298435_35456# user_project_wrapper_0.IOVSS1 rppd l=20u w=1u
X2529 user_project_wrapper_0.IOVDD4 a_156244_355624# user_project_wrapper_0.analog_io[29] user_project_wrapper_0.IOVDD4 sg13_hv_pmos ad=2.1312p pd=7.3u as=3.9294p ps=7.84u w=6.66u l=0.6u
X2530 user_project_wrapper_0.analog_io[4] a_29676_197044# user_project_wrapper_0.IOVSS1 user_project_wrapper_0.IOVSS1 sg13_hv_nmos ad=2.596p pd=5.58u as=1.408p ps=5.04u w=4.4u l=0.6u
X2531 user_project_wrapper_0.IOVSS1 user_project_wrapper_0.sg13g2_IOPadIOVdd_0.sg13g2_Clamp_N43N43D4R_0.gate user_project_wrapper_0.IOVDD2 user_project_wrapper_0.IOVSS1 sg13_hv_nmos ad=1.408p pd=5.04u as=2.596p ps=5.58u w=4.4u l=0.6u
X2532 user_project_wrapper_0.analog_io[30] a_176644_355624# user_project_wrapper_0.IOVDD4 user_project_wrapper_0.IOVDD4 sg13_hv_pmos ad=3.9294p pd=7.84u as=2.1312p ps=7.3u w=6.66u l=0.6u
X2533 VDD3 a_296625_208423# a_296731_208493# VDD3 sg13_lv_pmos ad=0.2603p pd=1.75u as=0.2603p ps=1.75u w=1.37u l=0.35u
X2534 user_project_wrapper_0.IOVSS1 a_182931_326125# user_project_wrapper_0.analog_io[27] user_project_wrapper_0.IOVSS1 sg13_lv_pmos ad=1.824p pd=9.98u as=1.824p ps=9.98u w=9.6u l=0.13u
X2535 VDD3 a_309516_194555# a_309917_199879# VDD3 sg13_lv_pmos ad=0.19p pd=1.38u as=0.19p ps=1.38u w=1u l=0.7u
X2536 IOVDD3 a_355624_258244# analog_io[25] IOVDD3 sg13_hv_pmos ad=2.1312p pd=7.3u as=3.9294p ps=7.84u w=6.66u l=0.6u
X2537 user_project_wrapper_0.VDD1 a_85127_131750# a_86594_129426# user_project_wrapper_0.VDD1 sg13_lv_pmos ad=0.3808p pd=2.92u as=0.2128p ps=1.5u w=1.12u l=0.13u
X2538 user_project_wrapper_0.IOVDD2 user_project_wrapper_0.sg13g2_IOPadIOVdd_0.sg13g2_RCClampResistor_0.p2 user_project_wrapper_0.sg13g2_IOPadIOVdd_0.sg13g2_Clamp_N43N43D4R_0.gate user_project_wrapper_0.IOVDD2 sg13_hv_pmos ad=1.33p pd=7.38u as=1.33p ps=7.38u w=7u l=0.5u
X2539 user_project_wrapper_0.IOVDD2 user_project_wrapper_0.sg13g2_IOPadIOVdd_0.sg13g2_Clamp_N43N43D4R_0.gate user_project_wrapper_0.IOVSS1 user_project_wrapper_0.IOVSS1 sg13_hv_nmos ad=2.596p pd=5.58u as=1.408p ps=5.04u w=4.4u l=0.6u
X2540 analog_io[25] a_369296_258244# user_project_wrapper_0.IOVSS1 user_project_wrapper_0.IOVSS1 sg13_hv_nmos ad=2.596p pd=5.58u as=1.408p ps=5.04u w=4.4u l=0.6u
X2541 user_project_wrapper_0.IOVSS1 user_project_wrapper_0.sg13g2_IOPadOut4mA$1_1.c2p a_58170_281249# user_project_wrapper_0.IOVSS1 sg13_hv_nmos ad=0.361p pd=2.28u as=0.646p ps=4.48u w=1.9u l=0.45u
X2542 user_project_wrapper_0.IOVDD4 user_project_wrapper_0.sg13g2_IOPadIOVdd_2.sg13g2_Clamp_N43N43D4R_0.gate user_project_wrapper_0.IOVSS1 user_project_wrapper_0.IOVSS1 sg13_hv_nmos ad=2.596p pd=5.58u as=1.408p ps=5.04u w=4.4u l=0.6u
X2543 user_project_wrapper_0.IOVSS1 a_29676_135844# user_project_wrapper_0.analog_io[1] user_project_wrapper_0.IOVSS1 sg13_hv_nmos ad=1.408p pd=5.04u as=2.596p ps=5.58u w=4.4u l=0.6u
X2544 user_project_wrapper_0.IOVSS1 user_project_wrapper_0.sg13g2_IOPadIOVdd_1.sg13g2_Clamp_N43N43D4R_0.gate user_project_wrapper_0.IOVDD1 user_project_wrapper_0.IOVSS1 sg13_hv_nmos ad=1.408p pd=5.04u as=2.596p ps=5.58u w=4.4u l=0.6u
X2545 analog_io[20] a_355624_176644# IOVDD3 IOVDD3 sg13_hv_pmos ad=3.9294p pd=7.84u as=2.1312p ps=7.3u w=6.66u l=0.6u
X2546 a_355624_156244# IOVDD3 IOVDD3 rppd l=12.9u w=0.5u
X2547 a_298105_39542# a_297775_35456# user_project_wrapper_0.IOVSS1 rppd l=20u w=1u
X2548 user_project_wrapper_0.IOVDD1 a_41476_115444# user_project_wrapper_0.analog_io[0] user_project_wrapper_0.IOVDD1 sg13_hv_pmos ad=2.1312p pd=7.3u as=3.9294p ps=7.84u w=6.66u l=0.6u
X2549 a_296732_200582# a_296626_197740# VDD3 VDD3 sg13_lv_pmos ad=1.33p pd=7.38u as=2.38p ps=14.68u w=7u l=0.7u
X2550 user_project_wrapper_0.IOVSS1 a_369296_217444# analog_io[23] user_project_wrapper_0.IOVSS1 sg13_hv_nmos ad=1.408p pd=5.04u as=2.596p ps=5.58u w=4.4u l=0.6u
X2551 user_project_wrapper_0.IOVDD2 a_217444_41476# user_project_wrapper_0.analog_io[14] user_project_wrapper_0.IOVDD2 sg13_hv_pmos ad=2.1312p pd=7.3u as=3.9294p ps=7.84u w=6.66u l=0.6u
X2552 a_92512_127896# a_89953_127531# user_project_wrapper_0.VDD1 user_project_wrapper_0.VDD1 sg13_lv_pmos ad=0.2128p pd=1.5u as=0.3808p ps=2.92u w=1.12u l=0.13u
X2553 user_project_wrapper_0.IOVSS1 a_190297_328605# a_190926_329327# user_project_wrapper_0.IOVSS1 sg13_lv_nmos ad=0.34p pd=2.68u as=0.19p ps=1.38u w=1u l=0.13u
X2554 a_189184_327491# user_project_wrapper_0.IOVSS1 user_project_wrapper_0.IOVSS1 w_188704_327938# sg13_lv_pmos ad=0.38p pd=2.38u as=0.68p ps=4.68u w=2u l=0.13u
X2555 user_project_wrapper_0.sg13g2_IOPadOut4mA$1_0.c2p a_93204_129062# user_project_wrapper_0.VDD1 user_project_wrapper_0.VDD1 sg13_lv_pmos ad=0.3808p pd=2.92u as=0.3808p ps=2.92u w=1.12u l=0.13u
X2556 user_project_wrapper_0.sg13g2_IOPadIOVdd_3.sg13g2_Clamp_N43N43D4R_0.gate user_project_wrapper_0.sg13g2_IOPadIOVdd_3.sg13g2_RCClampResistor_0.p2 IOVDD3 IOVDD3 sg13_hv_pmos ad=1.33p pd=7.38u as=1.33p ps=7.38u w=7u l=0.5u
X2557 analog_io[26] a_355624_278644# IOVDD3 IOVDD3 sg13_hv_pmos ad=3.9294p pd=7.84u as=3.1302p ps=14.26u w=6.66u l=0.6u
X2558 user_project_wrapper_0.analog_io[32] a_202114_326125# user_project_wrapper_0.IOVSS1 user_project_wrapper_0.IOVSS1 sg13_lv_nmos ad=0.912p pd=5.18u as=0.912p ps=5.18u w=4.8u l=0.13u
X2559 user_project_wrapper_0.IOVSS1 a_369296_176644# analog_io[20] user_project_wrapper_0.IOVSS1 sg13_hv_nmos ad=1.408p pd=5.04u as=2.596p ps=5.58u w=4.4u l=0.6u
X2560 user_project_wrapper_0.IOVDD4 a_278644_355624# user_project_wrapper_0.IOVDD4 rppd l=12.9u w=0.5u
X2561 user_project_wrapper_0.analog_io[33] a_237844_369296# user_project_wrapper_0.IOVSS1 user_project_wrapper_0.IOVSS1 sg13_hv_nmos ad=2.596p pd=5.58u as=2.068p ps=9.74u w=4.4u l=0.6u
X2562 user_project_wrapper_0.IOVSS1 user_project_wrapper_0.sg13g2_IOPadVdd_1.sg13g2_RCClampInverter_noptap_0.out user_project_wrapper_0.VDD2 user_project_wrapper_0.IOVSS1 sg13_hv_nmos ad=1.408p pd=5.04u as=2.596p ps=5.58u w=4.4u l=0.6u
X2563 user_project_wrapper_0.IOVSS1 a_29676_217444# user_project_wrapper_0.analog_io[5] user_project_wrapper_0.IOVSS1 sg13_hv_nmos ad=1.408p pd=5.04u as=2.596p ps=5.58u w=4.4u l=0.6u
X2564 user_project_wrapper_0.IOVSS1 a_186202_326221# a_182931_326125# user_project_wrapper_0.IOVSS1 sg13_lv_pmos ad=1.824p pd=9.98u as=1.824p ps=9.98u w=9.6u l=0.13u
X2565 a_210007_328605# a_208367_328605# a_209905_329327# user_project_wrapper_0.IOVSS1 sg13_lv_nmos ad=0.19p pd=1.38u as=0.19p ps=1.38u w=1u l=0.13u
X2566 VDD3 a_309516_194555# a_309917_199879# VDD3 sg13_lv_pmos ad=0.19p pd=1.38u as=0.19p ps=1.38u w=1u l=0.7u
X2567 user_project_wrapper_0.IOVSS1 a_369296_197044# analog_io[22] user_project_wrapper_0.IOVSS1 sg13_hv_nmos ad=2.068p pd=9.74u as=2.596p ps=5.58u w=4.4u l=0.6u
X2568 user_project_wrapper_0.IOVDD1 a_41476_197044# user_project_wrapper_0.analog_io[4] user_project_wrapper_0.IOVDD1 sg13_hv_pmos ad=2.1312p pd=7.3u as=3.9294p ps=7.84u w=6.66u l=0.6u
X2569 a_191438_327491# TOP_ROILIFNEURON_0.MEM user_project_wrapper_0.IOVSS1 rppd l=0.5u w=0.5u
X2570 user_project_wrapper_0.IOVSS1 user_project_wrapper_0.sg13g2_IOPadVdd_1.sg13g2_RCClampInverter_noptap_0.out user_project_wrapper_0.VDD2 user_project_wrapper_0.IOVSS1 sg13_hv_nmos ad=1.408p pd=5.04u as=2.596p ps=5.58u w=4.4u l=0.6u
X2571 user_project_wrapper_0.analog_io[30] a_194687_324142# user_project_wrapper_0.IOVSS1 user_project_wrapper_0.IOVSS1 sg13_lv_nmos ad=0.912p pd=5.18u as=0.912p ps=5.18u w=4.8u l=0.13u
X2572 user_project_wrapper_0.sg13g2_IOPadVdd_2.sg13g2_RCClampInverter_noptap_0.out user_project_wrapper_0.sg13g2_IOPadVdd_2.sg13g2_RCClampResistor_0.p2 user_project_wrapper_0.VDD1 user_project_wrapper_0.VDD1 sg13_hv_pmos ad=1.33p pd=7.38u as=1.33p ps=7.38u w=7u l=0.5u
X2573 a_369296_115444# user_project_wrapper_0.IOVSS1 user_project_wrapper_0.IOVSS1 rppd l=3.54u w=0.5u
X2574 a_83796_129203# a_82658_129203# a_83796_128838# user_project_wrapper_0.IOVSS1 sg13_lv_nmos ad=0.2516p pd=2.16u as=0.1406p ps=1.12u w=0.74u l=0.13u
X2575 user_project_wrapper_0.IOVSS1 TOP_ROILIFNEURON_0.MEM a_192745_324776# w_188806_323975# sg13_lv_pmos ad=0.68p pd=4.68u as=0.38p ps=2.38u w=2u l=0.13u
X2576 a_304196_197873# a_304090_197941# a_296625_189595# user_project_wrapper_0.IOVSS1 sg13_lv_nmos ad=0.361p pd=2.28u as=0.361p ps=2.28u w=1.9u l=0.16u
X2577 user_project_wrapper_0.IOVSS1 a_187364_324106# a_187018_328627# user_project_wrapper_0.IOVSS1 sg13_lv_pmos ad=3.264p pd=19.88u as=3.264p ps=19.88u w=9.6u l=0.13u
X2578 user_project_wrapper_0.analog_io[0] a_41476_115444# user_project_wrapper_0.IOVDD1 user_project_wrapper_0.IOVDD1 sg13_hv_pmos ad=3.9294p pd=7.84u as=2.1312p ps=7.3u w=6.66u l=0.6u
X2579 VDD3 a_296625_208423# a_296731_208493# VDD3 sg13_lv_pmos ad=0.2603p pd=1.75u as=0.2603p ps=1.75u w=1.37u l=0.35u
X2580 a_191438_329719# a_191234_329719# user_project_wrapper_0.IOVSS1 w_188700_330166# sg13_lv_pmos ad=0.38p pd=2.38u as=0.68p ps=4.68u w=2u l=0.13u
X2581 user_project_wrapper_0.IOVSS1 user_project_wrapper_0.sg13g2_IOPadVdd_1.sg13g2_RCClampInverter_noptap_0.out dantenna l=0.48u w=0.48u
X2582 user_project_wrapper_0.VDD1 user_project_wrapper_0.sg13g2_IOPadVdd_2.sg13g2_RCClampInverter_noptap_0.out user_project_wrapper_0.IOVSS1 user_project_wrapper_0.IOVSS1 sg13_hv_nmos ad=2.596p pd=5.58u as=1.408p ps=5.04u w=4.4u l=0.6u
X2583 user_project_wrapper_0.IOVSS1 a_301186_192011# a_296731_208493# user_project_wrapper_0.IOVSS1 sg13_lv_nmos ad=0.912p pd=5.18u as=0.912p ps=5.18u w=4.8u l=1.06u
X2584 user_project_wrapper_0.IOVSS1 user_project_wrapper_0.IOVSS1 user_project_wrapper_0.IOVSS1 rppd l=0.5u w=0.5u
X2585 VDD3 user_project_wrapper_0.sg13g2_IOPadVdd_0.sg13g2_RCClampInverter_noptap_0.out user_project_wrapper_0.IOVSS1 user_project_wrapper_0.IOVSS1 sg13_hv_nmos ad=2.596p pd=5.58u as=1.408p ps=5.04u w=4.4u l=0.6u
X2586 user_project_wrapper_0.IOVDD1 a_41476_237844# user_project_wrapper_0.analog_io[6] user_project_wrapper_0.IOVDD1 sg13_hv_pmos ad=2.1312p pd=7.3u as=3.9294p ps=7.84u w=6.66u l=0.6u
X2587 user_project_wrapper_0.IOVSS1 user_project_wrapper_0.sg13g2_IOPadIOVdd_0.sg13g2_Clamp_N43N43D4R_0.gate user_project_wrapper_0.IOVDD2 user_project_wrapper_0.IOVSS1 sg13_hv_nmos ad=1.408p pd=5.04u as=2.596p ps=5.58u w=4.4u l=0.6u
X2588 user_project_wrapper_0.analog_io[16] a_258244_41476# user_project_wrapper_0.IOVDD2 user_project_wrapper_0.IOVDD2 sg13_hv_pmos ad=3.9294p pd=7.84u as=2.1312p ps=7.3u w=6.66u l=0.6u
X2589 IOVDD3 a_355624_176644# analog_io[20] IOVDD3 sg13_hv_pmos ad=3.1302p pd=14.26u as=3.9294p ps=7.84u w=6.66u l=0.6u
X2590 QDLL_TOP_0.VDD a_271172_100118# QDLL_TOP_0.VOUT QDLL_TOP_0.VDD sg13_lv_pmos ad=0.2128p pd=1.5u as=0.2128p ps=1.5u w=1.12u l=0.13u
X2591 user_project_wrapper_0.IOVSS1 user_project_wrapper_0.sg13g2_IOPadIOVdd_2.sg13g2_Clamp_N43N43D4R_0.gate user_project_wrapper_0.IOVDD4 user_project_wrapper_0.IOVSS1 sg13_hv_nmos ad=1.408p pd=5.04u as=2.596p ps=5.58u w=4.4u l=0.6u
X2592 a_304045_39542# a_304375_35456# user_project_wrapper_0.IOVSS1 rppd l=20u w=1u
X2593 user_project_wrapper_0.IOVSS1 user_project_wrapper_0.sg13g2_IOPadIOVdd_0.sg13g2_Clamp_N43N43D4R_0.gate user_project_wrapper_0.IOVDD2 user_project_wrapper_0.IOVSS1 sg13_hv_nmos ad=1.408p pd=5.04u as=2.596p ps=5.58u w=4.4u l=0.6u
X2594 a_296731_189665# a_296625_189595# VDD3 VDD3 sg13_lv_pmos ad=0.2603p pd=1.75u as=0.4658p ps=3.42u w=1.37u l=0.35u
X2595 user_project_wrapper_0.IOVSS1 user_project_wrapper_0.IOVSS1 user_project_wrapper_0.IOVSS1 rppd l=0.5u w=0.5u
X2596 user_project_wrapper_0.analog_io[15] a_237844_41476# user_project_wrapper_0.IOVDD2 user_project_wrapper_0.IOVDD2 sg13_hv_pmos ad=3.9294p pd=7.84u as=2.1312p ps=7.3u w=6.66u l=0.6u
X2597 IOVDD3 a_355624_278644# analog_io[26] IOVDD3 sg13_hv_pmos ad=2.1312p pd=7.3u as=3.9294p ps=7.84u w=6.66u l=0.6u
X2598 user_project_wrapper_0.IOVSS1 user_project_wrapper_0.sg13g2_IOPadVdd_0.sg13g2_RCClampInverter_noptap_0.out VDD3 user_project_wrapper_0.IOVSS1 sg13_hv_nmos ad=1.408p pd=5.04u as=2.596p ps=5.58u w=4.4u l=0.6u
X2599 user_project_wrapper_0.IOVDD1 a_57810_281517# a_58170_281249# user_project_wrapper_0.IOVDD1 sg13_hv_pmos ad=57f pd=0.68u as=0.102p ps=1.28u w=0.3u l=0.45u
X2600 a_304045_39542# a_303715_35456# user_project_wrapper_0.IOVSS1 rppd l=20u w=1u
X2601 user_project_wrapper_0.IOVSS1 user_project_wrapper_0.sg13g2_IOPadVdd_1.sg13g2_RCClampInverter_noptap_0.out user_project_wrapper_0.VDD2 user_project_wrapper_0.IOVSS1 sg13_hv_nmos ad=1.408p pd=5.04u as=2.596p ps=5.58u w=4.4u l=0.6u
X2602 a_296732_197880# a_296626_197740# VDD3 VDD3 sg13_lv_pmos ad=1.33p pd=7.38u as=2.38p ps=14.68u w=7u l=0.7u
X2603 user_project_wrapper_0.analog_io[33] a_237844_369296# user_project_wrapper_0.IOVSS1 user_project_wrapper_0.IOVSS1 sg13_hv_nmos ad=2.596p pd=5.58u as=1.408p ps=5.04u w=4.4u l=0.6u
X2604 analog_io[22] a_355624_197044# IOVDD3 IOVDD3 sg13_hv_pmos ad=3.9294p pd=7.84u as=2.1312p ps=7.3u w=6.66u l=0.6u
X2605 user_project_wrapper_0.sg13g2_IOPadAnalog_0.padres analog_io[18] user_project_wrapper_0.IOVSS1 rppd l=2u w=1u
X2606 user_project_wrapper_0.analog_io[15] a_190389_101343# user_project_wrapper_0.IOVSS1 user_project_wrapper_0.IOVSS1 sg13_lv_nmos ad=0.1406p pd=1.12u as=0.1406p ps=1.12u w=0.74u l=0.13u
X2607 user_project_wrapper_0.sg13g2_IOPadIOVdd_3.sg13g2_Clamp_N43N43D4R_0.gate user_project_wrapper_0.sg13g2_IOPadIOVdd_3.sg13g2_RCClampResistor_0.p2 IOVDD3 IOVDD3 sg13_hv_pmos ad=1.33p pd=7.38u as=1.33p ps=7.38u w=7u l=0.5u
X2608 VDD3 a_296625_189595# a_296731_189665# VDD3 sg13_lv_pmos ad=0.2603p pd=1.75u as=0.2603p ps=1.75u w=1.37u l=0.35u
X2609 a_118465_39542# a_118795_35456# user_project_wrapper_0.IOVSS1 rppd l=20u w=1u
X2610 user_project_wrapper_0.VDD2 user_project_wrapper_0.sg13g2_IOPadVdd_1.sg13g2_RCClampInverter_noptap_0.out user_project_wrapper_0.IOVSS1 user_project_wrapper_0.IOVSS1 sg13_hv_nmos ad=2.596p pd=5.58u as=1.408p ps=5.04u w=4.4u l=0.6u
X2611 user_project_wrapper_0.IOVSS1 a_209480_328605# a_210109_329327# user_project_wrapper_0.IOVSS1 sg13_lv_nmos ad=0.34p pd=2.68u as=0.19p ps=1.38u w=1u l=0.13u
X2612 user_project_wrapper_0.sg13g2_IOPadIOVdd_0.sg13g2_Clamp_N43N43D4R_0.gate user_project_wrapper_0.sg13g2_IOPadIOVdd_0.sg13g2_RCClampResistor_0.p2 user_project_wrapper_0.IOVSS1 user_project_wrapper_0.IOVSS1 sg13_hv_nmos ad=1.71p pd=9.38u as=3.06p ps=18.68u w=9u l=0.5u
X2613 a_190686_324119# a_189672_324776# a_190814_324870# user_project_wrapper_0.IOVSS1 sg13_lv_nmos ad=0.34p pd=2.68u as=0.19p ps=1.38u w=1u l=0.13u
X2614 user_project_wrapper_0.IOVSS1 user_project_wrapper_0.sg13g2_IOPadVdd_0.sg13g2_RCClampInverter_noptap_0.out VDD3 user_project_wrapper_0.IOVSS1 sg13_hv_nmos ad=1.408p pd=5.04u as=2.596p ps=5.58u w=4.4u l=0.6u
X2615 user_project_wrapper_0.VDD2 user_project_wrapper_0.sg13g2_IOPadVdd_1.sg13g2_RCClampInverter_noptap_0.out user_project_wrapper_0.IOVSS1 user_project_wrapper_0.IOVSS1 sg13_hv_nmos ad=2.596p pd=5.58u as=1.408p ps=5.04u w=4.4u l=0.6u
X2616 user_project_wrapper_0.IOVDD1 a_41476_115444# user_project_wrapper_0.analog_io[0] user_project_wrapper_0.IOVDD1 sg13_hv_pmos ad=3.1302p pd=14.26u as=3.9294p ps=7.84u w=6.66u l=0.6u
X2617 user_project_wrapper_0.IOVDD4 user_project_wrapper_0.sg13g2_IOPadIOVdd_2.sg13g2_Clamp_N43N43D4R_0.gate user_project_wrapper_0.IOVSS1 user_project_wrapper_0.IOVSS1 sg13_hv_nmos ad=2.596p pd=5.58u as=1.408p ps=5.04u w=4.4u l=0.6u
X2618 user_project_wrapper_0.sg13g2_IOPadIOVdd_3.sg13g2_Clamp_N43N43D4R_0.gate user_project_wrapper_0.sg13g2_IOPadIOVdd_3.sg13g2_RCClampResistor_0.p2 IOVDD3 IOVDD3 sg13_hv_pmos ad=1.33p pd=7.38u as=1.33p ps=7.38u w=7u l=0.5u
X2619 user_project_wrapper_0.analog_io[30] a_194687_324142# user_project_wrapper_0.IOVSS1 user_project_wrapper_0.IOVSS1 sg13_lv_pmos ad=1.824p pd=9.98u as=1.824p ps=9.98u w=9.6u l=0.13u
X2620 user_project_wrapper_0.analog_io[27] a_182931_326125# user_project_wrapper_0.IOVSS1 user_project_wrapper_0.IOVSS1 sg13_lv_nmos ad=0.912p pd=5.18u as=0.912p ps=5.18u w=4.8u l=0.13u
X2621 a_360372_75685# a_364458_75355# user_project_wrapper_0.IOVSS1 rppd l=20u w=1u
X2622 VDD3 user_project_wrapper_0.sg13g2_IOPadVdd_0.sg13g2_RCClampInverter_noptap_0.out user_project_wrapper_0.IOVSS1 user_project_wrapper_0.IOVSS1 sg13_hv_nmos ad=2.596p pd=5.58u as=1.408p ps=5.04u w=4.4u l=0.6u
X2623 user_project_wrapper_0.IOVSS1 user_project_wrapper_0.sg13g2_IOPadIOVdd_0.sg13g2_Clamp_N43N43D4R_0.gate user_project_wrapper_0.IOVDD2 user_project_wrapper_0.IOVSS1 sg13_hv_nmos ad=1.408p pd=5.04u as=2.596p ps=5.58u w=4.4u l=0.6u
X2624 a_296731_208493# a_296625_208423# VDD3 VDD3 sg13_lv_pmos ad=0.2603p pd=1.75u as=0.2603p ps=1.75u w=1.37u l=0.35u
X2625 user_project_wrapper_0.IOVDD4 a_237844_355624# user_project_wrapper_0.analog_io[33] user_project_wrapper_0.IOVDD4 sg13_hv_pmos ad=2.1312p pd=7.3u as=3.9294p ps=7.84u w=6.66u l=0.6u
X2626 QDLL_TOP_0.VDD a_271172_100118# QDLL_TOP_0.VOUT QDLL_TOP_0.VDD sg13_lv_pmos ad=0.3808p pd=2.92u as=0.2128p ps=1.5u w=1.12u l=0.13u
X2627 user_project_wrapper_0.IOVDD1 user_project_wrapper_0.sg13g2_IOPadIOVdd_1.sg13g2_RCClampResistor_0.p2 user_project_wrapper_0.sg13g2_IOPadIOVdd_1.sg13g2_Clamp_N43N43D4R_0.gate user_project_wrapper_0.IOVDD1 sg13_hv_pmos ad=2.38p pd=14.68u as=1.33p ps=7.38u w=7u l=0.5u
X2628 a_35456_299755# a_39542_299425# user_project_wrapper_0.IOVSS1 rppd l=20u w=1u
X2629 user_project_wrapper_0.IOVDD2 user_project_wrapper_0.sg13g2_IOPadIOVdd_0.sg13g2_RCClampResistor_0.p2 user_project_wrapper_0.sg13g2_IOPadIOVdd_0.sg13g2_Clamp_N43N43D4R_0.gate user_project_wrapper_0.IOVDD2 sg13_hv_pmos ad=1.33p pd=7.38u as=1.33p ps=7.38u w=7u l=0.5u
X2630 a_118465_39542# a_118135_35456# user_project_wrapper_0.IOVSS1 rppd l=20u w=1u
X2631 user_project_wrapper_0.analog_io[27] a_115444_369296# user_project_wrapper_0.IOVSS1 user_project_wrapper_0.IOVSS1 sg13_hv_nmos ad=2.596p pd=5.58u as=1.408p ps=5.04u w=4.4u l=0.6u
X2632 user_project_wrapper_0.IOVSS1 user_project_wrapper_0.sg13g2_IOPadVdd_3.sg13g2_RCClampResistor_0.p2 user_project_wrapper_0.sg13g2_IOPadVdd_3.sg13g2_RCClampInverter_noptap_0.out user_project_wrapper_0.IOVSS1 sg13_hv_pmos ad=1.33p pd=7.38u as=1.33p ps=7.38u w=7u l=0.5u
X2633 a_79025_126994# a_78824_126541# user_project_wrapper_0.VDD1 user_project_wrapper_0.VDD1 sg13_lv_pmos ad=0.95p pd=5.38u as=1.7p ps=10.68u w=5u l=0.15u
X2634 a_296731_208493# a_296625_208423# VDD3 VDD3 sg13_lv_pmos ad=0.2603p pd=1.75u as=0.2603p ps=1.75u w=1.37u l=0.35u
X2635 a_35456_79315# a_39542_78985# user_project_wrapper_0.IOVSS1 rppd l=20u w=1u
X2636 user_project_wrapper_0.IOVSS1 user_project_wrapper_0.sg13g2_IOPadVdd_0.sg13g2_RCClampInverter_noptap_0.out VDD3 user_project_wrapper_0.IOVSS1 sg13_hv_nmos ad=1.408p pd=5.04u as=2.596p ps=5.58u w=4.4u l=0.6u
X2637 a_83925_130212# a_83398_130212# user_project_wrapper_0.IOVSS1 user_project_wrapper_0.IOVSS1 sg13_lv_nmos ad=0.2516p pd=2.16u as=0.2516p ps=2.16u w=0.74u l=0.13u
X2638 analog_io[19] a_355624_135844# IOVDD3 IOVDD3 sg13_hv_pmos ad=3.9294p pd=7.84u as=2.1312p ps=7.3u w=6.66u l=0.6u
X2639 user_project_wrapper_0.IOVSS1 TOP_ROILIFNEURON_0.MEM a_211928_324776# w_207989_323975# sg13_lv_pmos ad=0.68p pd=4.68u as=0.38p ps=2.38u w=2u l=0.13u
X2640 user_project_wrapper_0.IOVDD4 user_project_wrapper_0.sg13g2_IOPadIOVdd_2.sg13g2_RCClampResistor_0.p2 user_project_wrapper_0.sg13g2_IOPadIOVdd_2.sg13g2_Clamp_N43N43D4R_0.gate user_project_wrapper_0.IOVDD4 sg13_hv_pmos ad=1.33p pd=7.38u as=1.33p ps=7.38u w=7u l=0.5u
X2641 a_213870_324142# a_213462_327536# user_project_wrapper_0.IOVSS1 user_project_wrapper_0.IOVSS1 sg13_lv_pmos ad=1.824p pd=9.98u as=1.824p ps=9.98u w=9.6u l=0.13u
X2642 a_210621_329719# a_210417_329719# user_project_wrapper_0.IOVSS1 w_207883_330166# sg13_lv_pmos ad=0.38p pd=2.38u as=0.68p ps=4.68u w=2u l=0.13u
X2643 a_83490_125209# a_82826_124842# a_83050_125173# user_project_wrapper_0.VDD1 sg13_lv_pmos ad=0.2128p pd=1.5u as=0.2128p ps=1.5u w=1.12u l=0.13u
X2644 user_project_wrapper_0.IOVSS1 a_301186_192011# a_296731_189665# user_project_wrapper_0.IOVSS1 sg13_lv_nmos ad=0.912p pd=5.18u as=0.912p ps=5.18u w=4.8u l=1.06u
X2645 user_project_wrapper_0.IOVDD4 a_176644_355624# user_project_wrapper_0.analog_io[30] user_project_wrapper_0.IOVDD4 sg13_hv_pmos ad=2.1312p pd=7.3u as=3.9294p ps=7.84u w=6.66u l=0.6u
X2646 a_117805_39542# a_118135_35456# user_project_wrapper_0.IOVSS1 rppd l=20u w=1u
X2647 user_project_wrapper_0.IOVSS1 user_project_wrapper_0.sg13g2_IOPadIOVdd_1.sg13g2_Clamp_N43N43D4R_0.gate user_project_wrapper_0.IOVDD1 user_project_wrapper_0.IOVSS1 sg13_hv_nmos ad=1.408p pd=5.04u as=2.596p ps=5.58u w=4.4u l=0.6u
X2648 user_project_wrapper_0.IOVSS1 user_project_wrapper_0.sg13g2_IOPadVdd_2.sg13g2_RCClampInverter_noptap_0.out user_project_wrapper_0.VDD1 user_project_wrapper_0.IOVSS1 sg13_hv_nmos ad=1.408p pd=5.04u as=2.596p ps=5.58u w=4.4u l=0.6u
X2649 a_296731_189665# a_301186_192011# user_project_wrapper_0.IOVSS1 user_project_wrapper_0.IOVSS1 sg13_lv_nmos ad=0.912p pd=5.18u as=0.912p ps=5.18u w=4.8u l=1.06u
X2650 user_project_wrapper_0.IOVSS1 user_project_wrapper_0.IOVSS1 user_project_wrapper_0.IOVSS1 rppd l=0.5u w=0.5u
X2651 IOVDD3 a_355624_176644# analog_io[20] IOVDD3 sg13_hv_pmos ad=2.1312p pd=7.3u as=3.9294p ps=7.84u w=6.66u l=0.6u
X2652 a_304995_198817# a_307232_196607# user_project_wrapper_0.IOVSS1 user_project_wrapper_0.IOVSS1 sg13_lv_nmos ad=0.6327p pd=3.71u as=0.6327p ps=3.71u w=3.33u l=0.2u
X2653 analog_io[23] a_355624_237844# IOVDD3 IOVDD3 sg13_hv_pmos ad=3.9294p pd=7.84u as=2.1312p ps=7.3u w=6.66u l=0.6u
X2654 user_project_wrapper_0.analog_io[35] a_213870_324142# user_project_wrapper_0.IOVSS1 user_project_wrapper_0.IOVSS1 sg13_lv_pmos ad=1.824p pd=9.98u as=1.824p ps=9.98u w=9.6u l=0.13u
X2655 user_project_wrapper_0.analog_io[29] a_156244_369296# user_project_wrapper_0.IOVSS1 user_project_wrapper_0.IOVSS1 sg13_hv_nmos ad=2.596p pd=5.58u as=1.408p ps=5.04u w=4.4u l=0.6u
X2656 user_project_wrapper_0.IOVSS1 a_182931_326125# user_project_wrapper_0.analog_io[27] user_project_wrapper_0.IOVSS1 sg13_lv_pmos ad=1.824p pd=9.98u as=1.824p ps=9.98u w=9.6u l=0.13u
X2657 user_project_wrapper_0.analog_io[32] a_202114_326125# user_project_wrapper_0.IOVSS1 user_project_wrapper_0.IOVSS1 sg13_lv_nmos ad=0.912p pd=5.18u as=1.632p ps=10.28u w=4.8u l=0.13u
X2658 a_192745_324776# TOP_ROILIFNEURON_0.MEM user_project_wrapper_0.IOVSS1 user_project_wrapper_0.IOVSS1 sg13_lv_nmos ad=0.19p pd=1.38u as=0.19p ps=1.38u w=1u l=0.13u
X2659 VDD3 a_309516_194555# a_309917_199879# VDD3 sg13_lv_pmos ad=0.34p pd=2.68u as=0.19p ps=1.38u w=1u l=0.7u
X2660 user_project_wrapper_0.IOVSS1 a_156244_29676# user_project_wrapper_0.analog_io[11] user_project_wrapper_0.IOVSS1 sg13_hv_nmos ad=1.408p pd=5.04u as=2.596p ps=5.58u w=4.4u l=0.6u
X2661 user_project_wrapper_0.VDD2 user_project_wrapper_0.sg13g2_IOPadVdd_1.sg13g2_RCClampInverter_noptap_0.out user_project_wrapper_0.IOVSS1 user_project_wrapper_0.IOVSS1 sg13_hv_nmos ad=2.596p pd=5.58u as=1.408p ps=5.04u w=4.4u l=0.6u
X2662 VDD3 a_296625_208423# a_296731_208493# VDD3 sg13_lv_pmos ad=0.4658p pd=3.42u as=0.2603p ps=1.75u w=1.37u l=0.35u
X2663 user_project_wrapper_0.analog_io[16] a_258244_41476# user_project_wrapper_0.IOVDD2 user_project_wrapper_0.IOVDD2 sg13_hv_pmos ad=3.9294p pd=7.84u as=2.1312p ps=7.3u w=6.66u l=0.6u
X2664 user_project_wrapper_0.sg13g2_IOPadIOVdd_3.sg13g2_Clamp_N43N43D4R_0.gate user_project_wrapper_0.sg13g2_IOPadIOVdd_3.sg13g2_RCClampResistor_0.p2 IOVDD3 IOVDD3 sg13_hv_pmos ad=1.33p pd=7.38u as=1.33p ps=7.38u w=7u l=0.5u
X2665 user_project_wrapper_0.analog_io[7] a_29676_258244# user_project_wrapper_0.IOVSS1 user_project_wrapper_0.IOVSS1 sg13_hv_nmos ad=2.596p pd=5.58u as=1.408p ps=5.04u w=4.4u l=0.6u
X2666 user_project_wrapper_0.IOVSS1 a_213870_324142# user_project_wrapper_0.analog_io[35] user_project_wrapper_0.IOVSS1 sg13_lv_nmos ad=0.912p pd=5.18u as=0.912p ps=5.18u w=4.8u l=0.13u
X2667 user_project_wrapper_0.analog_io[27] a_182931_326125# user_project_wrapper_0.IOVSS1 user_project_wrapper_0.IOVSS1 sg13_lv_nmos ad=0.912p pd=5.18u as=0.912p ps=5.18u w=4.8u l=0.13u
X2668 user_project_wrapper_0.analog_io[15] a_237844_29676# user_project_wrapper_0.IOVSS1 user_project_wrapper_0.IOVSS1 sg13_hv_nmos ad=2.596p pd=5.58u as=1.408p ps=5.04u w=4.4u l=0.6u
X2669 user_project_wrapper_0.IOVSS1 user_project_wrapper_0.sg13g2_IOPadVdd_3.sg13g2_RCClampResistor_0.p2 user_project_wrapper_0.IOVSS1 user_project_wrapper_0.IOVSS1 sg13_hv_nmos ad=1.71p pd=9.38u as=0 ps=0 w=9u l=9.5u
X2670 user_project_wrapper_0.IOVSS1 user_project_wrapper_0.sg13g2_IOPadIOVdd_3.sg13g2_Clamp_N43N43D4R_0.gate IOVDD3 user_project_wrapper_0.IOVSS1 sg13_hv_nmos ad=1.408p pd=5.04u as=2.596p ps=5.58u w=4.4u l=0.6u
X2671 user_project_wrapper_0.analog_io[32] a_217444_355624# user_project_wrapper_0.IOVDD4 user_project_wrapper_0.IOVDD4 sg13_hv_pmos ad=3.9294p pd=7.84u as=2.1312p ps=7.3u w=6.66u l=0.6u
X2672 analog_io[23] a_355624_237844# IOVDD3 IOVDD3 sg13_hv_pmos ad=3.9294p pd=7.84u as=2.1312p ps=7.3u w=6.66u l=0.6u
X2673 a_296625_189595# a_301940_196388# a_296732_197880# VDD3 sg13_lv_pmos ad=0.7695p pd=4.43u as=0.7695p ps=4.43u w=4.05u l=0.5u
X2674 a_313884_211353# a_296731_208493# a_311189_211724# user_project_wrapper_0.IOVSS1 sg13_lv_nmos ad=1.9p pd=10.38u as=1.9p ps=10.38u w=10u l=0.5u
X2675 user_project_wrapper_0.IOVSS1 user_project_wrapper_0.sg13g2_IOPadAnalog_14.padres dantenna l=0.64u w=3.1u
X2676 user_project_wrapper_0.IOVDD1 a_41476_197044# user_project_wrapper_0.analog_io[4] user_project_wrapper_0.IOVDD1 sg13_hv_pmos ad=2.1312p pd=7.3u as=3.9294p ps=7.84u w=6.66u l=0.6u
X2677 VDD3 a_309516_194555# a_309917_199879# VDD3 sg13_lv_pmos ad=0.19p pd=1.38u as=0.19p ps=1.38u w=1u l=0.7u
X2678 user_project_wrapper_0.sg13g2_IOPadVdd_0.sg13g2_RCClampInverter_noptap_0.out user_project_wrapper_0.sg13g2_IOPadVdd_0.sg13g2_RCClampResistor_0.p2 VDD3 VDD3 sg13_hv_pmos ad=1.33p pd=7.38u as=1.33p ps=7.38u w=7u l=0.5u
X2679 QDLL_TOP_0.VDD a_190389_99046# user_project_wrapper_0.analog_io[14] QDLL_TOP_0.VDD sg13_lv_pmos ad=0.2128p pd=1.5u as=0.2128p ps=1.5u w=1.12u l=0.13u
X2680 user_project_wrapper_0.VDD1 a_86507_127725# a_91090_129425# user_project_wrapper_0.VDD1 sg13_lv_pmos ad=0.3808p pd=2.92u as=0.2128p ps=1.5u w=1.12u l=0.13u
X2681 user_project_wrapper_0.analog_io[0] a_41476_115444# user_project_wrapper_0.IOVDD1 user_project_wrapper_0.IOVDD1 sg13_hv_pmos ad=3.9294p pd=7.84u as=3.1302p ps=14.26u w=6.66u l=0.6u
X2682 user_project_wrapper_0.VDD1 user_project_wrapper_0.sg13g2_IOPadVdd_2.sg13g2_RCClampInverter_noptap_0.out user_project_wrapper_0.IOVSS1 user_project_wrapper_0.IOVSS1 sg13_hv_nmos ad=2.596p pd=5.58u as=1.408p ps=5.04u w=4.4u l=0.6u
X2683 user_project_wrapper_0.IOVDD1 user_project_wrapper_0.sg13g2_IOPadIOVdd_1.sg13g2_RCClampResistor_0.p2 user_project_wrapper_0.sg13g2_IOPadIOVdd_1.sg13g2_Clamp_N43N43D4R_0.gate user_project_wrapper_0.IOVDD1 sg13_hv_pmos ad=1.33p pd=7.38u as=1.33p ps=7.38u w=7u l=0.5u
X2684 user_project_wrapper_0.IOVDD4 user_project_wrapper_0.sg13g2_IOPadIOVdd_2.sg13g2_Clamp_N43N43D4R_0.gate user_project_wrapper_0.IOVSS1 user_project_wrapper_0.IOVSS1 sg13_hv_nmos ad=2.596p pd=5.58u as=1.408p ps=5.04u w=4.4u l=0.6u
X2685 user_project_wrapper_0.analog_io[32] a_202114_326125# user_project_wrapper_0.IOVSS1 user_project_wrapper_0.IOVSS1 sg13_lv_nmos ad=0.912p pd=5.18u as=0.912p ps=5.18u w=4.8u l=0.13u
X2686 user_project_wrapper_0.IOVSS1 a_369296_237844# analog_io[23] user_project_wrapper_0.IOVSS1 sg13_hv_nmos ad=1.408p pd=5.04u as=2.596p ps=5.58u w=4.4u l=0.6u
X2687 user_project_wrapper_0.IOVDD1 a_41476_237844# user_project_wrapper_0.analog_io[6] user_project_wrapper_0.IOVDD1 sg13_hv_pmos ad=2.1312p pd=7.3u as=3.9294p ps=7.84u w=6.66u l=0.6u
X2688 user_project_wrapper_0.analog_io[34] a_258244_355624# user_project_wrapper_0.IOVDD4 user_project_wrapper_0.IOVDD4 sg13_hv_pmos ad=3.9294p pd=7.84u as=2.1312p ps=7.3u w=6.66u l=0.6u
X2689 user_project_wrapper_0.analog_io[32] a_202114_326125# user_project_wrapper_0.IOVSS1 user_project_wrapper_0.IOVSS1 sg13_lv_nmos ad=0.912p pd=5.18u as=0.912p ps=5.18u w=4.8u l=0.13u
X2690 VDD3 a_296625_189595# a_296731_189665# VDD3 sg13_lv_pmos ad=0.2603p pd=1.75u as=0.2603p ps=1.75u w=1.37u l=0.35u
X2691 a_190926_328013# a_189184_327491# a_190824_327491# w_188704_327938# sg13_lv_pmos ad=0.38p pd=2.38u as=0.38p ps=2.38u w=2u l=0.13u
X2692 user_project_wrapper_0.IOVSS1 a_182931_326125# user_project_wrapper_0.analog_io[27] user_project_wrapper_0.IOVSS1 sg13_lv_pmos ad=1.824p pd=9.98u as=1.824p ps=9.98u w=9.6u l=0.13u
X2693 VDD3 a_309516_194555# a_309917_199879# VDD3 sg13_lv_pmos ad=0.19p pd=1.38u as=0.19p ps=1.38u w=1u l=0.7u
X2694 user_project_wrapper_0.IOVDD4 user_project_wrapper_0.sg13g2_IOPadIOVdd_2.sg13g2_Clamp_N43N43D4R_0.gate user_project_wrapper_0.IOVSS1 user_project_wrapper_0.IOVSS1 sg13_hv_nmos ad=2.596p pd=5.58u as=1.408p ps=5.04u w=4.4u l=0.6u
X2695 user_project_wrapper_0.sg13g2_IOPadVdd_1.sg13g2_RCClampInverter_noptap_0.out user_project_wrapper_0.sg13g2_IOPadVdd_1.sg13g2_RCClampResistor_0.p2 user_project_wrapper_0.VDD2 user_project_wrapper_0.VDD2 sg13_hv_pmos ad=1.33p pd=7.38u as=1.33p ps=7.38u w=7u l=0.5u
X2696 user_project_wrapper_0.IOVSS1 user_project_wrapper_0.sg13g2_IOPadIOVdd_1.sg13g2_Clamp_N43N43D4R_0.gate user_project_wrapper_0.IOVDD1 user_project_wrapper_0.IOVSS1 sg13_hv_nmos ad=1.408p pd=5.04u as=2.596p ps=5.58u w=4.4u l=0.6u
X2697 user_project_wrapper_0.IOVDD4 a_115444_355624# user_project_wrapper_0.analog_io[27] user_project_wrapper_0.IOVDD4 sg13_hv_pmos ad=3.1302p pd=14.26u as=3.9294p ps=7.84u w=6.66u l=0.6u
X2698 user_project_wrapper_0.IOVDD2 a_217444_41476# user_project_wrapper_0.analog_io[14] user_project_wrapper_0.IOVDD2 sg13_hv_pmos ad=3.1302p pd=14.26u as=3.9294p ps=7.84u w=6.66u l=0.6u
X2699 user_project_wrapper_0.VDD2 user_project_wrapper_0.sg13g2_IOPadVdd_1.sg13g2_RCClampInverter_noptap_0.out user_project_wrapper_0.IOVSS1 user_project_wrapper_0.IOVSS1 sg13_hv_nmos ad=2.596p pd=5.58u as=2.068p ps=9.74u w=4.4u l=0.6u
X2700 a_304995_198817# a_304889_199957# a_304196_200821# user_project_wrapper_0.IOVSS1 sg13_lv_nmos ad=0.209p pd=1.48u as=0.209p ps=1.48u w=1.1u l=0.15u
X2701 user_project_wrapper_0.IOVSS1 a_29676_258244# user_project_wrapper_0.analog_io[7] user_project_wrapper_0.IOVSS1 sg13_hv_nmos ad=1.408p pd=5.04u as=2.596p ps=5.58u w=4.4u l=0.6u
X2702 a_311108_179669# analog_io[20] a_313884_185173# user_project_wrapper_0.IOVSS1 sg13_lv_nmos ad=1.9p pd=10.38u as=1.9p ps=10.38u w=10u l=0.5u
X2703 IOVDD3 a_355624_115444# analog_io[18] IOVDD3 sg13_hv_pmos ad=2.1312p pd=7.3u as=3.9294p ps=7.84u w=6.66u l=0.6u
X2704 a_78824_135221# user_project_wrapper_0.sg13g2_IOPadAnalog_8.padres user_project_wrapper_0.IOVSS1 user_project_wrapper_0.IOVSS1 sg13_lv_nmos ad=0.17p pd=1.68u as=0.17p ps=1.68u w=0.5u l=0.15u
X2705 user_project_wrapper_0.IOVSS1 user_project_wrapper_0.sg13g2_IOPadIOVdd_2.sg13g2_Clamp_N43N43D4R_0.gate user_project_wrapper_0.IOVDD4 user_project_wrapper_0.IOVSS1 sg13_hv_nmos ad=1.408p pd=5.04u as=2.596p ps=5.58u w=4.4u l=0.6u
X2706 user_project_wrapper_0.sg13g2_IOPadIOVdd_0.sg13g2_Clamp_N43N43D4R_0.gate user_project_wrapper_0.sg13g2_IOPadIOVdd_0.sg13g2_RCClampResistor_0.p2 user_project_wrapper_0.IOVSS1 user_project_wrapper_0.IOVSS1 sg13_hv_nmos ad=1.71p pd=9.38u as=3.06p ps=18.68u w=9u l=0.5u
X2707 a_304196_197873# a_304889_198885# a_304995_198817# user_project_wrapper_0.IOVSS1 sg13_lv_nmos ad=0.209p pd=1.48u as=0.209p ps=1.48u w=1.1u l=0.15u
X2708 user_project_wrapper_0.analog_io[28] user_project_wrapper_0.sg13g2_IOPadAnalog_19.padres user_project_wrapper_0.IOVSS1 rppd l=2u w=1u
X2709 VDD3 a_296625_208423# a_296731_208493# VDD3 sg13_lv_pmos ad=0.2603p pd=1.75u as=0.2603p ps=1.75u w=1.37u l=0.35u
X2710 IOVDD3 user_project_wrapper_0.sg13g2_IOPadIOVdd_3.sg13g2_Clamp_N43N43D4R_0.gate user_project_wrapper_0.IOVSS1 user_project_wrapper_0.IOVSS1 sg13_hv_nmos ad=2.596p pd=5.58u as=1.408p ps=5.04u w=4.4u l=0.6u
X2711 a_311846_195517# user_project_wrapper_0.sg13g2_IOPadAnalog_29.padres a_309917_199879# VDD3 sg13_lv_pmos ad=0.24415p pd=1.665u as=0.24415p ps=1.665u w=1.285u l=0.35u
X2712 IOVDD3 a_355624_237844# analog_io[23] IOVDD3 sg13_hv_pmos ad=2.1312p pd=7.3u as=3.9294p ps=7.84u w=6.66u l=0.6u
X2713 user_project_wrapper_0.IOVDD1 user_project_wrapper_0.sg13g2_IOPadIOVdd_1.sg13g2_Clamp_N43N43D4R_0.gate user_project_wrapper_0.IOVSS1 user_project_wrapper_0.IOVSS1 sg13_hv_nmos ad=2.596p pd=5.58u as=1.408p ps=5.04u w=4.4u l=0.6u
X2714 user_project_wrapper_0.sg13g2_IOPadIOVdd_3.sg13g2_Clamp_N43N43D4R_0.gate user_project_wrapper_0.sg13g2_IOPadIOVdd_3.sg13g2_RCClampResistor_0.p2 IOVDD3 IOVDD3 sg13_hv_pmos ad=1.33p pd=7.38u as=1.33p ps=7.38u w=7u l=0.5u
X2715 a_208939_328605# user_project_wrapper_0.IOVSS1 user_project_wrapper_0.IOVSS1 w_207887_327938# sg13_lv_pmos ad=0.38p pd=2.38u as=0.68p ps=4.68u w=2u l=0.13u
X2716 user_project_wrapper_0.IOVSS1 user_project_wrapper_0.sg13g2_IOPadVdd_1.sg13g2_RCClampInverter_noptap_0.out user_project_wrapper_0.VDD2 user_project_wrapper_0.IOVSS1 sg13_hv_nmos ad=1.408p pd=5.04u as=2.596p ps=5.58u w=4.4u l=0.6u
X2717 user_project_wrapper_0.analog_io[11] user_project_wrapper_0.IOVDD2 dpantenna l=1.26u w=27.78u
X2718 user_project_wrapper_0.IOVSS1 user_project_wrapper_0.sg13g2_IOPadVdd_2.sg13g2_RCClampInverter_noptap_0.out user_project_wrapper_0.VDD1 user_project_wrapper_0.IOVSS1 sg13_hv_nmos ad=1.408p pd=5.04u as=2.596p ps=5.58u w=4.4u l=0.6u
X2719 a_296731_189665# a_296625_189595# VDD3 VDD3 sg13_lv_pmos ad=0.2603p pd=1.75u as=0.2603p ps=1.75u w=1.37u l=0.35u
X2720 analog_io[23] a_311108_215937# VDD3 user_project_wrapper_0.IOVSS1 sg13_lv_nmos ad=3.4p pd=20.68u as=3.4p ps=20.68u w=10u l=0.15u
X2721 user_project_wrapper_0.IOVSS1 user_project_wrapper_0.sg13g2_IOPadIOVdd_2.sg13g2_Clamp_N43N43D4R_0.gate user_project_wrapper_0.IOVDD4 user_project_wrapper_0.IOVSS1 sg13_hv_nmos ad=1.408p pd=5.04u as=2.596p ps=5.58u w=4.4u l=0.6u
X2722 user_project_wrapper_0.IOVDD2 a_176644_41476# user_project_wrapper_0.analog_io[12] user_project_wrapper_0.IOVDD2 sg13_hv_pmos ad=2.1312p pd=7.3u as=3.9294p ps=7.84u w=6.66u l=0.6u
X2723 user_project_wrapper_0.VDD1 a_78824_137391# a_79025_137844# user_project_wrapper_0.VDD1 sg13_lv_pmos ad=1.7p pd=10.68u as=0.95p ps=5.38u w=5u l=0.15u
X2724 user_project_wrapper_0.IOVSS1 user_project_wrapper_0.IOVSS1 user_project_wrapper_0.IOVSS1 rppd l=0.5u w=0.5u
X2725 user_project_wrapper_0.analog_io[13] a_197044_41476# user_project_wrapper_0.IOVDD2 user_project_wrapper_0.IOVDD2 sg13_hv_pmos ad=3.9294p pd=7.84u as=2.1312p ps=7.3u w=6.66u l=0.6u
X2726 user_project_wrapper_0.sg13g2_IOPadIOVdd_2.sg13g2_Clamp_N43N43D4R_0.gate user_project_wrapper_0.sg13g2_IOPadIOVdd_2.sg13g2_RCClampResistor_0.p2 user_project_wrapper_0.IOVDD4 user_project_wrapper_0.IOVDD4 sg13_hv_pmos ad=1.33p pd=7.38u as=1.33p ps=7.38u w=7u l=0.5u
X2727 user_project_wrapper_0.IOVSS1 a_187018_328627# a_186202_326221# user_project_wrapper_0.IOVSS1 sg13_lv_pmos ad=3.264p pd=19.88u as=1.824p ps=9.98u w=9.6u l=0.13u
X2728 a_301423_196360# a_296625_189595# user_project_wrapper_0.IOVSS1 rppd l=0.55u w=1.5u
X2729 user_project_wrapper_0.analog_io[35] user_project_wrapper_0.IOVDD4 dpantenna l=1.26u w=27.78u
X2730 VDD3 a_309516_194555# a_309917_194695# VDD3 sg13_lv_pmos ad=0.19p pd=1.38u as=0.19p ps=1.38u w=1u l=0.7u
X2731 user_project_wrapper_0.analog_io[16] a_258244_41476# user_project_wrapper_0.IOVDD2 user_project_wrapper_0.IOVDD2 sg13_hv_pmos ad=3.9294p pd=7.84u as=2.1312p ps=7.3u w=6.66u l=0.6u
X2732 VDD3 a_311108_215937# analog_io[23] user_project_wrapper_0.IOVSS1 sg13_lv_nmos ad=3.4p pd=20.68u as=3.4p ps=20.68u w=10u l=0.15u
X2733 user_project_wrapper_0.IOVSS1 user_project_wrapper_0.sg13g2_IOPadIOVdd_3.sg13g2_Clamp_N43N43D4R_0.gate IOVDD3 user_project_wrapper_0.IOVSS1 sg13_hv_nmos ad=1.408p pd=5.04u as=2.596p ps=5.58u w=4.4u l=0.6u
X2734 user_project_wrapper_0.IOVSS1 analog_io[22] dantenna l=27.78u w=1.26u
X2735 user_project_wrapper_0.IOVSS1 user_project_wrapper_0.sg13g2_IOPadIOVdd_3.sg13g2_Clamp_N43N43D4R_0.gate IOVDD3 user_project_wrapper_0.IOVSS1 sg13_hv_nmos ad=1.408p pd=5.04u as=2.596p ps=5.58u w=4.4u l=0.6u
X2736 analog_io[18] a_355624_115444# IOVDD3 IOVDD3 sg13_hv_pmos ad=3.9294p pd=7.84u as=2.1312p ps=7.3u w=6.66u l=0.6u
X2737 a_311108_215937# a_311189_211724# VDD3 VDD3 sg13_lv_pmos ad=1.9p pd=10.38u as=1.9p ps=10.38u w=10u l=1u
X2738 QDLL_TOP_0.VDD a_190389_99046# user_project_wrapper_0.analog_io[14] QDLL_TOP_0.VDD sg13_lv_pmos ad=0.2128p pd=1.5u as=0.2128p ps=1.5u w=1.12u l=0.13u
X2739 a_191234_326377# a_190824_326377# user_project_wrapper_0.IOVSS1 user_project_wrapper_0.IOVSS1 sg13_lv_nmos ad=0.34p pd=2.68u as=0.34p ps=2.68u w=1u l=0.13u
X2740 a_210621_329719# TOP_ROILIFNEURON_0.MEM user_project_wrapper_0.IOVSS1 rppd l=0.5u w=0.5u
X2741 user_project_wrapper_0.analog_io[33] a_237844_369296# user_project_wrapper_0.IOVSS1 user_project_wrapper_0.IOVSS1 sg13_hv_nmos ad=2.596p pd=5.58u as=1.408p ps=5.04u w=4.4u l=0.6u
X2742 user_project_wrapper_0.IOVSS1 user_project_wrapper_0.sg13g2_IOPadVdd_1.sg13g2_RCClampInverter_noptap_0.out user_project_wrapper_0.VDD2 user_project_wrapper_0.IOVSS1 sg13_hv_nmos ad=1.408p pd=5.04u as=2.596p ps=5.58u w=4.4u l=0.6u
X2743 a_89953_127531# a_89114_127896# user_project_wrapper_0.IOVSS1 user_project_wrapper_0.IOVSS1 sg13_lv_nmos ad=0.2516p pd=2.16u as=0.2516p ps=2.16u w=0.74u l=0.13u
X2744 user_project_wrapper_0.IOVSS1 a_156244_369296# user_project_wrapper_0.analog_io[29] user_project_wrapper_0.IOVSS1 sg13_hv_nmos ad=1.408p pd=5.04u as=2.596p ps=5.58u w=4.4u l=0.6u
X2745 QDLL_TOP_0.VDD a_271172_100118# QDLL_TOP_0.VOUT QDLL_TOP_0.VDD sg13_lv_pmos ad=0.2128p pd=1.5u as=0.2128p ps=1.5u w=1.12u l=0.13u
X2746 user_project_wrapper_0.IOVSS1 user_project_wrapper_0.sg13g2_IOPadIOVdd_3.sg13g2_Clamp_N43N43D4R_0.gate IOVDD3 user_project_wrapper_0.IOVSS1 sg13_hv_nmos ad=1.408p pd=5.04u as=2.596p ps=5.58u w=4.4u l=0.6u
X2747 user_project_wrapper_0.IOVSS1 user_project_wrapper_0.sg13g2_IOPadVdd_3.sg13g2_RCClampResistor_0.p2 user_project_wrapper_0.IOVSS1 user_project_wrapper_0.IOVSS1 sg13_hv_nmos ad=1.71p pd=9.38u as=0 ps=0 w=9u l=9.5u
X2748 user_project_wrapper_0.IOVSS1 user_project_wrapper_0.sg13g2_IOPadIOVdd_3.sg13g2_Clamp_N43N43D4R_0.gate IOVDD3 user_project_wrapper_0.IOVSS1 sg13_hv_nmos ad=1.408p pd=5.04u as=2.596p ps=5.58u w=4.4u l=0.6u
X2749 a_296731_189665# a_301186_192011# user_project_wrapper_0.IOVSS1 user_project_wrapper_0.IOVSS1 sg13_lv_nmos ad=0.912p pd=5.18u as=0.912p ps=5.18u w=4.8u l=1.06u
X2750 user_project_wrapper_0.VDD2 user_project_wrapper_0.sg13g2_IOPadVdd_1.sg13g2_RCClampInverter_noptap_0.out user_project_wrapper_0.IOVSS1 user_project_wrapper_0.IOVSS1 sg13_hv_nmos ad=2.596p pd=5.58u as=1.408p ps=5.04u w=4.4u l=0.6u
X2751 user_project_wrapper_0.IOVDD4 user_project_wrapper_0.sg13g2_IOPadIOVdd_2.sg13g2_Clamp_N43N43D4R_0.gate user_project_wrapper_0.IOVSS1 user_project_wrapper_0.IOVSS1 sg13_hv_nmos ad=2.596p pd=5.58u as=1.408p ps=5.04u w=4.4u l=0.6u
X2752 analog_io[22] a_355624_197044# IOVDD3 IOVDD3 sg13_hv_pmos ad=3.9294p pd=7.84u as=2.1312p ps=7.3u w=6.66u l=0.6u
X2753 user_project_wrapper_0.IOVSS1 user_project_wrapper_0.sg13g2_IOPadVdd_1.sg13g2_RCClampInverter_noptap_0.out user_project_wrapper_0.VDD2 user_project_wrapper_0.IOVSS1 sg13_hv_nmos ad=1.408p pd=5.04u as=2.596p ps=5.58u w=4.4u l=0.6u
X2754 user_project_wrapper_0.IOVSS1 user_project_wrapper_0.sg13g2_IOPadIOVdd_1.sg13g2_Clamp_N43N43D4R_0.gate user_project_wrapper_0.IOVDD1 user_project_wrapper_0.IOVSS1 sg13_hv_nmos ad=1.408p pd=5.04u as=2.596p ps=5.58u w=4.4u l=0.6u
X2755 user_project_wrapper_0.IOVDD4 a_278644_355624# user_project_wrapper_0.analog_io[35] user_project_wrapper_0.IOVDD4 sg13_hv_pmos ad=3.1302p pd=14.26u as=3.9294p ps=7.84u w=6.66u l=0.6u
X2756 a_79025_125231# a_78824_124371# user_project_wrapper_0.VDD1 user_project_wrapper_0.VDD1 sg13_lv_pmos ad=1.7p pd=10.68u as=1.7p ps=10.68u w=5u l=0.15u
X2757 user_project_wrapper_0.IOVSS1 user_project_wrapper_0.IOVSS1 user_project_wrapper_0.IOVSS1 rhigh l=0.96u w=0.5u
X2758 a_210417_329719# a_210007_329719# user_project_wrapper_0.IOVSS1 w_207883_330166# sg13_lv_pmos ad=0.68p pd=4.68u as=0.68p ps=4.68u w=2u l=0.13u
X2759 a_296731_208493# a_296625_208423# VDD3 VDD3 sg13_lv_pmos ad=0.2603p pd=1.75u as=0.4658p ps=3.42u w=1.37u l=0.35u
X2760 user_project_wrapper_0.sg13g2_IOPadIOVdd_3.sg13g2_Clamp_N43N43D4R_0.gate user_project_wrapper_0.sg13g2_IOPadIOVdd_3.sg13g2_RCClampResistor_0.p2 IOVDD3 IOVDD3 sg13_hv_pmos ad=1.33p pd=7.38u as=1.33p ps=7.38u w=7u l=0.5u
X2761 user_project_wrapper_0.uo_PAD[3] user_project_wrapper_0.sg13g2_IOPadOut4mA$1_0.sg13g2_GateLevelUpInv_noptap$1$1_0.pgate user_project_wrapper_0.IOVDD1 user_project_wrapper_0.IOVDD1 sg13_hv_pmos ad=3.9294p pd=7.84u as=3.1302p ps=14.26u w=6.66u l=0.6u
X2762 user_project_wrapper_0.IOVSS1 a_301186_192011# a_296731_189665# user_project_wrapper_0.IOVSS1 sg13_lv_nmos ad=0.912p pd=5.18u as=1.632p ps=10.28u w=4.8u l=1.06u
X2763 user_project_wrapper_0.analog_io[30] a_176644_355624# user_project_wrapper_0.IOVDD4 user_project_wrapper_0.IOVDD4 sg13_hv_pmos ad=3.9294p pd=7.84u as=2.1312p ps=7.3u w=6.66u l=0.6u
X2764 a_83389_129203# a_83079_128838# user_project_wrapper_0.VDD1 user_project_wrapper_0.VDD1 sg13_lv_pmos ad=0.2128p pd=1.5u as=0.3808p ps=2.92u w=1.12u l=0.13u
X2765 a_360372_305365# a_364458_305035# user_project_wrapper_0.IOVSS1 rppd l=20u w=1u
X2766 a_309917_199879# a_309516_194555# VDD3 VDD3 sg13_lv_pmos ad=0.19p pd=1.38u as=0.19p ps=1.38u w=1u l=0.7u
X2767 VDD3 a_309516_194555# a_309917_199879# VDD3 sg13_lv_pmos ad=0.19p pd=1.38u as=0.19p ps=1.38u w=1u l=0.7u
X2768 a_304995_198817# a_304889_198885# a_304196_197873# user_project_wrapper_0.IOVSS1 sg13_lv_nmos ad=0.209p pd=1.48u as=0.209p ps=1.48u w=1.1u l=0.15u
X2769 user_project_wrapper_0.IOVSS1 a_182931_326125# user_project_wrapper_0.analog_io[27] user_project_wrapper_0.IOVSS1 sg13_lv_pmos ad=1.824p pd=9.98u as=1.824p ps=9.98u w=9.6u l=0.13u
X2770 user_project_wrapper_0.analog_io[30] a_194687_324142# user_project_wrapper_0.IOVSS1 user_project_wrapper_0.IOVSS1 sg13_lv_pmos ad=1.824p pd=9.98u as=1.824p ps=9.98u w=9.6u l=0.13u
X2771 user_project_wrapper_0.IOVSS1 user_project_wrapper_0.IOVSS1 user_project_wrapper_0.IOVSS1 rppd l=0.5u w=0.5u
X2772 user_project_wrapper_0.IOVSS1 user_project_wrapper_0.sg13g2_IOPadIOVdd_1.sg13g2_Clamp_N43N43D4R_0.gate user_project_wrapper_0.IOVDD1 user_project_wrapper_0.IOVSS1 sg13_hv_nmos ad=1.408p pd=5.04u as=2.596p ps=5.58u w=4.4u l=0.6u
X2773 user_project_wrapper_0.sg13g2_IOPadVdd_3.sg13g2_RCClampInverter_noptap_0.out user_project_wrapper_0.sg13g2_IOPadVdd_3.sg13g2_RCClampResistor_0.p2 user_project_wrapper_0.IOVSS1 user_project_wrapper_0.IOVSS1 sg13_hv_pmos ad=1.33p pd=7.38u as=1.33p ps=7.38u w=7u l=0.5u
X2774 IOVDD3 a_355624_115444# analog_io[18] IOVDD3 sg13_hv_pmos ad=2.1312p pd=7.3u as=3.9294p ps=7.84u w=6.66u l=0.6u
X2775 user_project_wrapper_0.IOVSS1 a_82846_241091# a_86046_241645# user_project_wrapper_0.IOVSS1 sg13_lv_nmos ad=0.2516p pd=2.16u as=0.1406p ps=1.12u w=0.74u l=0.13u
X2776 analog_io[26] a_369296_278644# user_project_wrapper_0.IOVSS1 user_project_wrapper_0.IOVSS1 sg13_hv_nmos ad=2.596p pd=5.58u as=1.408p ps=5.04u w=4.4u l=0.6u
X2777 user_project_wrapper_0.IOVSS1 user_project_wrapper_0.sg13g2_IOPadVdd_1.sg13g2_RCClampResistor_0.p2 user_project_wrapper_0.sg13g2_IOPadVdd_1.sg13g2_RCClampInverter_noptap_0.out user_project_wrapper_0.IOVSS1 sg13_hv_nmos ad=1.71p pd=9.38u as=1.71p ps=9.38u w=9u l=0.5u
X2778 a_307232_196607# a_307232_196607# user_project_wrapper_0.IOVSS1 user_project_wrapper_0.IOVSS1 sg13_lv_nmos ad=0.6327p pd=3.71u as=0.6327p ps=3.71u w=3.33u l=0.2u
X2779 VDD3 a_296625_189595# a_296731_189665# VDD3 sg13_lv_pmos ad=0.4658p pd=3.42u as=0.2603p ps=1.75u w=1.37u l=0.35u
X2780 VDD3 user_project_wrapper_0.sg13g2_IOPadVdd_0.sg13g2_RCClampInverter_noptap_0.out user_project_wrapper_0.IOVSS1 user_project_wrapper_0.IOVSS1 sg13_hv_nmos ad=2.596p pd=5.58u as=1.408p ps=5.04u w=4.4u l=0.6u
X2781 a_85977_125209# a_85211_124842# a_85875_125209# user_project_wrapper_0.IOVSS1 sg13_lv_nmos ad=0.1406p pd=1.12u as=0.1406p ps=1.12u w=0.74u l=0.13u
X2782 user_project_wrapper_0.analog_io[30] a_194687_324142# user_project_wrapper_0.IOVSS1 user_project_wrapper_0.IOVSS1 sg13_lv_pmos ad=1.824p pd=9.98u as=1.824p ps=9.98u w=9.6u l=0.13u
X2783 user_project_wrapper_0.IOVSS1 a_191800_324119# a_191462_324119# user_project_wrapper_0.IOVSS1 sg13_lv_nmos ad=0.34p pd=2.68u as=0.34p ps=2.68u w=1u l=0.65u
X2784 user_project_wrapper_0.analog_io[27] a_182931_326125# user_project_wrapper_0.IOVSS1 user_project_wrapper_0.IOVSS1 sg13_lv_nmos ad=0.912p pd=5.18u as=0.912p ps=5.18u w=4.8u l=0.13u
X2785 user_project_wrapper_0.sg13g2_IOPadIOVdd_2.sg13g2_Clamp_N43N43D4R_0.gate user_project_wrapper_0.sg13g2_IOPadIOVdd_2.sg13g2_RCClampResistor_0.p2 user_project_wrapper_0.IOVDD4 user_project_wrapper_0.IOVDD4 sg13_hv_pmos ad=1.33p pd=7.38u as=1.33p ps=7.38u w=7u l=0.5u
X2786 user_project_wrapper_0.IOVSS1 user_project_wrapper_0.sg13g2_IOPadIOVdd_2.sg13g2_Clamp_N43N43D4R_0.gate user_project_wrapper_0.IOVDD4 user_project_wrapper_0.IOVSS1 sg13_hv_nmos ad=1.408p pd=5.04u as=2.596p ps=5.58u w=4.4u l=0.6u
X2787 user_project_wrapper_0.analog_io[27] a_182931_326125# user_project_wrapper_0.IOVSS1 user_project_wrapper_0.IOVSS1 sg13_lv_nmos ad=0.912p pd=5.18u as=0.912p ps=5.18u w=4.8u l=0.13u
X2788 a_296731_208493# a_296625_208423# VDD3 VDD3 sg13_lv_pmos ad=0.2603p pd=1.75u as=0.2603p ps=1.75u w=1.37u l=0.35u
X2789 user_project_wrapper_0.IOVSS1 user_project_wrapper_0.sg13g2_IOPadAnalog_22.padres a_208469_329719# user_project_wrapper_0.IOVSS1 sg13_lv_nmos ad=0.34p pd=2.68u as=0.19p ps=1.38u w=1u l=0.13u
X2790 user_project_wrapper_0.IOVDD2 user_project_wrapper_0.sg13g2_IOPadIOVdd_0.sg13g2_Clamp_N43N43D4R_0.gate user_project_wrapper_0.IOVSS1 user_project_wrapper_0.IOVSS1 sg13_hv_nmos ad=2.596p pd=5.58u as=1.408p ps=5.04u w=4.4u l=0.6u
X2791 user_project_wrapper_0.IOVDD4 a_258244_355624# user_project_wrapper_0.analog_io[34] user_project_wrapper_0.IOVDD4 sg13_hv_pmos ad=2.1312p pd=7.3u as=3.9294p ps=7.84u w=6.66u l=0.6u
X2792 a_309917_199879# a_296731_208493# a_307232_196607# VDD3 sg13_lv_pmos ad=0.24415p pd=1.665u as=0.24415p ps=1.665u w=1.285u l=0.35u
X2793 IOVDD3 a_355624_217444# analog_io[23] IOVDD3 sg13_hv_pmos ad=2.1312p pd=7.3u as=3.9294p ps=7.84u w=6.66u l=0.6u
X2794 IOVDD3 user_project_wrapper_0.sg13g2_IOPadIOVdd_3.sg13g2_Clamp_N43N43D4R_0.gate user_project_wrapper_0.IOVSS1 user_project_wrapper_0.IOVSS1 sg13_hv_nmos ad=2.596p pd=5.58u as=1.408p ps=5.04u w=4.4u l=0.6u
X2795 user_project_wrapper_0.analog_io[35] a_278644_355624# user_project_wrapper_0.IOVDD4 user_project_wrapper_0.IOVDD4 sg13_hv_pmos ad=3.9294p pd=7.84u as=2.1312p ps=7.3u w=6.66u l=0.6u
X2796 user_project_wrapper_0.analog_io[16] a_258244_29676# user_project_wrapper_0.IOVSS1 user_project_wrapper_0.IOVSS1 sg13_hv_nmos ad=2.596p pd=5.58u as=1.408p ps=5.04u w=4.4u l=0.6u
X2797 user_project_wrapper_0.analog_io[1] a_29676_135844# user_project_wrapper_0.IOVSS1 user_project_wrapper_0.IOVSS1 sg13_hv_nmos ad=2.596p pd=5.58u as=1.408p ps=5.04u w=4.4u l=0.6u
X2798 user_project_wrapper_0.IOVSS1 user_project_wrapper_0.IOVSS1 user_project_wrapper_0.IOVSS1 rppd l=0.5u w=0.5u
X2799 user_project_wrapper_0.analog_io[27] a_115444_355624# user_project_wrapper_0.IOVDD4 user_project_wrapper_0.IOVDD4 sg13_hv_pmos ad=3.9294p pd=7.84u as=2.1312p ps=7.3u w=6.66u l=0.6u
X2800 user_project_wrapper_0.analog_io[13] a_197044_41476# user_project_wrapper_0.IOVDD2 user_project_wrapper_0.IOVDD2 sg13_hv_pmos ad=3.9294p pd=7.84u as=2.1312p ps=7.3u w=6.66u l=0.6u
X2801 analog_io[19] a_355624_135844# IOVDD3 IOVDD3 sg13_hv_pmos ad=3.9294p pd=7.84u as=3.1302p ps=14.26u w=6.66u l=0.6u
X2802 a_296731_189665# a_296625_189595# VDD3 VDD3 sg13_lv_pmos ad=0.2603p pd=1.75u as=0.2603p ps=1.75u w=1.37u l=0.35u
X2803 user_project_wrapper_0.IOVDD2 user_project_wrapper_0.sg13g2_IOPadIOVdd_0.sg13g2_RCClampResistor_0.p2 user_project_wrapper_0.sg13g2_IOPadIOVdd_0.sg13g2_Clamp_N43N43D4R_0.gate user_project_wrapper_0.IOVDD2 sg13_hv_pmos ad=2.38p pd=14.68u as=1.33p ps=7.38u w=7u l=0.5u
X2804 user_project_wrapper_0.analog_io[35] a_213870_324142# user_project_wrapper_0.IOVSS1 user_project_wrapper_0.IOVSS1 sg13_lv_pmos ad=1.824p pd=9.98u as=1.824p ps=9.98u w=9.6u l=0.13u
X2805 a_314697_196700# a_314793_201808# a_315347_192648# user_project_wrapper_0.IOVSS1 sg13_lv_nmos ad=1.14p pd=6.38u as=1.14p ps=6.38u w=6u l=6.4u
X2806 VDD3 a_309516_194555# a_309917_194695# VDD3 sg13_lv_pmos ad=0.19p pd=1.38u as=0.19p ps=1.38u w=1u l=0.7u
X2807 user_project_wrapper_0.IOVSS1 a_182931_326125# user_project_wrapper_0.analog_io[27] user_project_wrapper_0.IOVSS1 sg13_lv_pmos ad=1.824p pd=9.98u as=1.824p ps=9.98u w=9.6u l=0.13u
X2808 user_project_wrapper_0.IOVDD1 user_project_wrapper_0.sg13g2_IOPadIOVdd_1.sg13g2_Clamp_N43N43D4R_0.gate user_project_wrapper_0.IOVSS1 user_project_wrapper_0.IOVSS1 sg13_hv_nmos ad=2.596p pd=5.58u as=1.408p ps=5.04u w=4.4u l=0.6u
X2809 user_project_wrapper_0.IOVSS1 a_270178_100118# a_270512_100118# user_project_wrapper_0.IOVSS1 sg13_lv_nmos ad=0.2516p pd=2.16u as=0.1406p ps=1.12u w=0.74u l=0.13u
X2810 a_190584_102855# a_190218_102763# user_project_wrapper_0.IOVSS1 user_project_wrapper_0.IOVSS1 sg13_lv_nmos ad=88.8f pd=0.98u as=0.15245p ps=1.17u w=0.74u l=0.13u
X2811 a_86507_127725# a_85052_125418# user_project_wrapper_0.VDD1 user_project_wrapper_0.VDD1 sg13_lv_pmos ad=0.3808p pd=2.92u as=0.3808p ps=2.92u w=1.12u l=0.13u
X2812 VDD3 a_309516_194555# a_309917_199879# VDD3 sg13_lv_pmos ad=0.34p pd=2.68u as=0.19p ps=1.38u w=1u l=0.7u
X2813 VDD3 a_296625_189595# a_296731_189665# VDD3 sg13_lv_pmos ad=0.4658p pd=3.42u as=0.2603p ps=1.75u w=1.37u l=0.35u
X2814 a_304196_200821# a_304090_197941# a_296625_208423# user_project_wrapper_0.IOVSS1 sg13_lv_nmos ad=0.361p pd=2.28u as=0.361p ps=2.28u w=1.9u l=0.16u
X2815 VDD3 a_309516_194555# a_309917_199879# VDD3 sg13_lv_pmos ad=0.19p pd=1.38u as=0.19p ps=1.38u w=1u l=0.7u
X2816 a_296732_200582# a_296626_197740# VDD3 VDD3 sg13_lv_pmos ad=1.33p pd=7.38u as=1.33p ps=7.38u w=7u l=0.7u
X2817 user_project_wrapper_0.IOVSS1 a_191124_324119# a_190757_324686# user_project_wrapper_0.IOVSS1 sg13_lv_nmos ad=0.34p pd=2.68u as=0.34p ps=2.68u w=1u l=0.65u
X2818 user_project_wrapper_0.analog_io[35] a_213870_324142# user_project_wrapper_0.IOVSS1 user_project_wrapper_0.IOVSS1 sg13_lv_pmos ad=1.824p pd=9.98u as=1.824p ps=9.98u w=9.6u l=0.13u
X2819 a_309917_194695# user_project_wrapper_0.sg13g2_IOPadAnalog_29.padres a_311846_195517# VDD3 sg13_lv_pmos ad=0.24415p pd=1.665u as=0.4369p ps=3.25u w=1.285u l=0.35u
X2820 a_176644_41476# user_project_wrapper_0.IOVDD2 user_project_wrapper_0.IOVDD2 rppd l=12.9u w=0.5u
X2821 user_project_wrapper_0.analog_io[32] a_202114_326125# user_project_wrapper_0.IOVSS1 user_project_wrapper_0.IOVSS1 sg13_lv_nmos ad=0.912p pd=5.18u as=0.912p ps=5.18u w=4.8u l=0.13u
X2822 user_project_wrapper_0.IOVSS1 a_301186_192011# a_296731_189665# user_project_wrapper_0.IOVSS1 sg13_lv_nmos ad=1.632p pd=10.28u as=0.912p ps=5.18u w=4.8u l=1.06u
X2823 user_project_wrapper_0.analog_io[32] a_202114_326125# user_project_wrapper_0.IOVSS1 user_project_wrapper_0.IOVSS1 sg13_lv_nmos ad=0.912p pd=5.18u as=0.912p ps=5.18u w=4.8u l=0.13u
X2824 user_project_wrapper_0.IOVSS1 a_307232_196607# a_304995_198817# user_project_wrapper_0.IOVSS1 sg13_lv_nmos ad=0.6327p pd=3.71u as=0.6327p ps=3.71u w=3.33u l=0.2u
X2825 user_project_wrapper_0.IOVDD2 a_278644_41476# QDLL_TOP_0.VOUT user_project_wrapper_0.IOVDD2 sg13_hv_pmos ad=3.1302p pd=14.26u as=3.9294p ps=7.84u w=6.66u l=0.6u
X2826 a_182931_326125# a_186202_326221# user_project_wrapper_0.IOVSS1 user_project_wrapper_0.IOVSS1 sg13_lv_nmos ad=0.912p pd=5.18u as=0.912p ps=5.18u w=4.8u l=0.13u
X2827 user_project_wrapper_0.IOVSS1 a_369296_278644# analog_io[26] user_project_wrapper_0.IOVSS1 sg13_hv_nmos ad=1.408p pd=5.04u as=2.596p ps=5.58u w=4.4u l=0.6u
X2828 VDD3 user_project_wrapper_0.sg13g2_IOPadVdd_0.sg13g2_RCClampInverter_noptap_0.out user_project_wrapper_0.IOVSS1 user_project_wrapper_0.IOVSS1 sg13_hv_nmos ad=2.596p pd=5.58u as=1.408p ps=5.04u w=4.4u l=0.6u
X2829 VDD3 a_296625_189595# a_296731_189665# VDD3 sg13_lv_pmos ad=0.2603p pd=1.75u as=0.2603p ps=1.75u w=1.37u l=0.35u
X2830 user_project_wrapper_0.IOVSS1 a_213870_324142# user_project_wrapper_0.analog_io[35] user_project_wrapper_0.IOVSS1 sg13_lv_nmos ad=0.912p pd=5.18u as=0.912p ps=5.18u w=4.8u l=0.13u
X2831 user_project_wrapper_0.IOVDD2 a_237844_41476# user_project_wrapper_0.analog_io[15] user_project_wrapper_0.IOVDD2 sg13_hv_pmos ad=2.1312p pd=7.3u as=3.9294p ps=7.84u w=6.66u l=0.6u
X2832 analog_io[22] a_369296_197044# user_project_wrapper_0.IOVSS1 user_project_wrapper_0.IOVSS1 sg13_hv_nmos ad=2.596p pd=5.58u as=1.408p ps=5.04u w=4.4u l=0.6u
X2833 a_313884_211353# a_296731_208493# a_311189_211724# user_project_wrapper_0.IOVSS1 sg13_lv_nmos ad=1.9p pd=10.38u as=1.9p ps=10.38u w=10u l=0.5u
X2834 user_project_wrapper_0.analog_io[4] a_41476_197044# user_project_wrapper_0.IOVDD1 user_project_wrapper_0.IOVDD1 sg13_hv_pmos ad=3.9294p pd=7.84u as=2.1312p ps=7.3u w=6.66u l=0.6u
X2835 user_project_wrapper_0.analog_io[29] a_156244_369296# user_project_wrapper_0.IOVSS1 user_project_wrapper_0.IOVSS1 sg13_hv_nmos ad=2.596p pd=5.58u as=1.408p ps=5.04u w=4.4u l=0.6u
X2836 IOVDD3 a_355624_278644# analog_io[26] IOVDD3 sg13_hv_pmos ad=2.1312p pd=7.3u as=3.9294p ps=7.84u w=6.66u l=0.6u
X2837 user_project_wrapper_0.analog_io[6] a_29676_237844# user_project_wrapper_0.IOVSS1 user_project_wrapper_0.IOVSS1 sg13_hv_nmos ad=2.596p pd=5.58u as=1.408p ps=5.04u w=4.4u l=0.6u
X2838 a_209905_325263# a_208939_325263# user_project_wrapper_0.IOVSS1 user_project_wrapper_0.IOVSS1 sg13_lv_nmos ad=0.19p pd=1.38u as=0.34p ps=2.68u w=1u l=0.13u
X2839 user_project_wrapper_0.IOVSS1 user_project_wrapper_0.sg13g2_IOPadAnalog_19.padres a_189858_329327# user_project_wrapper_0.IOVSS1 sg13_lv_nmos ad=0.34p pd=2.68u as=0.19p ps=1.38u w=1u l=0.13u
X2840 VDD3 a_296625_189595# a_296731_189665# VDD3 sg13_lv_pmos ad=0.2603p pd=1.75u as=0.2603p ps=1.75u w=1.37u l=0.35u
X2841 a_304995_198817# a_304889_199957# a_304196_200821# user_project_wrapper_0.IOVSS1 sg13_lv_nmos ad=0.374p pd=2.88u as=0.209p ps=1.48u w=1.1u l=0.15u
X2842 user_project_wrapper_0.IOVSS1 user_project_wrapper_0.sg13g2_IOPadVdd_0.sg13g2_RCClampInverter_noptap_0.out VDD3 user_project_wrapper_0.IOVSS1 sg13_hv_nmos ad=1.408p pd=5.04u as=2.596p ps=5.58u w=4.4u l=0.6u
X2843 user_project_wrapper_0.analog_io[6] a_41476_237844# user_project_wrapper_0.IOVDD1 user_project_wrapper_0.IOVDD1 sg13_hv_pmos ad=3.9294p pd=7.84u as=2.1312p ps=7.3u w=6.66u l=0.6u
X2844 user_project_wrapper_0.IOVDD2 a_176644_41476# user_project_wrapper_0.analog_io[12] user_project_wrapper_0.IOVDD2 sg13_hv_pmos ad=2.1312p pd=7.3u as=3.9294p ps=7.84u w=6.66u l=0.6u
X2845 user_project_wrapper_0.IOVDD4 user_project_wrapper_0.sg13g2_IOPadIOVdd_2.sg13g2_RCClampResistor_0.p2 user_project_wrapper_0.sg13g2_IOPadIOVdd_2.sg13g2_Clamp_N43N43D4R_0.gate user_project_wrapper_0.IOVDD4 sg13_hv_pmos ad=1.33p pd=7.38u as=1.33p ps=7.38u w=7u l=0.5u
X2846 user_project_wrapper_0.IOVSS1 user_project_wrapper_0.analog_io[6] dantenna l=27.78u w=1.26u
X2847 user_project_wrapper_0.IOVSS1 user_project_wrapper_0.sg13g2_IOPadIOVdd_2.sg13g2_Clamp_N43N43D4R_0.gate user_project_wrapper_0.IOVDD4 user_project_wrapper_0.IOVSS1 sg13_hv_nmos ad=1.408p pd=5.04u as=2.596p ps=5.58u w=4.4u l=0.6u
X2848 a_86970_241383# a_85989_241383# user_project_wrapper_0.IOVSS1 user_project_wrapper_0.IOVSS1 sg13_lv_nmos ad=0.2516p pd=2.16u as=0.2516p ps=2.16u w=0.74u l=0.13u
X2849 user_project_wrapper_0.IOVSS1 a_210983_324119# a_210645_324119# user_project_wrapper_0.IOVSS1 sg13_lv_nmos ad=0.34p pd=2.68u as=0.34p ps=2.68u w=1u l=0.65u
X2850 user_project_wrapper_0.IOVSS1 user_project_wrapper_0.sg13g2_IOPadIOVdd_2.sg13g2_Clamp_N43N43D4R_0.gate user_project_wrapper_0.IOVDD4 user_project_wrapper_0.IOVSS1 sg13_hv_nmos ad=1.408p pd=5.04u as=2.596p ps=5.58u w=4.4u l=0.6u
X2851 user_project_wrapper_0.IOVSS1 a_237844_369296# user_project_wrapper_0.analog_io[33] user_project_wrapper_0.IOVSS1 sg13_hv_nmos ad=1.408p pd=5.04u as=2.596p ps=5.58u w=4.4u l=0.6u
X2852 user_project_wrapper_0.analog_io[32] a_217444_355624# user_project_wrapper_0.IOVDD4 user_project_wrapper_0.IOVDD4 sg13_hv_pmos ad=3.9294p pd=7.84u as=2.1312p ps=7.3u w=6.66u l=0.6u
X2853 analog_io[26] a_369296_278644# user_project_wrapper_0.IOVSS1 user_project_wrapper_0.IOVSS1 sg13_hv_nmos ad=2.596p pd=5.58u as=1.408p ps=5.04u w=4.4u l=0.6u
X2854 user_project_wrapper_0.IOVSS1 user_project_wrapper_0.sg13g2_IOPadVdd_3.sg13g2_RCClampInverter_noptap_0.out dantenna l=0.48u w=0.48u
X2855 user_project_wrapper_0.analog_io[32] a_202114_326125# user_project_wrapper_0.IOVSS1 user_project_wrapper_0.IOVSS1 sg13_lv_nmos ad=0.912p pd=5.18u as=0.912p ps=5.18u w=4.8u l=0.13u
X2856 VDD3 a_311108_179669# analog_io[20] user_project_wrapper_0.IOVSS1 sg13_lv_nmos ad=3.4p pd=20.68u as=3.4p ps=20.68u w=10u l=0.15u
X2857 VDD3 a_296625_208423# a_296731_208493# VDD3 sg13_lv_pmos ad=0.2603p pd=1.75u as=0.2603p ps=1.75u w=1.37u l=0.35u
X2858 user_project_wrapper_0.IOVSS1 a_187018_328627# a_186202_326221# user_project_wrapper_0.IOVSS1 sg13_lv_pmos ad=1.824p pd=9.98u as=1.824p ps=9.98u w=9.6u l=0.13u
X2859 user_project_wrapper_0.IOVSS1 user_project_wrapper_0.IOVSS1 user_project_wrapper_0.IOVSS1 rppd l=0.5u w=0.5u
X2860 user_project_wrapper_0.IOVSS1 a_213870_324142# user_project_wrapper_0.analog_io[35] user_project_wrapper_0.IOVSS1 sg13_lv_pmos ad=1.824p pd=9.98u as=1.824p ps=9.98u w=9.6u l=0.13u
X2861 a_311108_179669# analog_io[20] a_313884_185173# user_project_wrapper_0.IOVSS1 sg13_lv_nmos ad=1.9p pd=10.38u as=1.9p ps=10.38u w=10u l=0.5u
X2862 user_project_wrapper_0.analog_io[7] user_project_wrapper_0.sg13g2_IOPadAnalog_13.padres user_project_wrapper_0.IOVSS1 rppd l=2u w=1u
X2863 VDD3 a_296625_208423# a_296731_208493# VDD3 sg13_lv_pmos ad=0.2603p pd=1.75u as=0.2603p ps=1.75u w=1.37u l=0.35u
X2864 user_project_wrapper_0.analog_io[13] a_197044_29676# user_project_wrapper_0.IOVSS1 user_project_wrapper_0.IOVSS1 sg13_hv_nmos ad=2.596p pd=5.58u as=1.408p ps=5.04u w=4.4u l=0.6u
X2865 a_92512_127531# a_89953_127531# user_project_wrapper_0.IOVSS1 user_project_wrapper_0.IOVSS1 sg13_lv_nmos ad=0.1406p pd=1.12u as=0.2516p ps=2.16u w=0.74u l=0.13u
X2866 a_79025_138251# a_79038_137002# user_project_wrapper_0.IOVSS1 user_project_wrapper_0.IOVSS1 sg13_lv_nmos ad=0.1428p pd=1.52u as=0.1428p ps=1.52u w=0.42u l=0.56u
X2867 a_188802_330987# a_189688_330987# user_project_wrapper_0.IOVSS1 rhigh l=4u w=0.5u
X2868 user_project_wrapper_0.IOVSS1 user_project_wrapper_0.sg13g2_IOPadVdd_1.sg13g2_RCClampResistor_0.p2 user_project_wrapper_0.sg13g2_IOPadVdd_1.sg13g2_RCClampInverter_noptap_0.out user_project_wrapper_0.IOVSS1 sg13_hv_nmos ad=1.71p pd=9.38u as=1.71p ps=9.38u w=9u l=0.5u
X2869 user_project_wrapper_0.analog_io[34] a_258244_355624# user_project_wrapper_0.IOVDD4 user_project_wrapper_0.IOVDD4 sg13_hv_pmos ad=3.9294p pd=7.84u as=2.1312p ps=7.3u w=6.66u l=0.6u
X2870 user_project_wrapper_0.IOVSS1 user_project_wrapper_0.sg13g2_IOPadIOVdd_0.sg13g2_Clamp_N43N43D4R_0.gate user_project_wrapper_0.IOVDD2 user_project_wrapper_0.IOVSS1 sg13_hv_nmos ad=1.408p pd=5.04u as=2.596p ps=5.58u w=4.4u l=0.6u
X2871 analog_io[23] a_311108_215937# VDD3 user_project_wrapper_0.IOVSS1 sg13_lv_nmos ad=3.4p pd=20.68u as=3.4p ps=20.68u w=10u l=0.15u
X2872 user_project_wrapper_0.IOVSS1 a_29676_237844# user_project_wrapper_0.analog_io[6] user_project_wrapper_0.IOVSS1 sg13_hv_nmos ad=1.408p pd=5.04u as=2.596p ps=5.58u w=4.4u l=0.6u
X2873 user_project_wrapper_0.analog_io[16] a_258244_41476# user_project_wrapper_0.IOVDD2 user_project_wrapper_0.IOVDD2 sg13_hv_pmos ad=3.9294p pd=7.84u as=2.1312p ps=7.3u w=6.66u l=0.6u
X2874 VDD3 a_311189_211724# a_311189_211724# VDD3 sg13_lv_pmos ad=1.9p pd=10.38u as=1.9p ps=10.38u w=10u l=1u
X2875 user_project_wrapper_0.VDD1 user_project_wrapper_0.sg13g2_IOPadVdd_2.sg13g2_RCClampResistor_0.p2 user_project_wrapper_0.sg13g2_IOPadVdd_2.sg13g2_RCClampInverter_noptap_0.out user_project_wrapper_0.VDD1 sg13_hv_pmos ad=1.33p pd=7.38u as=1.33p ps=7.38u w=7u l=0.5u
X2876 a_189395_99046# a_189148_99070# user_project_wrapper_0.IOVSS1 user_project_wrapper_0.IOVSS1 sg13_lv_nmos ad=0.2516p pd=2.16u as=0.1405p ps=1.15u w=0.74u l=0.13u
X2877 user_project_wrapper_0.IOVDD4 user_project_wrapper_0.sg13g2_IOPadIOVdd_2.sg13g2_Clamp_N43N43D4R_0.gate user_project_wrapper_0.IOVSS1 user_project_wrapper_0.IOVSS1 sg13_hv_nmos ad=2.596p pd=5.58u as=2.068p ps=9.74u w=4.4u l=0.6u
X2878 a_35456_76015# a_39542_75685# user_project_wrapper_0.IOVSS1 rppd l=20u w=1u
X2879 QDLL_TOP_0.VDD a_185968_102197# a_185968_102197# QDLL_TOP_0.VDD sg13_lv_pmos ad=0.7616p pd=5.16u as=0.7616p ps=5.16u w=2.24u l=0.13u
X2880 a_82826_124842# user_project_wrapper_0.sg13g2_IOPadIn$1_0.p2c user_project_wrapper_0.IOVSS1 user_project_wrapper_0.IOVSS1 sg13_lv_nmos ad=0.2516p pd=2.16u as=0.2516p ps=2.16u w=0.74u l=0.13u
X2881 user_project_wrapper_0.IOVSS1 user_project_wrapper_0.sg13g2_IOPadIOVdd_3.sg13g2_Clamp_N43N43D4R_0.gate IOVDD3 user_project_wrapper_0.IOVSS1 sg13_hv_nmos ad=1.408p pd=5.04u as=2.596p ps=5.58u w=4.4u l=0.6u
X2882 VDD3 a_309516_194555# a_309917_194695# VDD3 sg13_lv_pmos ad=0.19p pd=1.38u as=0.19p ps=1.38u w=1u l=0.7u
X2883 user_project_wrapper_0.analog_io[14] a_217444_41476# user_project_wrapper_0.IOVDD2 user_project_wrapper_0.IOVDD2 sg13_hv_pmos ad=3.9294p pd=7.84u as=2.1312p ps=7.3u w=6.66u l=0.6u
X2884 user_project_wrapper_0.analog_io[1] a_41476_135844# user_project_wrapper_0.IOVDD1 user_project_wrapper_0.IOVDD1 sg13_hv_pmos ad=3.9294p pd=7.84u as=2.1312p ps=7.3u w=6.66u l=0.6u
X2885 a_309917_199879# a_309516_194555# VDD3 VDD3 sg13_lv_pmos ad=0.19p pd=1.38u as=0.19p ps=1.38u w=1u l=0.7u
X2886 user_project_wrapper_0.IOVDD2 user_project_wrapper_0.sg13g2_IOPadIOVdd_0.sg13g2_RCClampResistor_0.p2 user_project_wrapper_0.sg13g2_IOPadIOVdd_0.sg13g2_Clamp_N43N43D4R_0.gate user_project_wrapper_0.IOVDD2 sg13_hv_pmos ad=1.33p pd=7.38u as=1.33p ps=7.38u w=7u l=0.5u
X2887 user_project_wrapper_0.VDD1 user_project_wrapper_0.sg13g2_IOPadVdd_2.sg13g2_RCClampInverter_noptap_0.out user_project_wrapper_0.IOVSS1 user_project_wrapper_0.IOVSS1 sg13_hv_nmos ad=3.256p pd=10.28u as=1.408p ps=5.04u w=4.4u l=0.6u
X2888 a_309917_194695# a_309516_194555# VDD3 VDD3 sg13_lv_pmos ad=0.19p pd=1.38u as=0.19p ps=1.38u w=1u l=0.7u
X2889 VDD3 a_309516_194555# a_309917_194695# VDD3 sg13_lv_pmos ad=0.19p pd=1.38u as=0.19p ps=1.38u w=1u l=0.7u
X2890 a_210109_327099# a_209684_326377# a_210007_326377# user_project_wrapper_0.IOVSS1 sg13_lv_nmos ad=0.19p pd=1.38u as=0.19p ps=1.38u w=1u l=0.13u
X2891 user_project_wrapper_0.analog_io[34] user_project_wrapper_0.IOVDD4 dpantenna l=1.26u w=27.78u
X2892 a_78220_128106# a_78221_125094# user_project_wrapper_0.IOVSS1 rppd l=2u w=0.5u
X2893 user_project_wrapper_0.analog_io[28] a_135844_355624# user_project_wrapper_0.IOVDD4 user_project_wrapper_0.IOVDD4 sg13_hv_pmos ad=3.9294p pd=7.84u as=2.1312p ps=7.3u w=6.66u l=0.6u
X2894 analog_io[23] a_355624_237844# IOVDD3 IOVDD3 sg13_hv_pmos ad=3.9294p pd=7.84u as=2.1312p ps=7.3u w=6.66u l=0.6u
X2895 a_82645_240231# user_project_wrapper_0.sg13g2_IOPadAnalog_8.padres user_project_wrapper_0.IOVSS1 user_project_wrapper_0.IOVSS1 sg13_lv_nmos ad=0.17p pd=1.68u as=0.17p ps=1.68u w=0.5u l=0.15u
X2896 user_project_wrapper_0.VDD1 a_85052_125418# a_85977_125209# user_project_wrapper_0.VDD1 sg13_lv_pmos ad=0.3808p pd=2.92u as=0.2128p ps=1.5u w=1.12u l=0.13u
X2897 user_project_wrapper_0.analog_io[0] a_29676_115444# user_project_wrapper_0.IOVSS1 user_project_wrapper_0.IOVSS1 sg13_hv_nmos ad=2.596p pd=5.58u as=1.408p ps=5.04u w=4.4u l=0.6u
X2898 user_project_wrapper_0.IOVDD4 a_278644_355624# user_project_wrapper_0.analog_io[35] user_project_wrapper_0.IOVDD4 sg13_hv_pmos ad=2.1312p pd=7.3u as=3.9294p ps=7.84u w=6.66u l=0.6u
X2899 a_304196_200821# a_304889_199957# a_304995_198817# user_project_wrapper_0.IOVSS1 sg13_lv_nmos ad=0.209p pd=1.48u as=0.209p ps=1.48u w=1.1u l=0.15u
X2900 user_project_wrapper_0.IOVDD4 a_115444_355624# user_project_wrapper_0.analog_io[27] user_project_wrapper_0.IOVDD4 sg13_hv_pmos ad=2.1312p pd=7.3u as=3.9294p ps=7.84u w=6.66u l=0.6u
X2901 user_project_wrapper_0.IOVSS1 user_project_wrapper_0.sg13g2_IOPadVdd_2.sg13g2_RCClampInverter_noptap_0.out user_project_wrapper_0.VDD1 user_project_wrapper_0.IOVSS1 sg13_hv_nmos ad=1.408p pd=5.04u as=2.596p ps=5.58u w=4.4u l=0.6u
X2902 user_project_wrapper_0.IOVDD2 user_project_wrapper_0.sg13g2_IOPadIOVdd_0.sg13g2_Clamp_N43N43D4R_0.gate user_project_wrapper_0.IOVSS1 user_project_wrapper_0.IOVSS1 sg13_hv_nmos ad=2.596p pd=5.58u as=1.408p ps=5.04u w=4.4u l=0.6u
X2903 user_project_wrapper_0.IOVSS1 a_209638_324119# a_209230_324119# w_207989_323975# sg13_lv_pmos ad=0.68p pd=4.68u as=0.68p ps=4.68u w=2u l=0.13u
X2904 user_project_wrapper_0.IOVSS1 a_182931_326125# user_project_wrapper_0.analog_io[27] user_project_wrapper_0.IOVSS1 sg13_lv_pmos ad=1.824p pd=9.98u as=1.824p ps=9.98u w=9.6u l=0.13u
X2905 a_35456_301735# a_39542_301405# user_project_wrapper_0.IOVSS1 rppd l=20u w=1u
X2906 user_project_wrapper_0.IOVSS1 user_project_wrapper_0.IOVSS1 user_project_wrapper_0.IOVSS1 rppd l=0.5u w=0.5u
X2907 a_304995_198817# a_304889_198885# a_304196_197873# user_project_wrapper_0.IOVSS1 sg13_lv_nmos ad=0.374p pd=2.88u as=0.209p ps=1.48u w=1.1u l=0.15u
X2908 a_296625_208423# a_301940_196388# a_296732_200582# VDD3 sg13_lv_pmos ad=0.7695p pd=4.43u as=1.377p ps=8.78u w=4.05u l=0.5u
X2909 user_project_wrapper_0.IOVSS1 user_project_wrapper_0.sg13g2_IOPadVdd_3.sg13g2_RCClampInverter_noptap_0.out user_project_wrapper_0.IOVSS1 user_project_wrapper_0.IOVSS1 sg13_hv_nmos ad=1.408p pd=5.04u as=0 ps=0 w=4.4u l=0.6u
X2910 a_35456_78655# a_39542_78985# user_project_wrapper_0.IOVSS1 rppd l=20u w=1u
X2911 user_project_wrapper_0.sg13g2_IOPadVdd_3.sg13g2_RCClampInverter_noptap_0.out user_project_wrapper_0.sg13g2_IOPadVdd_3.sg13g2_RCClampResistor_0.p2 user_project_wrapper_0.IOVSS1 user_project_wrapper_0.IOVSS1 sg13_hv_pmos ad=1.33p pd=7.38u as=1.33p ps=7.38u w=7u l=0.5u
X2912 VDD3 a_309516_194555# a_309917_194695# VDD3 sg13_lv_pmos ad=0.19p pd=1.38u as=0.19p ps=1.38u w=1u l=0.7u
X2913 user_project_wrapper_0.analog_io[30] a_176644_355624# user_project_wrapper_0.IOVDD4 user_project_wrapper_0.IOVDD4 sg13_hv_pmos ad=3.9294p pd=7.84u as=2.1312p ps=7.3u w=6.66u l=0.6u
X2914 user_project_wrapper_0.IOVDD2 user_project_wrapper_0.sg13g2_IOPadIOVdd_0.sg13g2_Clamp_N43N43D4R_0.gate user_project_wrapper_0.IOVSS1 user_project_wrapper_0.IOVSS1 sg13_hv_nmos ad=2.596p pd=5.58u as=1.408p ps=5.04u w=4.4u l=0.6u
X2915 a_188184_101343# a_187914_101343# user_project_wrapper_0.IOVSS1 user_project_wrapper_0.IOVSS1 sg13_lv_nmos ad=0.1428p pd=1.52u as=79.8f ps=0.8u w=0.42u l=0.5u
X2916 user_project_wrapper_0.analog_io[27] a_182931_326125# user_project_wrapper_0.IOVSS1 user_project_wrapper_0.IOVSS1 sg13_lv_nmos ad=0.912p pd=5.18u as=0.912p ps=5.18u w=4.8u l=0.13u
X2917 a_208367_329719# a_208103_324155# user_project_wrapper_0.IOVSS1 user_project_wrapper_0.IOVSS1 sg13_lv_nmos ad=0.19p pd=1.38u as=0.34p ps=2.68u w=1u l=0.13u
X2918 analog_io[20] a_369296_156244# user_project_wrapper_0.IOVSS1 user_project_wrapper_0.IOVSS1 sg13_hv_nmos ad=2.596p pd=5.58u as=1.408p ps=5.04u w=4.4u l=0.6u
X2919 a_189729_101343# a_189395_101343# user_project_wrapper_0.IOVSS1 user_project_wrapper_0.IOVSS1 sg13_lv_nmos ad=0.1406p pd=1.12u as=0.1406p ps=1.12u w=0.74u l=0.13u
X2920 user_project_wrapper_0.analog_io[4] a_29676_197044# user_project_wrapper_0.IOVSS1 user_project_wrapper_0.IOVSS1 sg13_hv_nmos ad=2.596p pd=5.58u as=1.408p ps=5.04u w=4.4u l=0.6u
X2921 user_project_wrapper_0.IOVDD2 a_135844_41476# user_project_wrapper_0.analog_io[10] user_project_wrapper_0.IOVDD2 sg13_hv_pmos ad=2.1312p pd=7.3u as=3.9294p ps=7.84u w=6.66u l=0.6u
X2922 a_87105_130470# a_86594_130470# user_project_wrapper_0.IOVSS1 user_project_wrapper_0.IOVSS1 sg13_lv_nmos ad=0.1406p pd=1.12u as=0.2516p ps=2.16u w=0.74u l=0.13u
X2923 user_project_wrapper_0.analog_io[16] a_258244_41476# user_project_wrapper_0.IOVDD2 user_project_wrapper_0.IOVDD2 sg13_hv_pmos ad=3.9294p pd=7.84u as=2.1312p ps=7.3u w=6.66u l=0.6u
X2924 user_project_wrapper_0.IOVSS1 a_369296_115444# analog_io[18] user_project_wrapper_0.IOVSS1 sg13_hv_nmos ad=1.408p pd=5.04u as=2.596p ps=5.58u w=4.4u l=0.6u
X2925 user_project_wrapper_0.IOVSS1 a_182931_326125# user_project_wrapper_0.analog_io[27] user_project_wrapper_0.IOVSS1 sg13_lv_pmos ad=1.824p pd=9.98u as=1.824p ps=9.98u w=9.6u l=0.13u
X2926 a_309516_194555# a_309516_194555# VDD3 VDD3 sg13_lv_pmos ad=0.19p pd=1.38u as=0.19p ps=1.38u w=1u l=0.7u
X2927 user_project_wrapper_0.analog_io[14] a_217444_41476# user_project_wrapper_0.IOVDD2 user_project_wrapper_0.IOVDD2 sg13_hv_pmos ad=3.9294p pd=7.84u as=2.1312p ps=7.3u w=6.66u l=0.6u
X2928 user_project_wrapper_0.IOVSS1 user_project_wrapper_0.sg13g2_IOPadIOVdd_0.sg13g2_Clamp_N43N43D4R_0.gate user_project_wrapper_0.IOVDD2 user_project_wrapper_0.IOVSS1 sg13_hv_nmos ad=1.408p pd=5.04u as=2.596p ps=5.58u w=4.4u l=0.6u
X2929 analog_io[22] IOVDD3 dpantenna l=27.78u w=1.26u
X2930 a_87468_125419# a_88291_125210# user_project_wrapper_0.IOVSS1 user_project_wrapper_0.IOVSS1 sg13_lv_nmos ad=0.2516p pd=2.16u as=0.2516p ps=2.16u w=0.74u l=0.13u
X2931 user_project_wrapper_0.IOVSS1 a_156244_369296# user_project_wrapper_0.analog_io[29] user_project_wrapper_0.IOVSS1 sg13_hv_nmos ad=1.408p pd=5.04u as=2.596p ps=5.58u w=4.4u l=0.6u
X2932 a_296731_189665# a_296625_189595# VDD3 VDD3 sg13_lv_pmos ad=0.2603p pd=1.75u as=0.4658p ps=3.42u w=1.37u l=0.35u
X2933 a_296625_208423# a_301940_196388# a_296732_200582# VDD3 sg13_lv_pmos ad=0.7695p pd=4.43u as=0.7695p ps=4.43u w=4.05u l=0.5u
X2934 user_project_wrapper_0.VDD1 user_project_wrapper_0.sg13g2_IOPadVdd_2.sg13g2_RCClampResistor_0.p2 user_project_wrapper_0.sg13g2_IOPadVdd_2.sg13g2_RCClampInverter_noptap_0.out user_project_wrapper_0.VDD1 sg13_hv_pmos ad=1.33p pd=7.38u as=1.33p ps=7.38u w=7u l=0.5u
X2935 user_project_wrapper_0.VDD1 user_project_wrapper_0.sg13g2_IOPadVdd_2.sg13g2_RCClampInverter_noptap_0.out user_project_wrapper_0.IOVSS1 user_project_wrapper_0.IOVSS1 sg13_hv_nmos ad=2.596p pd=5.58u as=1.408p ps=5.04u w=4.4u l=0.6u
X2936 user_project_wrapper_0.analog_io[30] a_194687_324142# user_project_wrapper_0.IOVSS1 user_project_wrapper_0.IOVSS1 sg13_lv_pmos ad=1.824p pd=9.98u as=1.824p ps=9.98u w=9.6u l=0.13u
X2937 user_project_wrapper_0.IOVSS1 user_project_wrapper_0.sg13g2_IOPadIOVdd_2.sg13g2_RCClampResistor_0.p2 user_project_wrapper_0.IOVSS1 user_project_wrapper_0.IOVSS1 sg13_hv_nmos ad=1.71p pd=9.38u as=0 ps=0 w=9u l=9.5u
X2938 user_project_wrapper_0.analog_io[5] a_41476_217444# user_project_wrapper_0.IOVDD1 user_project_wrapper_0.IOVDD1 sg13_hv_pmos ad=3.9294p pd=7.84u as=2.1312p ps=7.3u w=6.66u l=0.6u
X2939 user_project_wrapper_0.sg13g2_IOPadVdd_1.sg13g2_RCClampInverter_noptap_0.out user_project_wrapper_0.sg13g2_IOPadVdd_1.sg13g2_RCClampResistor_0.p2 user_project_wrapper_0.VDD2 user_project_wrapper_0.VDD2 sg13_hv_pmos ad=1.33p pd=7.38u as=1.33p ps=7.38u w=7u l=0.5u
X2940 a_315347_192648# a_314793_201808# a_314697_196700# user_project_wrapper_0.IOVSS1 sg13_lv_nmos ad=1.14p pd=6.38u as=2.04p ps=12.68u w=6u l=6.4u
X2941 a_296731_208493# a_296625_208423# VDD3 VDD3 sg13_lv_pmos ad=0.2603p pd=1.75u as=0.2603p ps=1.75u w=1.37u l=0.35u
X2942 user_project_wrapper_0.IOVSS1 a_29676_115444# user_project_wrapper_0.analog_io[0] user_project_wrapper_0.IOVSS1 sg13_hv_nmos ad=1.408p pd=5.04u as=2.596p ps=5.58u w=4.4u l=0.6u
X2943 a_296625_189595# a_304090_197941# a_304196_197873# user_project_wrapper_0.IOVSS1 sg13_lv_nmos ad=0.361p pd=2.28u as=0.646p ps=4.48u w=1.9u l=0.16u
X2944 a_87434_129426# a_85127_131750# a_87434_129061# user_project_wrapper_0.IOVSS1 sg13_lv_nmos ad=0.2516p pd=2.16u as=0.1406p ps=1.12u w=0.74u l=0.13u
X2945 a_309917_199879# user_project_wrapper_0.sg13g2_IOPadAnalog_29.padres a_311846_195517# VDD3 sg13_lv_pmos ad=0.24415p pd=1.665u as=0.24415p ps=1.665u w=1.285u l=0.35u
X2946 user_project_wrapper_0.IOVDD2 user_project_wrapper_0.sg13g2_IOPadIOVdd_0.sg13g2_RCClampResistor_0.p2 user_project_wrapper_0.sg13g2_IOPadIOVdd_0.sg13g2_Clamp_N43N43D4R_0.gate user_project_wrapper_0.IOVDD2 sg13_hv_pmos ad=1.33p pd=7.38u as=1.33p ps=7.38u w=7u l=0.5u
X2947 user_project_wrapper_0.VDD2 user_project_wrapper_0.sg13g2_IOPadVdd_1.sg13g2_RCClampInverter_noptap_0.out user_project_wrapper_0.IOVSS1 user_project_wrapper_0.IOVSS1 sg13_hv_nmos ad=2.596p pd=5.58u as=1.408p ps=5.04u w=4.4u l=0.6u
X2948 a_309917_199879# a_296731_208493# a_307232_196607# VDD3 sg13_lv_pmos ad=0.24415p pd=1.665u as=0.24415p ps=1.665u w=1.285u l=0.35u
X2949 a_209041_330241# a_208939_325263# a_208939_329719# w_207883_330166# sg13_lv_pmos ad=0.38p pd=2.38u as=0.38p ps=2.38u w=2u l=0.13u
X2950 a_182931_326125# a_186202_326221# user_project_wrapper_0.IOVSS1 user_project_wrapper_0.IOVSS1 sg13_lv_nmos ad=0.912p pd=5.18u as=0.912p ps=5.18u w=4.8u l=0.13u
X2951 a_309917_199879# a_309516_194555# VDD3 VDD3 sg13_lv_pmos ad=0.19p pd=1.38u as=0.19p ps=1.38u w=1u l=0.7u
X2952 user_project_wrapper_0.IOVSS1 user_project_wrapper_0.sg13g2_IOPadIOVdd_3.sg13g2_Clamp_N43N43D4R_0.gate IOVDD3 user_project_wrapper_0.IOVSS1 sg13_hv_nmos ad=1.408p pd=5.04u as=2.596p ps=5.58u w=4.4u l=0.6u
X2953 user_project_wrapper_0.IOVSS1 a_213870_324142# user_project_wrapper_0.analog_io[35] user_project_wrapper_0.IOVSS1 sg13_lv_nmos ad=0.912p pd=5.18u as=0.912p ps=5.18u w=4.8u l=0.13u
X2954 user_project_wrapper_0.VDD2 user_project_wrapper_0.sg13g2_IOPadVdd_1.sg13g2_RCClampInverter_noptap_0.out user_project_wrapper_0.IOVSS1 user_project_wrapper_0.IOVSS1 sg13_hv_nmos ad=2.596p pd=5.58u as=1.408p ps=5.04u w=4.4u l=0.6u
X2955 analog_io[25] a_369296_258244# user_project_wrapper_0.IOVSS1 user_project_wrapper_0.IOVSS1 sg13_hv_nmos ad=2.596p pd=5.58u as=1.408p ps=5.04u w=4.4u l=0.6u
X2956 user_project_wrapper_0.analog_io[30] a_176644_355624# user_project_wrapper_0.IOVDD4 user_project_wrapper_0.IOVDD4 sg13_hv_pmos ad=3.9294p pd=7.84u as=2.1312p ps=7.3u w=6.66u l=0.6u
X2957 user_project_wrapper_0.analog_io[27] a_182931_326125# user_project_wrapper_0.IOVSS1 user_project_wrapper_0.IOVSS1 sg13_lv_nmos ad=0.912p pd=5.18u as=0.912p ps=5.18u w=4.8u l=0.13u
X2958 user_project_wrapper_0.analog_io[7] a_41476_258244# user_project_wrapper_0.IOVDD1 user_project_wrapper_0.IOVDD1 sg13_hv_pmos ad=3.9294p pd=7.84u as=3.1302p ps=14.26u w=6.66u l=0.6u
X2959 IOVDD3 a_355624_197044# analog_io[22] IOVDD3 sg13_hv_pmos ad=2.1312p pd=7.3u as=3.9294p ps=7.84u w=6.66u l=0.6u
X2960 analog_io[25] a_355624_258244# IOVDD3 IOVDD3 sg13_hv_pmos ad=3.9294p pd=7.84u as=2.1312p ps=7.3u w=6.66u l=0.6u
X2961 a_189756_328605# user_project_wrapper_0.IOVSS1 user_project_wrapper_0.IOVSS1 user_project_wrapper_0.IOVSS1 sg13_lv_nmos ad=0.19p pd=1.38u as=0.34p ps=2.68u w=1u l=0.13u
X2962 a_360372_80965# a_364458_80635# user_project_wrapper_0.IOVSS1 rppd l=20u w=1u
X2963 user_project_wrapper_0.IOVSS1 analog_io[23] dantenna l=27.78u w=1.26u
X2964 user_project_wrapper_0.IOVSS1 user_project_wrapper_0.sg13g2_IOPadVdd_0.sg13g2_RCClampInverter_noptap_0.out VDD3 user_project_wrapper_0.IOVSS1 sg13_hv_nmos ad=1.408p pd=5.04u as=2.596p ps=5.58u w=4.4u l=0.6u
X2965 user_project_wrapper_0.analog_io[35] a_213870_324142# user_project_wrapper_0.IOVSS1 user_project_wrapper_0.IOVSS1 sg13_lv_pmos ad=1.824p pd=9.98u as=1.824p ps=9.98u w=9.6u l=0.13u
X2966 user_project_wrapper_0.IOVSS1 user_project_wrapper_0.sg13g2_IOPadIOVdd_0.sg13g2_Clamp_N43N43D4R_0.gate user_project_wrapper_0.IOVDD2 user_project_wrapper_0.IOVSS1 sg13_hv_nmos ad=1.408p pd=5.04u as=2.596p ps=5.58u w=4.4u l=0.6u
X2967 a_79025_131741# a_79038_130492# user_project_wrapper_0.IOVSS1 user_project_wrapper_0.IOVSS1 sg13_lv_nmos ad=0.1428p pd=1.52u as=0.1428p ps=1.52u w=0.42u l=0.56u
X2968 a_296731_208493# a_296625_208423# VDD3 VDD3 sg13_lv_pmos ad=0.2603p pd=1.75u as=0.2603p ps=1.75u w=1.37u l=0.35u
X2969 VDD3 a_296625_189595# a_296731_189665# VDD3 sg13_lv_pmos ad=0.2603p pd=1.75u as=0.2603p ps=1.75u w=1.37u l=0.35u
X2970 a_307232_196607# a_296731_189665# a_309917_194695# VDD3 sg13_lv_pmos ad=0.24415p pd=1.665u as=0.24415p ps=1.665u w=1.285u l=0.35u
X2971 a_304995_198817# a_307232_196607# user_project_wrapper_0.IOVSS1 user_project_wrapper_0.IOVSS1 sg13_lv_nmos ad=0.6327p pd=3.71u as=0.6327p ps=3.71u w=3.33u l=0.2u
X2972 a_190722_330241# a_189756_329719# user_project_wrapper_0.IOVSS1 w_188700_330166# sg13_lv_pmos ad=0.38p pd=2.38u as=0.68p ps=4.68u w=2u l=0.13u
X2973 QDLL_TOP_0.VOUT user_project_wrapper_0.sg13g2_IOPadAnalog_6.padres a_186431_99272# user_project_wrapper_0.IOVSS1 sg13_lv_nmos ad=0.68p pd=4.68u as=0.68p ps=4.68u w=2u l=0.13u
X2974 user_project_wrapper_0.IOVDD4 a_258244_355624# user_project_wrapper_0.analog_io[34] user_project_wrapper_0.IOVDD4 sg13_hv_pmos ad=2.1312p pd=7.3u as=3.9294p ps=7.84u w=6.66u l=0.6u
X2975 a_296625_189595# a_301940_196388# a_296732_197880# VDD3 sg13_lv_pmos ad=0.7695p pd=4.43u as=1.377p ps=8.78u w=4.05u l=0.5u
X2976 user_project_wrapper_0.IOVSS1 a_176644_29676# user_project_wrapper_0.analog_io[12] user_project_wrapper_0.IOVSS1 sg13_hv_nmos ad=1.408p pd=5.04u as=2.596p ps=5.58u w=4.4u l=0.6u
X2977 VDD3 a_296625_189595# a_296731_189665# VDD3 sg13_lv_pmos ad=0.2603p pd=1.75u as=0.2603p ps=1.75u w=1.37u l=0.35u
X2978 user_project_wrapper_0.IOVSS1 user_project_wrapper_0.sg13g2_IOPadIOVdd_1.sg13g2_Clamp_N43N43D4R_0.gate user_project_wrapper_0.IOVDD1 user_project_wrapper_0.IOVSS1 sg13_hv_nmos ad=1.408p pd=5.04u as=2.596p ps=5.58u w=4.4u l=0.6u
X2979 user_project_wrapper_0.analog_io[32] a_202114_326125# user_project_wrapper_0.IOVSS1 user_project_wrapper_0.IOVSS1 sg13_lv_nmos ad=0.912p pd=5.18u as=0.912p ps=5.18u w=4.8u l=0.13u
X2980 a_189609_324119# a_189672_324776# user_project_wrapper_0.IOVSS1 user_project_wrapper_0.IOVSS1 sg13_lv_nmos ad=0.19p pd=1.38u as=0.19p ps=1.38u w=1u l=0.13u
X2981 user_project_wrapper_0.IOVSS1 user_project_wrapper_0.sg13g2_IOPadVdd_1.sg13g2_RCClampInverter_noptap_0.out user_project_wrapper_0.VDD2 user_project_wrapper_0.IOVSS1 sg13_hv_nmos ad=1.408p pd=5.04u as=2.596p ps=5.58u w=4.4u l=0.6u
X2982 user_project_wrapper_0.VDD1 user_project_wrapper_0.sg13g2_IOPadVdd_2.sg13g2_RCClampResistor_0.p2 user_project_wrapper_0.sg13g2_IOPadVdd_2.sg13g2_RCClampInverter_noptap_0.out user_project_wrapper_0.VDD1 sg13_hv_pmos ad=1.33p pd=7.38u as=1.33p ps=7.38u w=7u l=0.5u
X2983 user_project_wrapper_0.IOVSS1 user_project_wrapper_0.sg13g2_IOPadVdd_0.sg13g2_RCClampInverter_noptap_0.out VDD3 user_project_wrapper_0.IOVSS1 sg13_hv_nmos ad=1.408p pd=5.04u as=2.596p ps=5.58u w=4.4u l=0.6u
X2984 VDD3 a_311189_211724# a_311108_215937# VDD3 sg13_lv_pmos ad=3.4p pd=20.68u as=1.9p ps=10.38u w=10u l=1u
X2985 user_project_wrapper_0.IOVDD1 a_41476_217444# user_project_wrapper_0.analog_io[5] user_project_wrapper_0.IOVDD1 sg13_hv_pmos ad=2.1312p pd=7.3u as=3.9294p ps=7.84u w=6.66u l=0.6u
X2986 a_209684_325263# a_208367_325263# user_project_wrapper_0.IOVSS1 w_207887_326203# sg13_lv_pmos ad=0.68p pd=4.68u as=0.68p ps=4.68u w=2u l=0.13u
X2987 VDD3 user_project_wrapper_0.sg13g2_IOPadVdd_0.sg13g2_RCClampResistor_0.p2 user_project_wrapper_0.sg13g2_IOPadVdd_0.sg13g2_RCClampInverter_noptap_0.out VDD3 sg13_hv_pmos ad=1.33p pd=7.38u as=1.33p ps=7.38u w=7u l=0.5u
X2988 VDD3 a_296625_189595# a_296731_189665# VDD3 sg13_lv_pmos ad=0.2603p pd=1.75u as=0.2603p ps=1.75u w=1.37u l=0.35u
X2989 user_project_wrapper_0.IOVSS1 IOVDD3 dpantenna l=1.26u w=27.78u
X2990 a_299755_364458# a_300085_360372# user_project_wrapper_0.IOVSS1 rppd l=20u w=1u
X2991 user_project_wrapper_0.IOVSS1 user_project_wrapper_0.uo_PAD[8] dantenna l=27.78u w=1.26u
X2992 user_project_wrapper_0.VDD1 user_project_wrapper_0.sg13g2_IOPadVdd_2.sg13g2_RCClampInverter_noptap_0.out user_project_wrapper_0.IOVSS1 user_project_wrapper_0.IOVSS1 sg13_hv_nmos ad=2.596p pd=5.58u as=1.408p ps=5.04u w=4.4u l=0.6u
X2993 user_project_wrapper_0.analog_io[1] a_41476_135844# user_project_wrapper_0.IOVDD1 user_project_wrapper_0.IOVDD1 sg13_hv_pmos ad=3.9294p pd=7.84u as=2.1312p ps=7.3u w=6.66u l=0.6u
X2994 VDD3 a_309516_194555# a_309917_194695# VDD3 sg13_lv_pmos ad=0.19p pd=1.38u as=0.19p ps=1.38u w=1u l=0.7u
X2995 user_project_wrapper_0.IOVSS1 user_project_wrapper_0.sg13g2_IOPadVdd_3.sg13g2_RCClampInverter_noptap_0.out user_project_wrapper_0.IOVSS1 user_project_wrapper_0.IOVSS1 sg13_hv_nmos ad=2.596p pd=5.58u as=0 ps=0 w=4.4u l=0.6u
X2996 user_project_wrapper_0.VDD1 user_project_wrapper_0.sg13g2_IOPadVdd_2.sg13g2_RCClampResistor_0.p2 user_project_wrapper_0.sg13g2_IOPadVdd_2.sg13g2_RCClampInverter_noptap_0.out user_project_wrapper_0.VDD1 sg13_hv_pmos ad=1.33p pd=7.38u as=1.33p ps=7.38u w=7u l=0.5u
X2997 a_79038_125686# a_78221_125094# a_79025_126994# user_project_wrapper_0.VDD1 sg13_lv_pmos ad=0.95p pd=5.38u as=1.7p ps=10.68u w=5u l=0.3u
X2998 user_project_wrapper_0.IOVSS1 user_project_wrapper_0.sg13g2_IOPadVdd_3.sg13g2_RCClampInverter_noptap_0.out user_project_wrapper_0.IOVSS1 user_project_wrapper_0.IOVSS1 sg13_hv_nmos ad=2.596p pd=5.58u as=0 ps=0 w=4.4u l=0.6u
X2999 VDD3 a_296625_208423# a_296731_208493# VDD3 sg13_lv_pmos ad=0.2603p pd=1.75u as=0.2603p ps=1.75u w=1.37u l=0.35u
X3000 IOVDD3 user_project_wrapper_0.sg13g2_IOPadIOVdd_3.sg13g2_Clamp_N43N43D4R_0.gate user_project_wrapper_0.IOVSS1 user_project_wrapper_0.IOVSS1 sg13_hv_nmos ad=2.596p pd=5.58u as=1.408p ps=5.04u w=4.4u l=0.6u
X3001 user_project_wrapper_0.IOVSS1 a_369296_237844# analog_io[23] user_project_wrapper_0.IOVSS1 sg13_hv_nmos ad=1.408p pd=5.04u as=2.596p ps=5.58u w=4.4u l=0.6u
X3002 user_project_wrapper_0.IOVSS1 a_369296_258244# analog_io[25] user_project_wrapper_0.IOVSS1 sg13_hv_nmos ad=1.408p pd=5.04u as=2.596p ps=5.58u w=4.4u l=0.6u
X3003 IOVDD3 user_project_wrapper_0.sg13g2_IOPadIOVdd_3.sg13g2_Clamp_N43N43D4R_0.gate user_project_wrapper_0.IOVSS1 user_project_wrapper_0.IOVSS1 sg13_hv_nmos ad=2.596p pd=5.58u as=1.408p ps=5.04u w=4.4u l=0.6u
X3004 a_191438_329719# TOP_ROILIFNEURON_0.MEM user_project_wrapper_0.IOVSS1 rppd l=0.5u w=0.5u
X3005 user_project_wrapper_0.IOVSS1 a_307232_196607# a_304995_198817# user_project_wrapper_0.IOVSS1 sg13_lv_nmos ad=0.6327p pd=3.71u as=0.6327p ps=3.71u w=3.33u l=0.2u
X3006 user_project_wrapper_0.IOVDD1 a_41476_258244# user_project_wrapper_0.analog_io[7] user_project_wrapper_0.IOVDD1 sg13_hv_pmos ad=2.1312p pd=7.3u as=3.9294p ps=7.84u w=6.66u l=0.6u
X3007 user_project_wrapper_0.IOVDD1 user_project_wrapper_0.sg13g2_IOPadIOVdd_1.sg13g2_Clamp_N43N43D4R_0.gate user_project_wrapper_0.IOVSS1 user_project_wrapper_0.IOVSS1 sg13_hv_nmos ad=2.596p pd=5.58u as=1.408p ps=5.04u w=4.4u l=0.6u
X3008 user_project_wrapper_0.analog_io[30] a_176644_369296# user_project_wrapper_0.IOVSS1 user_project_wrapper_0.IOVSS1 sg13_hv_nmos ad=2.596p pd=5.58u as=1.408p ps=5.04u w=4.4u l=0.6u
X3009 analog_io[23] a_355624_217444# IOVDD3 IOVDD3 sg13_hv_pmos ad=3.9294p pd=7.84u as=2.1312p ps=7.3u w=6.66u l=0.6u
X3010 a_79025_131334# a_78824_130881# user_project_wrapper_0.VDD1 user_project_wrapper_0.VDD1 sg13_lv_pmos ad=0.95p pd=5.38u as=1.7p ps=10.68u w=5u l=0.15u
X3011 VDD3 a_311108_215937# analog_io[23] user_project_wrapper_0.IOVSS1 sg13_lv_nmos ad=3.4p pd=20.68u as=3.4p ps=20.68u w=10u l=0.15u
X3012 a_309917_194695# a_309516_194555# VDD3 VDD3 sg13_lv_pmos ad=0.19p pd=1.38u as=0.19p ps=1.38u w=1u l=0.7u
X3013 user_project_wrapper_0.VDD1 user_project_wrapper_0.sg13g2_IOPadOut4mA$1_1.c2p a_58798_281951# user_project_wrapper_0.VDD1 sg13_lv_pmos ad=1.615p pd=10.18u as=1.615p ps=10.18u w=4.75u l=0.13u
X3014 analog_io[20] a_355624_176644# IOVDD3 IOVDD3 sg13_hv_pmos ad=3.9294p pd=7.84u as=2.1312p ps=7.3u w=6.66u l=0.6u
X3015 user_project_wrapper_0.IOVSS1 a_301186_192011# a_296731_208493# user_project_wrapper_0.IOVSS1 sg13_lv_nmos ad=0.912p pd=5.18u as=0.912p ps=5.18u w=4.8u l=1.06u
X3016 user_project_wrapper_0.IOVDD4 a_217444_355624# user_project_wrapper_0.IOVDD4 rppd l=12.9u w=0.5u
X3017 a_192309_92557# QDLL_TOP_0.CPIN user_project_wrapper_0.IOVSS1 rppd l=10u w=1u
X3018 user_project_wrapper_0.IOVDD1 user_project_wrapper_0.sg13g2_IOPadIOVdd_1.sg13g2_Clamp_N43N43D4R_0.gate user_project_wrapper_0.IOVSS1 user_project_wrapper_0.IOVSS1 sg13_hv_nmos ad=2.596p pd=5.58u as=1.408p ps=5.04u w=4.4u l=0.6u
X3019 VDD3 user_project_wrapper_0.sg13g2_IOPadVdd_0.sg13g2_RCClampInverter_noptap_0.out user_project_wrapper_0.IOVSS1 user_project_wrapper_0.IOVSS1 sg13_hv_nmos ad=2.596p pd=5.58u as=1.408p ps=5.04u w=4.4u l=0.6u
X3020 VDD3 user_project_wrapper_0.sg13g2_IOPadVdd_0.sg13g2_RCClampInverter_noptap_0.out user_project_wrapper_0.IOVSS1 user_project_wrapper_0.IOVSS1 sg13_hv_nmos ad=3.256p pd=10.28u as=1.408p ps=5.04u w=4.4u l=0.6u
X3021 QDLL_TOP_0.VOUT a_278644_41476# user_project_wrapper_0.IOVDD2 user_project_wrapper_0.IOVDD2 sg13_hv_pmos ad=3.9294p pd=7.84u as=2.1312p ps=7.3u w=6.66u l=0.6u
X3022 a_296625_189595# a_304090_197941# a_304196_197873# user_project_wrapper_0.IOVSS1 sg13_lv_nmos ad=0.361p pd=2.28u as=0.646p ps=4.48u w=1.9u l=0.16u
X3023 user_project_wrapper_0.analog_io[5] a_41476_217444# user_project_wrapper_0.IOVDD1 user_project_wrapper_0.IOVDD1 sg13_hv_pmos ad=3.9294p pd=7.84u as=2.1312p ps=7.3u w=6.66u l=0.6u
X3024 user_project_wrapper_0.IOVSS1 a_213870_324142# user_project_wrapper_0.analog_io[35] user_project_wrapper_0.IOVSS1 sg13_lv_pmos ad=1.824p pd=9.98u as=1.824p ps=9.98u w=9.6u l=0.13u
X3025 user_project_wrapper_0.sg13g2_IOPadOut4mA$1_0.sg13g2_GateLevelUpInv_noptap$1$1_0.ngate a_57810_179517# user_project_wrapper_0.IOVDD1 user_project_wrapper_0.IOVDD1 sg13_hv_pmos ad=1.326p pd=8.48u as=1.326p ps=8.48u w=3.9u l=0.45u
X3026 a_311189_211724# a_311189_211724# VDD3 VDD3 sg13_lv_pmos ad=1.9p pd=10.38u as=3.4p ps=20.68u w=10u l=1u
X3027 analog_io[26] a_355624_278644# IOVDD3 IOVDD3 sg13_hv_pmos ad=3.9294p pd=7.84u as=2.1312p ps=7.3u w=6.66u l=0.6u
X3028 a_83398_130212# a_83070_130577# user_project_wrapper_0.VDD1 user_project_wrapper_0.VDD1 sg13_lv_pmos ad=0.2128p pd=1.5u as=0.3808p ps=2.92u w=1.12u l=0.13u
X3029 user_project_wrapper_0.IOVDD4 a_176644_355624# user_project_wrapper_0.analog_io[30] user_project_wrapper_0.IOVDD4 sg13_hv_pmos ad=2.1312p pd=7.3u as=3.9294p ps=7.84u w=6.66u l=0.6u
X3030 user_project_wrapper_0.IOVSS1 a_258244_369296# user_project_wrapper_0.analog_io[34] user_project_wrapper_0.IOVSS1 sg13_hv_nmos ad=1.408p pd=5.04u as=2.596p ps=5.58u w=4.4u l=0.6u
X3031 a_360372_302065# a_364458_301735# user_project_wrapper_0.IOVSS1 rppd l=20u w=1u
X3032 user_project_wrapper_0.IOVSS1 user_project_wrapper_0.sg13g2_IOPadAnalog_22.padres dantenna l=3.1u w=0.64u
X3033 VDD3 a_296626_197740# a_296732_200582# VDD3 sg13_lv_pmos ad=2.38p pd=14.68u as=1.33p ps=7.38u w=7u l=0.7u
X3034 user_project_wrapper_0.IOVDD2 a_237844_41476# user_project_wrapper_0.analog_io[15] user_project_wrapper_0.IOVDD2 sg13_hv_pmos ad=3.1302p pd=14.26u as=3.9294p ps=7.84u w=6.66u l=0.6u
X3035 user_project_wrapper_0.sg13g2_IOPadIOVdd_0.sg13g2_Clamp_N43N43D4R_0.gate user_project_wrapper_0.sg13g2_IOPadIOVdd_0.sg13g2_RCClampResistor_0.p2 user_project_wrapper_0.IOVSS1 user_project_wrapper_0.IOVSS1 sg13_hv_nmos ad=1.71p pd=9.38u as=1.71p ps=9.38u w=9u l=0.5u
X3036 user_project_wrapper_0.IOVSS1 a_213870_324142# user_project_wrapper_0.analog_io[35] user_project_wrapper_0.IOVSS1 sg13_lv_pmos ad=3.264p pd=19.88u as=1.824p ps=9.98u w=9.6u l=0.13u
X3037 user_project_wrapper_0.IOVSS1 user_project_wrapper_0.sg13g2_IOPadVdd_3.sg13g2_RCClampInverter_noptap_0.out user_project_wrapper_0.IOVSS1 user_project_wrapper_0.IOVSS1 sg13_hv_nmos ad=1.408p pd=5.04u as=0 ps=0 w=4.4u l=0.6u
X3038 a_189184_328605# user_project_wrapper_0.IOVSS1 user_project_wrapper_0.IOVSS1 user_project_wrapper_0.IOVSS1 sg13_lv_nmos ad=0.19p pd=1.38u as=0.34p ps=2.68u w=1u l=0.13u
X3039 user_project_wrapper_0.IOVSS1 user_project_wrapper_0.analog_io[28] dantenna l=1.26u w=27.78u
X3040 user_project_wrapper_0.IOVSS1 a_213376_328627# a_213462_327536# user_project_wrapper_0.IOVSS1 sg13_lv_nmos ad=0.912p pd=5.18u as=0.912p ps=5.18u w=4.8u l=0.13u
X3041 user_project_wrapper_0.IOVSS1 user_project_wrapper_0.sg13g2_IOPadVdd_2.sg13g2_RCClampInverter_noptap_0.out user_project_wrapper_0.VDD1 user_project_wrapper_0.IOVSS1 sg13_hv_nmos ad=1.408p pd=5.04u as=2.596p ps=5.58u w=4.4u l=0.6u
X3042 user_project_wrapper_0.IOVSS1 a_191234_329719# a_191438_329719# user_project_wrapper_0.IOVSS1 sg13_lv_nmos ad=0.19p pd=1.38u as=0.19p ps=1.38u w=1u l=0.13u
X3043 user_project_wrapper_0.IOVSS1 user_project_wrapper_0.sg13g2_IOPadVdd_0.sg13g2_RCClampResistor_0.p2 user_project_wrapper_0.IOVSS1 user_project_wrapper_0.IOVSS1 sg13_hv_nmos ad=1.71p pd=9.38u as=0 ps=0 w=9u l=9.5u
X3044 VDD3 a_296626_197740# a_296732_200582# VDD3 sg13_lv_pmos ad=1.33p pd=7.38u as=1.33p ps=7.38u w=7u l=0.7u
X3045 user_project_wrapper_0.IOVSS1 user_project_wrapper_0.sg13g2_IOPadIOVdd_2.sg13g2_RCClampResistor_0.p2 user_project_wrapper_0.IOVSS1 user_project_wrapper_0.IOVSS1 sg13_hv_nmos ad=1.71p pd=9.38u as=0 ps=0 w=9u l=9.5u
X3046 user_project_wrapper_0.IOVSS1 user_project_wrapper_0.sg13g2_IOPadVdd_0.sg13g2_RCClampInverter_noptap_0.out VDD3 user_project_wrapper_0.IOVSS1 sg13_hv_nmos ad=1.408p pd=5.04u as=2.596p ps=5.58u w=4.4u l=0.6u
X3047 user_project_wrapper_0.IOVSS1 user_project_wrapper_0.sg13g2_IOPadVdd_1.sg13g2_RCClampInverter_noptap_0.out user_project_wrapper_0.VDD2 user_project_wrapper_0.IOVSS1 sg13_hv_nmos ad=1.408p pd=5.04u as=2.596p ps=5.58u w=4.4u l=0.6u
X3048 user_project_wrapper_0.IOVSS1 a_209230_324119# a_206547_324106# w_207989_323975# sg13_lv_pmos ad=0.68p pd=4.68u as=0.38p ps=2.38u w=2u l=0.13u
X3049 user_project_wrapper_0.IOVSS1 user_project_wrapper_0.sg13g2_IOPadVdd_2.sg13g2_RCClampInverter_noptap_0.out user_project_wrapper_0.VDD1 user_project_wrapper_0.IOVSS1 sg13_hv_nmos ad=1.408p pd=5.04u as=2.596p ps=5.58u w=4.4u l=0.6u
X3050 user_project_wrapper_0.IOVDD1 a_41476_135844# user_project_wrapper_0.analog_io[1] user_project_wrapper_0.IOVDD1 sg13_hv_pmos ad=3.1302p pd=14.26u as=3.9294p ps=7.84u w=6.66u l=0.6u
X3051 a_309917_199879# a_309516_194555# VDD3 VDD3 sg13_lv_pmos ad=0.19p pd=1.38u as=0.19p ps=1.38u w=1u l=0.7u
X3052 user_project_wrapper_0.IOVSS1 user_project_wrapper_0.sg13g2_IOPadIOVdd_0.sg13g2_RCClampResistor_0.p2 user_project_wrapper_0.IOVSS1 user_project_wrapper_0.IOVSS1 sg13_hv_nmos ad=1.71p pd=9.38u as=0 ps=0 w=9u l=9.5u
X3053 user_project_wrapper_0.VDD1 user_project_wrapper_0.sg13g2_IOPadVdd_2.sg13g2_RCClampResistor_0.p2 user_project_wrapper_0.sg13g2_IOPadVdd_2.sg13g2_RCClampInverter_noptap_0.out user_project_wrapper_0.VDD1 sg13_hv_pmos ad=1.33p pd=7.38u as=1.33p ps=7.38u w=7u l=0.5u
X3054 a_35456_305035# a_39542_304705# user_project_wrapper_0.IOVSS1 rppd l=20u w=1u
X3055 user_project_wrapper_0.IOVSS1 a_301186_192011# a_296731_208493# user_project_wrapper_0.IOVSS1 sg13_lv_nmos ad=0.912p pd=5.18u as=0.912p ps=5.18u w=4.8u l=1.06u
X3056 VDD3 a_309516_194555# a_309516_194555# VDD3 sg13_lv_pmos ad=0.19p pd=1.38u as=0.19p ps=1.38u w=1u l=0.7u
X3057 a_309516_194555# a_309516_194555# VDD3 VDD3 sg13_lv_pmos ad=0.19p pd=1.38u as=0.19p ps=1.38u w=1u l=0.7u
X3058 VDD3 a_296625_189595# a_296731_189665# VDD3 sg13_lv_pmos ad=0.2603p pd=1.75u as=0.2603p ps=1.75u w=1.37u l=0.35u
X3059 a_208792_324119# a_208855_324776# user_project_wrapper_0.IOVSS1 user_project_wrapper_0.IOVSS1 sg13_lv_nmos ad=0.19p pd=1.38u as=0.19p ps=1.38u w=1u l=0.13u
X3060 VDD3 user_project_wrapper_0.sg13g2_IOPadVdd_0.sg13g2_RCClampResistor_0.p2 user_project_wrapper_0.sg13g2_IOPadVdd_0.sg13g2_RCClampInverter_noptap_0.out VDD3 sg13_hv_pmos ad=1.33p pd=7.38u as=1.33p ps=7.38u w=7u l=0.5u
X3061 a_87775_125210# a_87627_124843# a_87673_125210# user_project_wrapper_0.VDD1 sg13_lv_pmos ad=0.2128p pd=1.5u as=0.2128p ps=1.5u w=1.12u l=0.13u
X3062 user_project_wrapper_0.IOVSS1 a_269799_100118# a_269931_100182# user_project_wrapper_0.IOVSS1 sg13_lv_nmos ad=0.1405p pd=1.15u as=0.2163p ps=1.87u w=0.42u l=0.18u
X3063 user_project_wrapper_0.IOVSS1 a_369296_156244# analog_io[20] user_project_wrapper_0.IOVSS1 sg13_hv_nmos ad=1.408p pd=5.04u as=2.596p ps=5.58u w=4.4u l=0.6u
X3064 analog_io[23] a_369296_217444# user_project_wrapper_0.IOVSS1 user_project_wrapper_0.IOVSS1 sg13_hv_nmos ad=2.596p pd=5.58u as=1.408p ps=5.04u w=4.4u l=0.6u
X3065 user_project_wrapper_0.analog_io[12] user_project_wrapper_0.IOVDD2 dpantenna l=1.26u w=27.78u
X3066 user_project_wrapper_0.IOVSS1 user_project_wrapper_0.sg13g2_IOPadVdd_0.sg13g2_RCClampInverter_noptap_0.out VDD3 user_project_wrapper_0.IOVSS1 sg13_hv_nmos ad=1.408p pd=5.04u as=2.596p ps=5.58u w=4.4u l=0.6u
X3067 analog_io[19] a_355624_135844# IOVDD3 IOVDD3 sg13_hv_pmos ad=3.9294p pd=7.84u as=2.1312p ps=7.3u w=6.66u l=0.6u
X3068 user_project_wrapper_0.IOVDD2 a_197044_41476# user_project_wrapper_0.analog_io[13] user_project_wrapper_0.IOVDD2 sg13_hv_pmos ad=2.1312p pd=7.3u as=3.9294p ps=7.84u w=6.66u l=0.6u
X3069 user_project_wrapper_0.IOVSS1 user_project_wrapper_0.sg13g2_IOPadIOVdd_0.sg13g2_Clamp_N43N43D4R_0.gate user_project_wrapper_0.IOVDD2 user_project_wrapper_0.IOVSS1 sg13_hv_nmos ad=1.408p pd=5.04u as=2.596p ps=5.58u w=4.4u l=0.6u
X3070 a_189729_101343# a_189395_101343# user_project_wrapper_0.IOVSS1 user_project_wrapper_0.IOVSS1 sg13_lv_nmos ad=0.1406p pd=1.12u as=0.2516p ps=2.16u w=0.74u l=0.13u
X3071 a_296731_189665# a_296625_189595# VDD3 VDD3 sg13_lv_pmos ad=0.2603p pd=1.75u as=0.2603p ps=1.75u w=1.37u l=0.35u
X3072 user_project_wrapper_0.IOVSS1 user_project_wrapper_0.sg13g2_IOPadIOVdd_1.sg13g2_Clamp_N43N43D4R_0.gate user_project_wrapper_0.IOVDD1 user_project_wrapper_0.IOVSS1 sg13_hv_nmos ad=1.408p pd=5.04u as=2.596p ps=5.58u w=4.4u l=0.6u
X3073 a_268967_100118# a_268697_100118# user_project_wrapper_0.IOVSS1 user_project_wrapper_0.IOVSS1 sg13_lv_nmos ad=0.1428p pd=1.52u as=79.8f ps=0.8u w=0.42u l=0.5u
X3074 user_project_wrapper_0.IOVSS1 user_project_wrapper_0.IOVSS1 user_project_wrapper_0.IOVSS1 rhigh l=0.96u w=0.5u
X3075 a_309917_199879# a_309516_194555# VDD3 VDD3 sg13_lv_pmos ad=0.19p pd=1.38u as=0.19p ps=1.38u w=1u l=0.7u
X3076 user_project_wrapper_0.analog_io[6] a_29676_237844# user_project_wrapper_0.IOVSS1 user_project_wrapper_0.IOVSS1 sg13_hv_nmos ad=2.596p pd=5.58u as=1.408p ps=5.04u w=4.4u l=0.6u
X3077 user_project_wrapper_0.IOVSS1 a_182931_326125# user_project_wrapper_0.analog_io[27] user_project_wrapper_0.IOVSS1 sg13_lv_pmos ad=1.824p pd=9.98u as=1.824p ps=9.98u w=9.6u l=0.13u
X3078 user_project_wrapper_0.IOVSS1 a_258244_369296# user_project_wrapper_0.analog_io[34] user_project_wrapper_0.IOVSS1 sg13_hv_nmos ad=2.068p pd=9.74u as=2.596p ps=5.58u w=4.4u l=0.6u
X3079 QDLL_TOP_0.VOUT a_278644_41476# user_project_wrapper_0.IOVDD2 user_project_wrapper_0.IOVDD2 sg13_hv_pmos ad=3.9294p pd=7.84u as=2.1312p ps=7.3u w=6.66u l=0.6u
X3080 user_project_wrapper_0.VDD1 user_project_wrapper_0.sg13g2_IOPadVdd_2.sg13g2_RCClampInverter_noptap_0.out user_project_wrapper_0.IOVSS1 user_project_wrapper_0.IOVSS1 sg13_hv_nmos ad=2.596p pd=5.58u as=1.408p ps=5.04u w=4.4u l=0.6u
X3081 a_86594_130470# a_85127_131750# user_project_wrapper_0.IOVSS1 user_project_wrapper_0.IOVSS1 sg13_lv_nmos ad=0.2516p pd=2.16u as=0.2516p ps=2.16u w=0.74u l=0.13u
X3082 user_project_wrapper_0.IOVSS1 user_project_wrapper_0.sg13g2_IOPadIOVdd_1.sg13g2_Clamp_N43N43D4R_0.gate user_project_wrapper_0.IOVDD1 user_project_wrapper_0.IOVSS1 sg13_hv_nmos ad=1.408p pd=5.04u as=2.596p ps=5.58u w=4.4u l=0.6u
X3083 a_79315_364458# a_79645_360372# user_project_wrapper_0.IOVSS1 rppd l=20u w=1u
X3084 a_296731_189665# a_296625_189595# VDD3 VDD3 sg13_lv_pmos ad=0.2603p pd=1.75u as=0.2603p ps=1.75u w=1.37u l=0.35u
X3085 IOVDD3 a_355624_156244# analog_io[20] IOVDD3 sg13_hv_pmos ad=2.1312p pd=7.3u as=3.9294p ps=7.84u w=6.66u l=0.6u
X3086 VDD3 a_296625_189595# a_296731_189665# VDD3 sg13_lv_pmos ad=0.4658p pd=3.42u as=0.2603p ps=1.75u w=1.37u l=0.35u
X3087 analog_io[23] a_355624_217444# IOVDD3 IOVDD3 sg13_hv_pmos ad=3.9294p pd=7.84u as=2.1312p ps=7.3u w=6.66u l=0.6u
X3088 user_project_wrapper_0.IOVSS1 a_83050_125173# a_82974_125209# user_project_wrapper_0.IOVSS1 sg13_lv_nmos ad=0.2516p pd=2.16u as=0.1406p ps=1.12u w=0.74u l=0.13u
X3089 user_project_wrapper_0.sg13g2_IOPadIOVdd_2.sg13g2_Clamp_N43N43D4R_0.gate user_project_wrapper_0.sg13g2_IOPadIOVdd_2.sg13g2_RCClampResistor_0.p2 user_project_wrapper_0.IOVDD4 user_project_wrapper_0.IOVDD4 sg13_hv_pmos ad=1.33p pd=7.38u as=1.33p ps=7.38u w=7u l=0.5u
X3090 QDLL_TOP_0.CPIN a_190319_102855# a_190490_102497# QDLL_TOP_0.VDD sg13_lv_pmos ad=0.3808p pd=2.92u as=0.2128p ps=1.5u w=1.12u l=0.13u
X3091 user_project_wrapper_0.VDD1 a_82658_129203# a_83796_129203# user_project_wrapper_0.VDD1 sg13_lv_pmos ad=0.3808p pd=2.92u as=0.2128p ps=1.5u w=1.12u l=0.13u
X3092 user_project_wrapper_0.analog_io[14] a_217444_41476# user_project_wrapper_0.IOVDD2 user_project_wrapper_0.IOVDD2 sg13_hv_pmos ad=3.9294p pd=7.84u as=2.1312p ps=7.3u w=6.66u l=0.6u
X3093 VDD3 a_296626_197740# a_296732_197880# VDD3 sg13_lv_pmos ad=2.38p pd=14.68u as=1.33p ps=7.38u w=7u l=0.7u
X3094 IOVDD3 user_project_wrapper_0.sg13g2_IOPadIOVdd_3.sg13g2_Clamp_N43N43D4R_0.gate user_project_wrapper_0.IOVSS1 user_project_wrapper_0.IOVSS1 sg13_hv_nmos ad=2.596p pd=5.58u as=1.408p ps=5.04u w=4.4u l=0.6u
X3095 IOVDD3 user_project_wrapper_0.sg13g2_IOPadIOVdd_3.sg13g2_Clamp_N43N43D4R_0.gate user_project_wrapper_0.IOVSS1 user_project_wrapper_0.IOVSS1 sg13_hv_nmos ad=2.596p pd=5.58u as=1.408p ps=5.04u w=4.4u l=0.6u
X3096 user_project_wrapper_0.IOVSS1 a_213870_324142# user_project_wrapper_0.analog_io[35] user_project_wrapper_0.IOVSS1 sg13_lv_nmos ad=0.912p pd=5.18u as=0.912p ps=5.18u w=4.8u l=0.13u
X3097 user_project_wrapper_0.analog_io[27] a_182931_326125# user_project_wrapper_0.IOVSS1 user_project_wrapper_0.IOVSS1 sg13_lv_nmos ad=0.912p pd=5.18u as=0.912p ps=5.18u w=4.8u l=0.13u
X3098 IOVDD3 a_355624_258244# analog_io[25] IOVDD3 sg13_hv_pmos ad=2.1312p pd=7.3u as=3.9294p ps=7.84u w=6.66u l=0.6u
X3099 VDD3 user_project_wrapper_0.sg13g2_IOPadVdd_0.sg13g2_RCClampInverter_noptap_0.out user_project_wrapper_0.IOVSS1 user_project_wrapper_0.IOVSS1 sg13_hv_nmos ad=2.596p pd=5.58u as=1.408p ps=5.04u w=4.4u l=0.6u
X3100 user_project_wrapper_0.analog_io[7] user_project_wrapper_0.IOVDD1 dpantenna l=27.78u w=1.26u
X3101 VDD3 a_296626_197740# a_296732_197880# VDD3 sg13_lv_pmos ad=1.33p pd=7.38u as=1.33p ps=7.38u w=7u l=0.7u
X3102 VDD3 user_project_wrapper_0.sg13g2_IOPadVdd_0.sg13g2_RCClampResistor_0.p2 user_project_wrapper_0.sg13g2_IOPadVdd_0.sg13g2_RCClampInverter_noptap_0.out VDD3 sg13_hv_pmos ad=1.33p pd=7.38u as=1.33p ps=7.38u w=7u l=0.5u
X3103 user_project_wrapper_0.analog_io[34] a_258244_369296# user_project_wrapper_0.IOVSS1 user_project_wrapper_0.IOVSS1 sg13_hv_nmos ad=2.596p pd=5.58u as=1.408p ps=5.04u w=4.4u l=0.6u
X3104 user_project_wrapper_0.IOVSS1 a_210417_329719# a_210621_329719# user_project_wrapper_0.IOVSS1 sg13_lv_nmos ad=0.19p pd=1.38u as=0.19p ps=1.38u w=1u l=0.13u
X3105 user_project_wrapper_0.IOVSS1 user_project_wrapper_0.sg13g2_IOPadVdd_3.sg13g2_RCClampInverter_noptap_0.out user_project_wrapper_0.IOVSS1 user_project_wrapper_0.IOVSS1 sg13_hv_nmos ad=1.408p pd=5.04u as=0 ps=0 w=4.4u l=0.6u
X3106 a_79038_134832# user_project_wrapper_0.sg13g2_IOPadAnalog_9.padres a_79025_135674# user_project_wrapper_0.VDD1 sg13_lv_pmos ad=0.95p pd=5.38u as=1.7p ps=10.68u w=5u l=0.3u
X3107 user_project_wrapper_0.VDD1 user_project_wrapper_0.sg13g2_IOPadVdd_2.sg13g2_RCClampResistor_0.p2 user_project_wrapper_0.sg13g2_IOPadVdd_2.sg13g2_RCClampInverter_noptap_0.out user_project_wrapper_0.VDD1 sg13_hv_pmos ad=1.33p pd=7.38u as=1.33p ps=7.38u w=7u l=0.5u
X3108 a_296625_208423# a_301940_196388# a_296732_200582# VDD3 sg13_lv_pmos ad=0.7695p pd=4.43u as=0.7695p ps=4.43u w=4.05u l=0.5u
X3109 user_project_wrapper_0.IOVSS1 a_213462_327536# a_213870_324142# user_project_wrapper_0.IOVSS1 sg13_lv_pmos ad=1.824p pd=9.98u as=1.824p ps=9.98u w=9.6u l=0.13u
X3110 user_project_wrapper_0.analog_io[30] a_176644_355624# user_project_wrapper_0.IOVDD4 user_project_wrapper_0.IOVDD4 sg13_hv_pmos ad=3.9294p pd=7.84u as=2.1312p ps=7.3u w=6.66u l=0.6u
X3111 user_project_wrapper_0.IOVSS1 a_190297_328605# a_190926_328605# w_188704_327938# sg13_lv_pmos ad=0.68p pd=4.68u as=0.38p ps=2.38u w=2u l=0.13u
X3112 a_309917_194695# a_309516_194555# VDD3 VDD3 sg13_lv_pmos ad=0.19p pd=1.38u as=0.19p ps=1.38u w=1u l=0.7u
X3113 user_project_wrapper_0.IOVDD1 a_41476_237844# user_project_wrapper_0.analog_io[6] user_project_wrapper_0.IOVDD1 sg13_hv_pmos ad=2.1312p pd=7.3u as=3.9294p ps=7.84u w=6.66u l=0.6u
X3114 user_project_wrapper_0.IOVSS1 user_project_wrapper_0.sg13g2_IOPadIOVdd_1.sg13g2_Clamp_N43N43D4R_0.gate user_project_wrapper_0.IOVDD1 user_project_wrapper_0.IOVSS1 sg13_hv_nmos ad=1.408p pd=5.04u as=2.596p ps=5.58u w=4.4u l=0.6u
X3115 user_project_wrapper_0.IOVDD1 a_41476_258244# user_project_wrapper_0.analog_io[7] user_project_wrapper_0.IOVDD1 sg13_hv_pmos ad=2.1312p pd=7.3u as=3.9294p ps=7.84u w=6.66u l=0.6u
X3116 user_project_wrapper_0.IOVSS1 a_176644_369296# user_project_wrapper_0.analog_io[30] user_project_wrapper_0.IOVSS1 sg13_hv_nmos ad=1.408p pd=5.04u as=2.596p ps=5.58u w=4.4u l=0.6u
X3117 user_project_wrapper_0.analog_io[1] user_project_wrapper_0.IOVDD1 dpantenna l=27.78u w=1.26u
X3118 user_project_wrapper_0.IOVSS1 user_project_wrapper_0.IOVSS1 user_project_wrapper_0.IOVSS1 rppd l=0.5u w=0.5u
X3119 user_project_wrapper_0.IOVSS1 user_project_wrapper_0.sg13g2_IOPadVdd_3.sg13g2_RCClampInverter_noptap_0.out user_project_wrapper_0.IOVSS1 user_project_wrapper_0.IOVSS1 sg13_hv_nmos ad=1.408p pd=5.04u as=0 ps=0 w=4.4u l=0.6u
X3120 a_189858_327099# a_189756_327491# a_189756_326377# user_project_wrapper_0.IOVSS1 sg13_lv_nmos ad=0.19p pd=1.38u as=0.19p ps=1.38u w=1u l=0.13u
X3121 a_209480_325263# a_208939_325263# user_project_wrapper_0.IOVSS1 w_207887_326203# sg13_lv_pmos ad=0.68p pd=4.68u as=0.68p ps=4.68u w=2u l=0.13u
X3122 user_project_wrapper_0.sg13g2_IOPadIOVdd_0.sg13g2_Clamp_N43N43D4R_0.gate user_project_wrapper_0.sg13g2_IOPadIOVdd_0.sg13g2_RCClampResistor_0.p2 user_project_wrapper_0.IOVSS1 user_project_wrapper_0.IOVSS1 sg13_hv_nmos ad=1.71p pd=9.38u as=1.71p ps=9.38u w=9u l=0.5u
X3123 a_296731_208493# a_296625_208423# VDD3 VDD3 sg13_lv_pmos ad=0.2603p pd=1.75u as=0.2603p ps=1.75u w=1.37u l=0.35u
X3124 a_311108_215937# analog_io[23] a_313884_211353# user_project_wrapper_0.IOVSS1 sg13_lv_nmos ad=1.9p pd=10.38u as=1.9p ps=10.38u w=10u l=0.5u
X3125 user_project_wrapper_0.IOVSS1 user_project_wrapper_0.IOVSS1 user_project_wrapper_0.IOVSS1 rppd l=0.5u w=0.5u
X3126 a_210007_328605# a_209684_328605# a_209905_328605# w_207887_327938# sg13_lv_pmos ad=0.38p pd=2.38u as=0.38p ps=2.38u w=2u l=0.13u
X3127 user_project_wrapper_0.sg13g2_IOPadVdd_1.sg13g2_RCClampInverter_noptap_0.out user_project_wrapper_0.sg13g2_IOPadVdd_1.sg13g2_RCClampResistor_0.p2 user_project_wrapper_0.VDD2 user_project_wrapper_0.VDD2 sg13_hv_pmos ad=1.33p pd=7.38u as=1.33p ps=7.38u w=7u l=0.5u
X3128 user_project_wrapper_0.analog_io[30] user_project_wrapper_0.IOVDD4 dpantenna l=1.26u w=27.78u
X3129 user_project_wrapper_0.IOVSS1 user_project_wrapper_0.IOVSS1 user_project_wrapper_0.IOVSS1 rhigh l=0.96u w=0.5u
X3130 a_182931_326125# a_186202_326221# user_project_wrapper_0.IOVSS1 user_project_wrapper_0.IOVSS1 sg13_lv_nmos ad=0.912p pd=5.18u as=0.912p ps=5.18u w=4.8u l=0.13u
X3131 user_project_wrapper_0.IOVSS1 user_project_wrapper_0.sg13g2_IOPadVdd_0.sg13g2_RCClampInverter_noptap_0.out VDD3 user_project_wrapper_0.IOVSS1 sg13_hv_nmos ad=1.408p pd=5.04u as=2.596p ps=5.58u w=4.4u l=0.6u
X3132 user_project_wrapper_0.sg13g2_IOPadAnalog_7.padres user_project_wrapper_0.IOVDD2 dpantenna l=0.64u w=4.98u
X3133 a_191234_327491# a_190824_327491# user_project_wrapper_0.IOVSS1 user_project_wrapper_0.IOVSS1 sg13_lv_nmos ad=0.34p pd=2.68u as=0.34p ps=2.68u w=1u l=0.13u
X3134 a_311108_215937# a_311189_211724# VDD3 VDD3 sg13_lv_pmos ad=1.9p pd=10.38u as=1.9p ps=10.38u w=10u l=1u
X3135 VDD3 a_296625_189595# a_296731_189665# VDD3 sg13_lv_pmos ad=0.2603p pd=1.75u as=0.2603p ps=1.75u w=1.37u l=0.35u
X3136 user_project_wrapper_0.IOVSS1 user_project_wrapper_0.sg13g2_IOPadIOVdd_0.sg13g2_RCClampResistor_0.p2 user_project_wrapper_0.IOVSS1 user_project_wrapper_0.IOVSS1 sg13_hv_nmos ad=1.71p pd=9.38u as=0 ps=0 w=9u l=9.5u
X3137 user_project_wrapper_0.IOVSS1 user_project_wrapper_0.sg13g2_IOPadVdd_3.sg13g2_RCClampInverter_noptap_0.out user_project_wrapper_0.IOVSS1 user_project_wrapper_0.IOVSS1 sg13_hv_nmos ad=2.596p pd=5.58u as=0 ps=0 w=4.4u l=0.6u
X3138 VDD3 a_309516_194555# a_309917_194695# VDD3 sg13_lv_pmos ad=0.19p pd=1.38u as=0.19p ps=1.38u w=1u l=0.7u
X3139 user_project_wrapper_0.analog_io[14] a_217444_41476# user_project_wrapper_0.IOVDD2 user_project_wrapper_0.IOVDD2 sg13_hv_pmos ad=3.9294p pd=7.84u as=2.1312p ps=7.3u w=6.66u l=0.6u
X3140 user_project_wrapper_0.IOVSS1 user_project_wrapper_0.sg13g2_IOPadVdd_3.sg13g2_RCClampInverter_noptap_0.out user_project_wrapper_0.IOVSS1 user_project_wrapper_0.IOVSS1 sg13_hv_nmos ad=2.596p pd=5.58u as=0 ps=0 w=4.4u l=0.6u
X3141 user_project_wrapper_0.IOVSS1 user_project_wrapper_0.sg13g2_IOPadVdd_2.sg13g2_RCClampInverter_noptap_0.out user_project_wrapper_0.VDD1 user_project_wrapper_0.IOVSS1 sg13_hv_nmos ad=1.408p pd=5.04u as=2.596p ps=5.58u w=4.4u l=0.6u
X3142 analog_io[23] IOVDD3 dpantenna l=4.98u w=0.64u
X3143 user_project_wrapper_0.sg13g2_IOPadIOVdd_1.sg13g2_Clamp_N43N43D4R_0.gate user_project_wrapper_0.sg13g2_IOPadIOVdd_1.sg13g2_RCClampResistor_0.p2 user_project_wrapper_0.IOVDD1 user_project_wrapper_0.IOVDD1 sg13_hv_pmos ad=1.33p pd=7.38u as=1.33p ps=7.38u w=7u l=0.5u
X3144 analog_io[23] a_355624_237844# IOVDD3 IOVDD3 sg13_hv_pmos ad=3.9294p pd=7.84u as=2.1312p ps=7.3u w=6.66u l=0.6u
X3145 a_78824_126541# user_project_wrapper_0.sg13g2_IOPadAnalog_8.padres user_project_wrapper_0.IOVSS1 user_project_wrapper_0.IOVSS1 sg13_lv_nmos ad=0.17p pd=1.68u as=0.17p ps=1.68u w=0.5u l=0.15u
X3146 IOVDD3 a_355624_176644# analog_io[20] IOVDD3 sg13_hv_pmos ad=2.1312p pd=7.3u as=3.9294p ps=7.84u w=6.66u l=0.6u
X3147 IOVDD3 user_project_wrapper_0.sg13g2_IOPadIOVdd_3.sg13g2_Clamp_N43N43D4R_0.gate user_project_wrapper_0.IOVSS1 user_project_wrapper_0.IOVSS1 sg13_hv_nmos ad=2.596p pd=5.58u as=1.408p ps=5.04u w=4.4u l=0.6u
X3148 user_project_wrapper_0.IOVSS1 a_217444_369296# user_project_wrapper_0.analog_io[32] user_project_wrapper_0.IOVSS1 sg13_hv_nmos ad=1.408p pd=5.04u as=2.596p ps=5.58u w=4.4u l=0.6u
X3149 a_190304_110495# a_189748_108410# user_project_wrapper_0.IOVSS1 rppd l=10u w=1u
X3150 a_296731_189665# a_296625_189595# VDD3 VDD3 sg13_lv_pmos ad=0.2603p pd=1.75u as=0.2603p ps=1.75u w=1.37u l=0.35u
X3151 a_189286_330241# a_189184_325263# a_189184_329719# w_188700_330166# sg13_lv_pmos ad=0.38p pd=2.38u as=0.38p ps=2.38u w=2u l=0.13u
X3152 a_296732_200582# a_301940_196388# a_296625_208423# VDD3 sg13_lv_pmos ad=0.7695p pd=4.43u as=0.7695p ps=4.43u w=4.05u l=0.5u
X3153 user_project_wrapper_0.IOVSS1 a_29676_258244# user_project_wrapper_0.IOVSS1 rppd l=3.54u w=0.5u
X3154 a_296731_189665# a_301186_192011# user_project_wrapper_0.IOVSS1 user_project_wrapper_0.IOVSS1 sg13_lv_nmos ad=0.912p pd=5.18u as=0.912p ps=5.18u w=4.8u l=1.06u
X3155 a_313884_185173# a_296731_189665# a_311189_185546# user_project_wrapper_0.IOVSS1 sg13_lv_nmos ad=1.9p pd=10.38u as=1.9p ps=10.38u w=10u l=0.5u
X3156 VDD3 a_309516_194555# a_309917_194695# VDD3 sg13_lv_pmos ad=0.19p pd=1.38u as=0.19p ps=1.38u w=1u l=0.7u
X3157 user_project_wrapper_0.IOVSS1 user_project_wrapper_0.IOVSS1 user_project_wrapper_0.IOVSS1 rhigh l=0.96u w=0.5u
X3158 a_79038_123982# a_79038_123516# user_project_wrapper_0.IOVSS1 user_project_wrapper_0.IOVSS1 sg13_lv_nmos ad=0.1428p pd=1.52u as=0.1428p ps=1.52u w=0.42u l=0.56u
X3159 a_296731_208493# a_296625_208423# VDD3 VDD3 sg13_lv_pmos ad=0.2603p pd=1.75u as=0.2603p ps=1.75u w=1.37u l=0.35u
X3160 VDD3 user_project_wrapper_0.sg13g2_IOPadVdd_0.sg13g2_RCClampResistor_0.p2 user_project_wrapper_0.sg13g2_IOPadVdd_0.sg13g2_RCClampInverter_noptap_0.out VDD3 sg13_hv_pmos ad=1.33p pd=7.38u as=1.33p ps=7.38u w=7u l=0.5u
X3161 user_project_wrapper_0.IOVSS1 user_project_wrapper_0.sg13g2_IOPadVdd_2.sg13g2_RCClampInverter_noptap_0.out user_project_wrapper_0.VDD1 user_project_wrapper_0.IOVSS1 sg13_hv_nmos ad=1.408p pd=5.04u as=2.596p ps=5.58u w=4.4u l=0.6u
X3162 user_project_wrapper_0.analog_io[14] a_217444_41476# user_project_wrapper_0.IOVDD2 user_project_wrapper_0.IOVDD2 sg13_hv_pmos ad=3.9294p pd=7.84u as=2.1312p ps=7.3u w=6.66u l=0.6u
X3163 VDD3 a_296625_189595# a_296731_189665# VDD3 sg13_lv_pmos ad=0.2603p pd=1.75u as=0.2603p ps=1.75u w=1.37u l=0.35u
X3164 user_project_wrapper_0.analog_io[28] a_135844_355624# user_project_wrapper_0.IOVDD4 user_project_wrapper_0.IOVDD4 sg13_hv_pmos ad=3.9294p pd=7.84u as=2.1312p ps=7.3u w=6.66u l=0.6u
X3165 user_project_wrapper_0.IOVSS1 a_135844_369296# user_project_wrapper_0.IOVSS1 rppd l=3.54u w=0.5u
X3166 a_194687_324142# a_194279_327536# user_project_wrapper_0.IOVSS1 user_project_wrapper_0.IOVSS1 sg13_lv_pmos ad=1.824p pd=9.98u as=1.824p ps=9.98u w=9.6u l=0.13u
X3167 user_project_wrapper_0.IOVSS1 a_301186_192011# a_296731_208493# user_project_wrapper_0.IOVSS1 sg13_lv_nmos ad=0.912p pd=5.18u as=0.912p ps=5.18u w=4.8u l=1.06u
X3168 user_project_wrapper_0.IOVSS1 user_project_wrapper_0.sg13g2_IOPadIOVdd_1.sg13g2_Clamp_N43N43D4R_0.gate user_project_wrapper_0.IOVDD1 user_project_wrapper_0.IOVSS1 sg13_hv_nmos ad=1.408p pd=5.04u as=2.596p ps=5.58u w=4.4u l=0.6u
X3169 user_project_wrapper_0.IOVSS1 user_project_wrapper_0.sg13g2_IOPadVdd_3.sg13g2_RCClampInverter_noptap_0.out user_project_wrapper_0.IOVSS1 user_project_wrapper_0.IOVSS1 sg13_hv_nmos ad=1.408p pd=5.04u as=0 ps=0 w=4.4u l=0.6u
X3170 a_35456_75355# a_39542_75685# user_project_wrapper_0.IOVSS1 rppd l=20u w=1u
X3171 user_project_wrapper_0.IOVDD2 a_258244_41476# user_project_wrapper_0.analog_io[16] user_project_wrapper_0.IOVDD2 sg13_hv_pmos ad=2.1312p pd=7.3u as=3.9294p ps=7.84u w=6.66u l=0.6u
X3172 a_296731_208493# a_301186_192011# user_project_wrapper_0.IOVSS1 user_project_wrapper_0.IOVSS1 sg13_lv_nmos ad=0.912p pd=5.18u as=1.632p ps=10.28u w=4.8u l=1.06u
X3173 user_project_wrapper_0.IOVDD1 a_41476_197044# user_project_wrapper_0.analog_io[4] user_project_wrapper_0.IOVDD1 sg13_hv_pmos ad=2.1312p pd=7.3u as=3.9294p ps=7.84u w=6.66u l=0.6u
X3174 user_project_wrapper_0.IOVSS1 a_209230_324119# a_206547_324106# w_207989_323975# sg13_lv_pmos ad=0.38p pd=2.38u as=0.68p ps=4.68u w=2u l=0.13u
X3175 user_project_wrapper_0.analog_io[32] a_202114_326125# user_project_wrapper_0.IOVSS1 user_project_wrapper_0.IOVSS1 sg13_lv_pmos ad=1.824p pd=9.98u as=1.824p ps=9.98u w=9.6u l=0.13u
X3176 IOVDD3 a_355624_258244# analog_io[25] IOVDD3 sg13_hv_pmos ad=2.1312p pd=7.3u as=3.9294p ps=7.84u w=6.66u l=0.6u
X3177 user_project_wrapper_0.analog_io[5] a_29676_217444# user_project_wrapper_0.IOVSS1 user_project_wrapper_0.IOVSS1 sg13_hv_nmos ad=2.596p pd=5.58u as=1.408p ps=5.04u w=4.4u l=0.6u
X3178 user_project_wrapper_0.IOVSS1 a_194687_324142# user_project_wrapper_0.analog_io[30] user_project_wrapper_0.IOVSS1 sg13_lv_nmos ad=0.912p pd=5.18u as=0.912p ps=5.18u w=4.8u l=0.13u
X3179 user_project_wrapper_0.IOVSS1 a_209480_328605# a_210109_328605# w_207887_327938# sg13_lv_pmos ad=0.68p pd=4.68u as=0.38p ps=2.38u w=2u l=0.13u
X3180 a_190926_329327# a_190501_328605# a_190824_328605# user_project_wrapper_0.IOVSS1 sg13_lv_nmos ad=0.19p pd=1.38u as=0.19p ps=1.38u w=1u l=0.13u
X3181 analog_io[20] a_355624_176644# IOVDD3 IOVDD3 sg13_hv_pmos ad=3.9294p pd=7.84u as=3.1302p ps=14.26u w=6.66u l=0.6u
X3182 user_project_wrapper_0.IOVSS1 user_project_wrapper_0.sg13g2_IOPadIOVdd_3.sg13g2_Clamp_N43N43D4R_0.gate IOVDD3 user_project_wrapper_0.IOVSS1 sg13_hv_nmos ad=1.408p pd=5.04u as=2.596p ps=5.58u w=4.4u l=0.6u
X3183 VDD3 a_296625_208423# a_296731_208493# VDD3 sg13_lv_pmos ad=0.4658p pd=3.42u as=0.2603p ps=1.75u w=1.37u l=0.35u
X3184 a_311846_195517# user_project_wrapper_0.sg13g2_IOPadAnalog_29.padres a_309917_199879# VDD3 sg13_lv_pmos ad=0.4369p pd=3.25u as=0.24415p ps=1.665u w=1.285u l=0.35u
X3185 user_project_wrapper_0.IOVDD4 user_project_wrapper_0.sg13g2_IOPadIOVdd_2.sg13g2_Clamp_N43N43D4R_0.gate user_project_wrapper_0.IOVSS1 user_project_wrapper_0.IOVSS1 sg13_hv_nmos ad=2.596p pd=5.58u as=1.408p ps=5.04u w=4.4u l=0.6u
X3186 a_87571_125210# a_87468_125419# user_project_wrapper_0.VDD1 user_project_wrapper_0.VDD1 sg13_lv_pmos ad=0.2128p pd=1.5u as=0.3808p ps=2.92u w=1.12u l=0.13u
X3187 a_304995_198817# a_307232_196607# user_project_wrapper_0.IOVSS1 user_project_wrapper_0.IOVSS1 sg13_lv_nmos ad=0.6327p pd=3.71u as=0.6327p ps=3.71u w=3.33u l=0.2u
X3188 user_project_wrapper_0.analog_io[32] user_project_wrapper_0.IOVDD4 dpantenna l=1.26u w=27.78u
X3189 a_307232_196607# a_296731_208493# a_309917_199879# VDD3 sg13_lv_pmos ad=0.24415p pd=1.665u as=0.24415p ps=1.665u w=1.285u l=0.35u
X3190 user_project_wrapper_0.IOVSS1 user_project_wrapper_0.sg13g2_IOPadVdd_3.sg13g2_RCClampInverter_noptap_0.out user_project_wrapper_0.IOVSS1 user_project_wrapper_0.IOVSS1 sg13_hv_nmos ad=2.596p pd=5.58u as=0 ps=0 w=4.4u l=0.6u
X3191 user_project_wrapper_0.IOVSS1 a_213870_324142# user_project_wrapper_0.analog_io[35] user_project_wrapper_0.IOVSS1 sg13_lv_pmos ad=3.264p pd=19.88u as=1.824p ps=9.98u w=9.6u l=0.13u
X3192 user_project_wrapper_0.IOVSS1 user_project_wrapper_0.sg13g2_IOPadIOVdd_1.sg13g2_Clamp_N43N43D4R_0.gate user_project_wrapper_0.IOVDD1 user_project_wrapper_0.IOVSS1 sg13_hv_nmos ad=1.408p pd=5.04u as=2.596p ps=5.58u w=4.4u l=0.6u
X3193 user_project_wrapper_0.IOVSS1 user_project_wrapper_0.sg13g2_IOPadAnalog_27.padres dantenna l=0.64u w=3.1u
X3194 a_307232_196607# a_296731_189665# a_309917_194695# VDD3 sg13_lv_pmos ad=0.24415p pd=1.665u as=0.24415p ps=1.665u w=1.285u l=0.35u
X3195 analog_io[25] a_369296_258244# user_project_wrapper_0.IOVSS1 user_project_wrapper_0.IOVSS1 sg13_hv_nmos ad=2.596p pd=5.58u as=1.408p ps=5.04u w=4.4u l=0.6u
X3196 user_project_wrapper_0.IOVDD2 user_project_wrapper_0.sg13g2_IOPadIOVdd_0.sg13g2_RCClampResistor_0.p2 user_project_wrapper_0.sg13g2_IOPadIOVdd_0.sg13g2_Clamp_N43N43D4R_0.gate user_project_wrapper_0.IOVDD2 sg13_hv_pmos ad=1.33p pd=7.38u as=1.33p ps=7.38u w=7u l=0.5u
X3197 user_project_wrapper_0.VDD1 user_project_wrapper_0.sg13g2_IOPadVdd_2.sg13g2_RCClampInverter_noptap_0.out user_project_wrapper_0.IOVSS1 user_project_wrapper_0.IOVSS1 sg13_hv_nmos ad=2.596p pd=5.58u as=1.408p ps=5.04u w=4.4u l=0.6u
X3198 a_309917_194695# a_309516_194555# VDD3 VDD3 sg13_lv_pmos ad=0.19p pd=1.38u as=0.19p ps=1.38u w=1u l=0.7u
X3199 a_92512_129426# a_91911_129060# a_92512_129061# user_project_wrapper_0.IOVSS1 sg13_lv_nmos ad=0.2516p pd=2.16u as=0.1406p ps=1.12u w=0.74u l=0.13u
X3200 analog_io[25] a_355624_258244# IOVDD3 IOVDD3 sg13_hv_pmos ad=3.9294p pd=7.84u as=2.1312p ps=7.3u w=6.66u l=0.6u
X3201 user_project_wrapper_0.analog_io[27] a_182931_326125# user_project_wrapper_0.IOVSS1 user_project_wrapper_0.IOVSS1 sg13_lv_nmos ad=0.912p pd=5.18u as=0.912p ps=5.18u w=4.8u l=0.13u
X3202 user_project_wrapper_0.IOVSS1 a_213462_327536# a_213870_324142# user_project_wrapper_0.IOVSS1 sg13_lv_nmos ad=0.912p pd=5.18u as=0.912p ps=5.18u w=4.8u l=0.13u
X3203 user_project_wrapper_0.IOVDD1 a_41476_197044# user_project_wrapper_0.analog_io[4] user_project_wrapper_0.IOVDD1 sg13_hv_pmos ad=2.1312p pd=7.3u as=3.9294p ps=7.84u w=6.66u l=0.6u
X3204 user_project_wrapper_0.analog_io[27] a_182931_326125# user_project_wrapper_0.IOVSS1 user_project_wrapper_0.IOVSS1 sg13_lv_nmos ad=0.912p pd=5.18u as=1.632p ps=10.28u w=4.8u l=0.13u
X3205 IOVDD3 a_355624_217444# analog_io[23] IOVDD3 sg13_hv_pmos ad=2.1312p pd=7.3u as=3.9294p ps=7.84u w=6.66u l=0.6u
X3206 user_project_wrapper_0.analog_io[14] a_217444_41476# user_project_wrapper_0.IOVDD2 user_project_wrapper_0.IOVDD2 sg13_hv_pmos ad=3.9294p pd=7.84u as=2.1312p ps=7.3u w=6.66u l=0.6u
X3207 user_project_wrapper_0.analog_io[0] a_41476_115444# user_project_wrapper_0.IOVDD1 user_project_wrapper_0.IOVDD1 sg13_hv_pmos ad=3.9294p pd=7.84u as=3.1302p ps=14.26u w=6.66u l=0.6u
X3208 a_296625_189595# a_304090_197941# a_304196_197873# user_project_wrapper_0.IOVSS1 sg13_lv_nmos ad=0.361p pd=2.28u as=0.361p ps=2.28u w=1.9u l=0.16u
X3209 user_project_wrapper_0.sg13g2_IOPadVdd_3.sg13g2_RCClampInverter_noptap_0.out user_project_wrapper_0.sg13g2_IOPadVdd_3.sg13g2_RCClampResistor_0.p2 user_project_wrapper_0.IOVSS1 user_project_wrapper_0.IOVSS1 sg13_hv_pmos ad=1.33p pd=7.38u as=1.33p ps=7.38u w=7u l=0.5u
X3210 user_project_wrapper_0.IOVSS1 a_301186_192011# a_296731_189665# user_project_wrapper_0.IOVSS1 sg13_lv_nmos ad=0.912p pd=5.18u as=1.632p ps=10.28u w=4.8u l=1.06u
X3211 user_project_wrapper_0.IOVDD4 a_176644_355624# user_project_wrapper_0.analog_io[30] user_project_wrapper_0.IOVDD4 sg13_hv_pmos ad=2.1312p pd=7.3u as=3.9294p ps=7.84u w=6.66u l=0.6u
X3212 user_project_wrapper_0.IOVSS1 user_project_wrapper_0.sg13g2_IOPadVdd_0.sg13g2_RCClampResistor_0.p2 user_project_wrapper_0.IOVSS1 user_project_wrapper_0.IOVSS1 sg13_hv_nmos ad=3.06p pd=18.68u as=0 ps=0 w=9u l=9.5u
X3213 user_project_wrapper_0.VDD1 a_78824_130881# a_79025_131334# user_project_wrapper_0.VDD1 sg13_lv_pmos ad=1.7p pd=10.68u as=0.95p ps=5.38u w=5u l=0.15u
X3214 user_project_wrapper_0.IOVSS1 a_258244_369296# user_project_wrapper_0.analog_io[34] user_project_wrapper_0.IOVSS1 sg13_hv_nmos ad=1.408p pd=5.04u as=2.596p ps=5.58u w=4.4u l=0.6u
X3215 VDD3 user_project_wrapper_0.sg13g2_IOPadVdd_0.sg13g2_RCClampResistor_0.p2 user_project_wrapper_0.sg13g2_IOPadVdd_0.sg13g2_RCClampInverter_noptap_0.out VDD3 sg13_hv_pmos ad=1.33p pd=7.38u as=1.33p ps=7.38u w=7u l=0.5u
X3216 VDD3 user_project_wrapper_0.sg13g2_IOPadVdd_0.sg13g2_RCClampInverter_noptap_0.out user_project_wrapper_0.IOVSS1 user_project_wrapper_0.IOVSS1 sg13_hv_nmos ad=2.596p pd=5.58u as=1.408p ps=5.04u w=4.4u l=0.6u
X3217 QDLL_TOP_0.VOUT a_278644_41476# user_project_wrapper_0.IOVDD2 user_project_wrapper_0.IOVDD2 sg13_hv_pmos ad=3.9294p pd=7.84u as=2.1312p ps=7.3u w=6.66u l=0.6u
X3218 a_78824_135221# a_78824_135221# user_project_wrapper_0.VDD1 user_project_wrapper_0.VDD1 sg13_lv_pmos ad=0.95p pd=5.38u as=1.7p ps=10.68u w=5u l=0.15u
X3219 user_project_wrapper_0.sg13g2_IOPadIOVdd_2.sg13g2_Clamp_N43N43D4R_0.gate user_project_wrapper_0.sg13g2_IOPadIOVdd_2.sg13g2_RCClampResistor_0.p2 user_project_wrapper_0.IOVDD4 user_project_wrapper_0.IOVDD4 sg13_hv_pmos ad=1.33p pd=7.38u as=1.33p ps=7.38u w=7u l=0.5u
X3220 user_project_wrapper_0.IOVSS1 user_project_wrapper_0.sg13g2_IOPadIOVdd_0.sg13g2_Clamp_N43N43D4R_0.gate user_project_wrapper_0.IOVDD2 user_project_wrapper_0.IOVSS1 sg13_hv_nmos ad=1.408p pd=5.04u as=2.596p ps=5.58u w=4.4u l=0.6u
X3221 IOVDD3 a_355624_176644# analog_io[20] IOVDD3 sg13_hv_pmos ad=2.1312p pd=7.3u as=3.9294p ps=7.84u w=6.66u l=0.6u
X3222 user_project_wrapper_0.analog_io[1] a_29676_135844# user_project_wrapper_0.IOVSS1 user_project_wrapper_0.IOVSS1 sg13_hv_nmos ad=2.596p pd=5.58u as=1.408p ps=5.04u w=4.4u l=0.6u
X3223 user_project_wrapper_0.IOVDD4 a_217444_355624# user_project_wrapper_0.analog_io[32] user_project_wrapper_0.IOVDD4 sg13_hv_pmos ad=3.1302p pd=14.26u as=3.9294p ps=7.84u w=6.66u l=0.6u
X3224 user_project_wrapper_0.VDD1 a_78824_126541# a_79025_126994# user_project_wrapper_0.VDD1 sg13_lv_pmos ad=1.7p pd=10.68u as=0.95p ps=5.38u w=5u l=0.15u
X3225 user_project_wrapper_0.analog_io[15] a_237844_41476# user_project_wrapper_0.IOVDD2 user_project_wrapper_0.IOVDD2 sg13_hv_pmos ad=3.9294p pd=7.84u as=2.1312p ps=7.3u w=6.66u l=0.6u
X3226 a_296732_197880# a_301940_196388# a_296625_189595# VDD3 sg13_lv_pmos ad=0.7695p pd=4.43u as=0.7695p ps=4.43u w=4.05u l=0.5u
X3227 IOVDD3 a_355624_197044# analog_io[22] IOVDD3 sg13_hv_pmos ad=3.1302p pd=14.26u as=3.9294p ps=7.84u w=6.66u l=0.6u
X3228 VDD3 a_311189_185546# a_311108_179669# VDD3 sg13_lv_pmos ad=1.9p pd=10.38u as=1.9p ps=10.38u w=10u l=1u
X3229 IOVDD3 a_355624_278644# analog_io[26] IOVDD3 sg13_hv_pmos ad=2.1312p pd=7.3u as=3.9294p ps=7.84u w=6.66u l=0.6u
X3230 user_project_wrapper_0.IOVSS1 user_project_wrapper_0.sg13g2_IOPadVdd_0.sg13g2_RCClampInverter_noptap_0.out VDD3 user_project_wrapper_0.IOVSS1 sg13_hv_nmos ad=1.408p pd=5.04u as=2.596p ps=5.58u w=4.4u l=0.6u
X3231 a_77638_59490# user_project_wrapper_0.sg13g2_IOPadIn$1_1.sg13g2_LevelDown_noptap$1_0.sg13g2_SecondaryProtection$1$1_0.core user_project_wrapper_0.VDD1 user_project_wrapper_0.VDD1 sg13_hv_pmos ad=1.581p pd=9.98u as=1.581p ps=9.98u w=4.65u l=0.45u
X3232 user_project_wrapper_0.IOVSS1 user_project_wrapper_0.sg13g2_IOPadIOVdd_0.sg13g2_Clamp_N43N43D4R_0.gate user_project_wrapper_0.IOVDD2 user_project_wrapper_0.IOVSS1 sg13_hv_nmos ad=1.408p pd=5.04u as=2.596p ps=5.58u w=4.4u l=0.6u
X3233 user_project_wrapper_0.IOVDD2 a_197044_41476# user_project_wrapper_0.analog_io[13] user_project_wrapper_0.IOVDD2 sg13_hv_pmos ad=3.1302p pd=14.26u as=3.9294p ps=7.84u w=6.66u l=0.6u
X3234 user_project_wrapper_0.IOVSS1 a_191462_324119# a_191124_324119# user_project_wrapper_0.IOVSS1 sg13_lv_nmos ad=0.34p pd=2.68u as=0.34p ps=2.68u w=1u l=0.65u
X3235 a_296731_208493# a_296625_208423# VDD3 VDD3 sg13_lv_pmos ad=0.2603p pd=1.75u as=0.2603p ps=1.75u w=1.37u l=0.35u
X3236 user_project_wrapper_0.analog_io[5] a_29676_217444# user_project_wrapper_0.IOVSS1 user_project_wrapper_0.IOVSS1 sg13_hv_nmos ad=2.596p pd=5.58u as=1.408p ps=5.04u w=4.4u l=0.6u
X3237 user_project_wrapper_0.IOVSS1 user_project_wrapper_0.IOVSS1 user_project_wrapper_0.IOVSS1 rppd l=0.5u w=0.5u
X3238 a_309917_194695# a_296731_189665# a_307232_196607# VDD3 sg13_lv_pmos ad=0.24415p pd=1.665u as=0.4369p ps=3.25u w=1.285u l=0.35u
X3239 user_project_wrapper_0.IOVSS1 user_project_wrapper_0.sg13g2_IOPadIOVdd_3.sg13g2_Clamp_N43N43D4R_0.gate IOVDD3 user_project_wrapper_0.IOVSS1 sg13_hv_nmos ad=1.408p pd=5.04u as=2.596p ps=5.58u w=4.4u l=0.6u
X3240 user_project_wrapper_0.IOVSS1 user_project_wrapper_0.sg13g2_IOPadIOVdd_3.sg13g2_Clamp_N43N43D4R_0.gate IOVDD3 user_project_wrapper_0.IOVSS1 sg13_hv_nmos ad=1.408p pd=5.04u as=2.596p ps=5.58u w=4.4u l=0.6u
X3241 user_project_wrapper_0.IOVSS1 user_project_wrapper_0.sg13g2_IOPadVdd_0.sg13g2_RCClampInverter_noptap_0.out VDD3 user_project_wrapper_0.IOVSS1 sg13_hv_nmos ad=1.408p pd=5.04u as=2.596p ps=5.58u w=4.4u l=0.6u
X3242 user_project_wrapper_0.IOVSS1 user_project_wrapper_0.IOVSS1 user_project_wrapper_0.IOVSS1 rppd l=0.5u w=0.5u
X3243 user_project_wrapper_0.IOVSS1 a_301186_192011# a_296731_189665# user_project_wrapper_0.IOVSS1 sg13_lv_nmos ad=1.632p pd=10.28u as=0.912p ps=5.18u w=4.8u l=1.06u
X3244 a_315347_192648# a_314793_201808# a_314697_196700# user_project_wrapper_0.IOVSS1 sg13_lv_nmos ad=1.14p pd=6.38u as=1.14p ps=6.38u w=6u l=6.4u
X3245 VDD3 a_309516_194555# a_309917_199879# VDD3 sg13_lv_pmos ad=0.19p pd=1.38u as=0.19p ps=1.38u w=1u l=0.7u
X3246 a_296732_197880# a_296626_197740# VDD3 VDD3 sg13_lv_pmos ad=1.33p pd=7.38u as=1.33p ps=7.38u w=7u l=0.7u
X3247 a_182931_326125# a_186202_326221# user_project_wrapper_0.IOVSS1 user_project_wrapper_0.IOVSS1 sg13_lv_nmos ad=0.912p pd=5.18u as=0.912p ps=5.18u w=4.8u l=0.13u
X3248 user_project_wrapper_0.VDD1 user_project_wrapper_0.sg13g2_IOPadVdd_2.sg13g2_RCClampInverter_noptap_0.out user_project_wrapper_0.IOVSS1 user_project_wrapper_0.IOVSS1 sg13_hv_nmos ad=2.596p pd=5.58u as=1.408p ps=5.04u w=4.4u l=0.6u
X3249 user_project_wrapper_0.IOVDD2 a_156244_41476# user_project_wrapper_0.analog_io[11] user_project_wrapper_0.IOVDD2 sg13_hv_pmos ad=2.1312p pd=7.3u as=3.9294p ps=7.84u w=6.66u l=0.6u
X3250 user_project_wrapper_0.IOVSS1 a_213462_327536# a_213870_324142# user_project_wrapper_0.IOVSS1 sg13_lv_pmos ad=1.824p pd=9.98u as=1.824p ps=9.98u w=9.6u l=0.13u
X3251 user_project_wrapper_0.IOVDD4 a_135844_355624# user_project_wrapper_0.analog_io[28] user_project_wrapper_0.IOVDD4 sg13_hv_pmos ad=2.1312p pd=7.3u as=3.9294p ps=7.84u w=6.66u l=0.6u
X3252 a_296731_189665# a_301186_192011# user_project_wrapper_0.IOVSS1 user_project_wrapper_0.IOVSS1 sg13_lv_nmos ad=0.912p pd=5.18u as=0.912p ps=5.18u w=4.8u l=1.06u
X3253 a_309917_194695# a_309516_194555# VDD3 VDD3 sg13_lv_pmos ad=0.19p pd=1.38u as=0.19p ps=1.38u w=1u l=0.7u
X3254 a_191438_328605# TOP_ROILIFNEURON_0.MEM user_project_wrapper_0.IOVSS1 rppd l=0.5u w=0.5u
X3255 user_project_wrapper_0.IOVDD2 user_project_wrapper_0.sg13g2_IOPadIOVdd_0.sg13g2_Clamp_N43N43D4R_0.gate user_project_wrapper_0.IOVSS1 user_project_wrapper_0.IOVSS1 sg13_hv_nmos ad=2.596p pd=5.58u as=1.408p ps=5.04u w=4.4u l=0.6u
X3256 user_project_wrapper_0.IOVSS1 user_project_wrapper_0.sg13g2_IOPadVdd_3.sg13g2_RCClampInverter_noptap_0.out user_project_wrapper_0.IOVSS1 user_project_wrapper_0.IOVSS1 sg13_hv_nmos ad=2.596p pd=5.58u as=0 ps=0 w=4.4u l=0.6u
X3257 a_190501_329719# a_189184_329719# user_project_wrapper_0.IOVSS1 user_project_wrapper_0.IOVSS1 sg13_lv_nmos ad=0.34p pd=2.68u as=0.34p ps=2.68u w=1u l=0.13u
X3258 user_project_wrapper_0.analog_io[35] a_278644_369296# user_project_wrapper_0.IOVSS1 user_project_wrapper_0.IOVSS1 sg13_hv_nmos ad=2.596p pd=5.58u as=1.408p ps=5.04u w=4.4u l=0.6u
X3259 user_project_wrapper_0.IOVSS1 a_301186_192011# a_296731_189665# user_project_wrapper_0.IOVSS1 sg13_lv_nmos ad=0.912p pd=5.18u as=0.912p ps=5.18u w=4.8u l=1.06u
X3260 a_296626_197740# a_296626_197740# VDD3 VDD3 sg13_lv_pmos ad=0.266p pd=1.78u as=0.266p ps=1.78u w=1.4u l=0.35u
X3261 user_project_wrapper_0.IOVSS1 a_213870_324142# user_project_wrapper_0.analog_io[35] user_project_wrapper_0.IOVSS1 sg13_lv_pmos ad=1.824p pd=9.98u as=1.824p ps=9.98u w=9.6u l=0.13u
X3262 user_project_wrapper_0.IOVSS1 user_project_wrapper_0.sg13g2_IOPadVdd_3.sg13g2_RCClampInverter_noptap_0.out user_project_wrapper_0.IOVSS1 user_project_wrapper_0.IOVSS1 sg13_hv_nmos ad=2.596p pd=5.58u as=0 ps=0 w=4.4u l=0.6u
X3263 user_project_wrapper_0.sg13g2_IOPadVdd_3.sg13g2_RCClampInverter_noptap_0.out user_project_wrapper_0.sg13g2_IOPadVdd_3.sg13g2_RCClampResistor_0.p2 user_project_wrapper_0.IOVSS1 user_project_wrapper_0.IOVSS1 sg13_hv_pmos ad=1.33p pd=7.38u as=1.33p ps=7.38u w=7u l=0.5u
X3264 a_369296_278644# user_project_wrapper_0.IOVSS1 user_project_wrapper_0.IOVSS1 rppd l=3.54u w=0.5u
X3265 user_project_wrapper_0.analog_io[34] a_258244_355624# user_project_wrapper_0.IOVDD4 user_project_wrapper_0.IOVDD4 sg13_hv_pmos ad=3.9294p pd=7.84u as=2.1312p ps=7.3u w=6.66u l=0.6u
X3266 user_project_wrapper_0.IOVSS1 a_192745_324776# a_189672_324776# user_project_wrapper_0.IOVSS1 sg13_lv_nmos ad=0.19p pd=1.38u as=0.19p ps=1.38u w=1u l=0.13u
X3267 user_project_wrapper_0.IOVDD2 a_197044_41476# user_project_wrapper_0.analog_io[13] user_project_wrapper_0.IOVDD2 sg13_hv_pmos ad=2.1312p pd=7.3u as=3.9294p ps=7.84u w=6.66u l=0.6u
X3268 a_296731_208493# a_296625_208423# VDD3 VDD3 sg13_lv_pmos ad=0.2603p pd=1.75u as=0.2603p ps=1.75u w=1.37u l=0.35u
X3269 user_project_wrapper_0.IOVSS1 user_project_wrapper_0.sg13g2_IOPadIOVdd_1.sg13g2_Clamp_N43N43D4R_0.gate user_project_wrapper_0.IOVDD1 user_project_wrapper_0.IOVSS1 sg13_hv_nmos ad=1.408p pd=5.04u as=2.596p ps=5.58u w=4.4u l=0.6u
X3270 a_210109_327491# a_209684_327491# a_210007_327491# user_project_wrapper_0.IOVSS1 sg13_lv_nmos ad=0.19p pd=1.38u as=0.19p ps=1.38u w=1u l=0.13u
X3271 user_project_wrapper_0.IOVDD4 a_176644_355624# user_project_wrapper_0.analog_io[30] user_project_wrapper_0.IOVDD4 sg13_hv_pmos ad=2.1312p pd=7.3u as=3.9294p ps=7.84u w=6.66u l=0.6u
X3272 a_85211_124842# a_84332_125209# user_project_wrapper_0.IOVSS1 user_project_wrapper_0.IOVSS1 sg13_lv_nmos ad=0.2516p pd=2.16u as=0.2516p ps=2.16u w=0.74u l=0.13u
X3273 user_project_wrapper_0.sg13g2_IOPadIOVdd_2.sg13g2_Clamp_N43N43D4R_0.gate user_project_wrapper_0.sg13g2_IOPadIOVdd_2.sg13g2_RCClampResistor_0.p2 user_project_wrapper_0.IOVDD4 user_project_wrapper_0.IOVDD4 sg13_hv_pmos ad=1.33p pd=7.38u as=1.33p ps=7.38u w=7u l=0.5u
X3274 a_360372_79645# a_364458_79315# user_project_wrapper_0.IOVSS1 rppd l=20u w=1u
X3275 VDD3 user_project_wrapper_0.sg13g2_IOPadVdd_0.sg13g2_RCClampInverter_noptap_0.out user_project_wrapper_0.IOVSS1 user_project_wrapper_0.IOVSS1 sg13_hv_nmos ad=2.596p pd=5.58u as=1.408p ps=5.04u w=4.4u l=0.6u
X3276 a_309917_194695# user_project_wrapper_0.sg13g2_IOPadAnalog_29.padres a_311846_195517# VDD3 sg13_lv_pmos ad=0.24415p pd=1.665u as=0.24415p ps=1.665u w=1.285u l=0.35u
X3277 a_296731_208493# a_301186_192011# user_project_wrapper_0.IOVSS1 user_project_wrapper_0.IOVSS1 sg13_lv_nmos ad=0.912p pd=5.18u as=0.912p ps=5.18u w=4.8u l=1.06u
X3278 user_project_wrapper_0.analog_io[35] a_213870_324142# user_project_wrapper_0.IOVSS1 user_project_wrapper_0.IOVSS1 sg13_lv_nmos ad=0.912p pd=5.18u as=0.912p ps=5.18u w=4.8u l=0.13u
X3279 a_311189_211724# a_296731_208493# a_313884_211353# user_project_wrapper_0.IOVSS1 sg13_lv_nmos ad=1.9p pd=10.38u as=1.9p ps=10.38u w=10u l=0.5u
X3280 a_304090_197941# a_304090_197941# user_project_wrapper_0.IOVSS1 user_project_wrapper_0.IOVSS1 sg13_lv_nmos ad=0.17p pd=1.68u as=0.17p ps=1.68u w=0.5u l=0.8u
X3281 user_project_wrapper_0.VDD1 user_project_wrapper_0.sg13g2_IOPadVdd_2.sg13g2_RCClampResistor_0.p2 user_project_wrapper_0.sg13g2_IOPadVdd_2.sg13g2_RCClampInverter_noptap_0.out user_project_wrapper_0.VDD1 sg13_hv_pmos ad=1.33p pd=7.38u as=1.33p ps=7.38u w=7u l=0.5u
X3282 user_project_wrapper_0.IOVSS1 user_project_wrapper_0.sg13g2_IOPadIOVdd_2.sg13g2_Clamp_N43N43D4R_0.gate user_project_wrapper_0.IOVDD4 user_project_wrapper_0.IOVSS1 sg13_hv_nmos ad=1.408p pd=5.04u as=2.596p ps=5.58u w=4.4u l=0.6u
X3283 analog_io[20] a_311108_179669# VDD3 user_project_wrapper_0.IOVSS1 sg13_lv_nmos ad=3.4p pd=20.68u as=3.4p ps=20.68u w=10u l=0.15u
X3284 user_project_wrapper_0.IOVSS1 a_176644_369296# user_project_wrapper_0.analog_io[30] user_project_wrapper_0.IOVSS1 sg13_hv_nmos ad=2.068p pd=9.74u as=2.596p ps=5.58u w=4.4u l=0.6u
X3285 user_project_wrapper_0.sg13g2_IOPadVdd_1.sg13g2_RCClampInverter_noptap_0.out user_project_wrapper_0.sg13g2_IOPadVdd_1.sg13g2_RCClampResistor_0.p2 user_project_wrapper_0.VDD2 user_project_wrapper_0.VDD2 sg13_hv_pmos ad=1.33p pd=7.38u as=1.33p ps=7.38u w=7u l=0.5u
X3286 user_project_wrapper_0.IOVSS1 user_project_wrapper_0.sg13g2_IOPadVdd_3.sg13g2_RCClampInverter_noptap_0.out user_project_wrapper_0.IOVSS1 user_project_wrapper_0.IOVSS1 sg13_hv_nmos ad=1.408p pd=5.04u as=0 ps=0 w=4.4u l=0.6u
X3287 user_project_wrapper_0.IOVSS1 user_project_wrapper_0.sg13g2_IOPadVdd_3.sg13g2_RCClampInverter_noptap_0.out user_project_wrapper_0.IOVSS1 user_project_wrapper_0.IOVSS1 sg13_hv_nmos ad=1.408p pd=5.04u as=0 ps=0 w=4.4u l=0.6u
X3288 user_project_wrapper_0.analog_io[14] a_217444_29676# user_project_wrapper_0.IOVSS1 user_project_wrapper_0.IOVSS1 sg13_hv_nmos ad=2.596p pd=5.58u as=1.408p ps=5.04u w=4.4u l=0.6u
X3289 user_project_wrapper_0.IOVSS1 user_project_wrapper_0.sg13g2_IOPadIOVdd_3.sg13g2_Clamp_N43N43D4R_0.gate IOVDD3 user_project_wrapper_0.IOVSS1 sg13_hv_nmos ad=1.408p pd=5.04u as=2.596p ps=5.58u w=4.4u l=0.6u
X3290 user_project_wrapper_0.IOVSS1 user_project_wrapper_0.sg13g2_IOPadVdd_2.sg13g2_RCClampInverter_noptap_0.out user_project_wrapper_0.VDD1 user_project_wrapper_0.IOVSS1 sg13_hv_nmos ad=1.408p pd=5.04u as=2.596p ps=5.58u w=4.4u l=0.6u
X3291 user_project_wrapper_0.IOVSS1 a_87851_125174# a_87775_125210# user_project_wrapper_0.IOVSS1 sg13_lv_nmos ad=0.2516p pd=2.16u as=0.1406p ps=1.12u w=0.74u l=0.13u
X3292 VDD3 a_296625_189595# a_296731_189665# VDD3 sg13_lv_pmos ad=0.2603p pd=1.75u as=0.2603p ps=1.75u w=1.37u l=0.35u
X3293 a_121765_39542# a_121435_35456# user_project_wrapper_0.IOVSS1 rppd l=20u w=1u
X3294 a_191234_326377# a_190824_326377# user_project_wrapper_0.IOVSS1 w_188704_326203# sg13_lv_pmos ad=0.68p pd=4.68u as=0.68p ps=4.68u w=2u l=0.13u
X3295 user_project_wrapper_0.IOVDD2 user_project_wrapper_0.sg13g2_IOPadIOVdd_0.sg13g2_Clamp_N43N43D4R_0.gate user_project_wrapper_0.IOVSS1 user_project_wrapper_0.IOVSS1 sg13_hv_nmos ad=2.596p pd=5.58u as=1.408p ps=5.04u w=4.4u l=0.6u
X3296 user_project_wrapper_0.sg13g2_IOPadAnalog_27.padres analog_io[26] user_project_wrapper_0.IOVSS1 rppd l=2u w=1u
X3297 user_project_wrapper_0.IOVDD4 user_project_wrapper_0.sg13g2_IOPadIOVdd_2.sg13g2_Clamp_N43N43D4R_0.gate user_project_wrapper_0.IOVSS1 user_project_wrapper_0.IOVSS1 sg13_hv_nmos ad=2.596p pd=5.58u as=1.408p ps=5.04u w=4.4u l=0.6u
X3298 user_project_wrapper_0.IOVDD2 user_project_wrapper_0.sg13g2_IOPadIOVdd_0.sg13g2_RCClampResistor_0.p2 user_project_wrapper_0.sg13g2_IOPadIOVdd_0.sg13g2_Clamp_N43N43D4R_0.gate user_project_wrapper_0.IOVDD2 sg13_hv_pmos ad=1.33p pd=7.38u as=1.33p ps=7.38u w=7u l=0.5u
X3299 QDLL_TOP_0.VDD a_270178_100118# a_270512_100118# QDLL_TOP_0.VDD sg13_lv_pmos ad=0.3808p pd=2.92u as=0.2128p ps=1.5u w=1.12u l=0.13u
X3300 a_296731_208493# a_296625_208423# VDD3 VDD3 sg13_lv_pmos ad=0.2603p pd=1.75u as=0.2603p ps=1.75u w=1.37u l=0.35u
X3301 user_project_wrapper_0.IOVSS1 user_project_wrapper_0.sg13g2_IOPadVdd_0.sg13g2_RCClampResistor_0.p2 user_project_wrapper_0.IOVSS1 user_project_wrapper_0.IOVSS1 sg13_hv_nmos ad=1.71p pd=9.38u as=0 ps=0 w=9u l=9.5u
X3302 a_309917_194695# a_309516_194555# VDD3 VDD3 sg13_lv_pmos ad=0.19p pd=1.38u as=0.19p ps=1.38u w=1u l=0.7u
X3303 user_project_wrapper_0.IOVDD2 user_project_wrapper_0.sg13g2_IOPadIOVdd_0.sg13g2_Clamp_N43N43D4R_0.gate user_project_wrapper_0.IOVSS1 user_project_wrapper_0.IOVSS1 sg13_hv_nmos ad=2.596p pd=5.58u as=1.408p ps=5.04u w=4.4u l=0.6u
X3304 VDD3 a_296625_189595# a_296731_189665# VDD3 sg13_lv_pmos ad=0.2603p pd=1.75u as=0.2603p ps=1.75u w=1.37u l=0.35u
X3305 VDD3 user_project_wrapper_0.sg13g2_IOPadVdd_0.sg13g2_RCClampInverter_noptap_0.out user_project_wrapper_0.IOVSS1 user_project_wrapper_0.IOVSS1 sg13_hv_nmos ad=2.596p pd=5.58u as=1.408p ps=5.04u w=4.4u l=0.6u
X3306 user_project_wrapper_0.IOVDD2 user_project_wrapper_0.sg13g2_IOPadIOVdd_0.sg13g2_Clamp_N43N43D4R_0.gate user_project_wrapper_0.IOVSS1 user_project_wrapper_0.IOVSS1 sg13_hv_nmos ad=2.596p pd=5.58u as=1.408p ps=5.04u w=4.4u l=0.6u
X3307 a_313884_185173# analog_io[20] a_311108_179669# user_project_wrapper_0.IOVSS1 sg13_lv_nmos ad=1.9p pd=10.38u as=1.9p ps=10.38u w=10u l=0.5u
X3308 user_project_wrapper_0.IOVSS1 a_208579_324119# a_208171_324119# user_project_wrapper_0.IOVSS1 sg13_lv_nmos ad=0.34p pd=2.68u as=0.34p ps=2.68u w=1u l=0.13u
X3309 user_project_wrapper_0.IOVDD4 user_project_wrapper_0.sg13g2_IOPadIOVdd_2.sg13g2_Clamp_N43N43D4R_0.gate user_project_wrapper_0.IOVSS1 user_project_wrapper_0.IOVSS1 sg13_hv_nmos ad=2.596p pd=5.58u as=1.408p ps=5.04u w=4.4u l=0.6u
X3310 a_194687_324142# a_194279_327536# user_project_wrapper_0.IOVSS1 user_project_wrapper_0.IOVSS1 sg13_lv_pmos ad=1.824p pd=9.98u as=1.824p ps=9.98u w=9.6u l=0.13u
X3311 user_project_wrapper_0.IOVDD4 user_project_wrapper_0.sg13g2_IOPadIOVdd_2.sg13g2_Clamp_N43N43D4R_0.gate user_project_wrapper_0.IOVSS1 user_project_wrapper_0.IOVSS1 sg13_hv_nmos ad=2.596p pd=5.58u as=1.408p ps=5.04u w=4.4u l=0.6u
X3312 a_121105_39542# a_121435_35456# user_project_wrapper_0.IOVSS1 rppd l=20u w=1u
X3313 VDD3 user_project_wrapper_0.sg13g2_IOPadVdd_0.sg13g2_RCClampResistor_0.p2 user_project_wrapper_0.sg13g2_IOPadVdd_0.sg13g2_RCClampInverter_noptap_0.out VDD3 sg13_hv_pmos ad=1.33p pd=7.38u as=1.33p ps=7.38u w=7u l=0.5u
X3314 VDD3 user_project_wrapper_0.sg13g2_IOPadVdd_0.sg13g2_RCClampInverter_noptap_0.out user_project_wrapper_0.IOVSS1 user_project_wrapper_0.IOVSS1 sg13_hv_nmos ad=2.596p pd=5.58u as=1.408p ps=5.04u w=4.4u l=0.6u
X3315 user_project_wrapper_0.VDD1 user_project_wrapper_0.sg13g2_IOPadVdd_2.sg13g2_RCClampInverter_noptap_0.out user_project_wrapper_0.IOVSS1 user_project_wrapper_0.IOVSS1 sg13_hv_nmos ad=2.596p pd=5.58u as=1.408p ps=5.04u w=4.4u l=0.6u
X3316 user_project_wrapper_0.analog_io[32] a_202114_326125# user_project_wrapper_0.IOVSS1 user_project_wrapper_0.IOVSS1 sg13_lv_pmos ad=1.824p pd=9.98u as=1.824p ps=9.98u w=9.6u l=0.13u
X3317 a_78824_124371# a_78824_124371# user_project_wrapper_0.VDD1 user_project_wrapper_0.VDD1 sg13_lv_pmos ad=0.95p pd=5.38u as=1.7p ps=10.68u w=5u l=0.15u
X3318 user_project_wrapper_0.analog_io[30] a_194687_324142# user_project_wrapper_0.IOVSS1 user_project_wrapper_0.IOVSS1 sg13_lv_pmos ad=1.824p pd=9.98u as=1.824p ps=9.98u w=9.6u l=0.13u
X3319 user_project_wrapper_0.IOVSS1 user_project_wrapper_0.sg13g2_IOPadIOVdd_2.sg13g2_Clamp_N43N43D4R_0.gate user_project_wrapper_0.IOVDD4 user_project_wrapper_0.IOVSS1 sg13_hv_nmos ad=1.408p pd=5.04u as=2.596p ps=5.58u w=4.4u l=0.6u
X3320 user_project_wrapper_0.VDD2 user_project_wrapper_0.sg13g2_IOPadVdd_1.sg13g2_RCClampInverter_noptap_0.out user_project_wrapper_0.IOVSS1 user_project_wrapper_0.IOVSS1 sg13_hv_nmos ad=2.596p pd=5.58u as=1.408p ps=5.04u w=4.4u l=0.6u
X3321 analog_io[20] a_355624_176644# IOVDD3 IOVDD3 sg13_hv_pmos ad=3.9294p pd=7.84u as=2.1312p ps=7.3u w=6.66u l=0.6u
X3322 user_project_wrapper_0.IOVSS1 a_217444_369296# user_project_wrapper_0.analog_io[32] user_project_wrapper_0.IOVSS1 sg13_hv_nmos ad=1.408p pd=5.04u as=2.596p ps=5.58u w=4.4u l=0.6u
X3323 user_project_wrapper_0.analog_io[27] a_182931_326125# user_project_wrapper_0.IOVSS1 user_project_wrapper_0.IOVSS1 sg13_lv_nmos ad=0.912p pd=5.18u as=0.912p ps=5.18u w=4.8u l=0.13u
X3324 user_project_wrapper_0.IOVSS1 a_213462_327536# a_213870_324142# user_project_wrapper_0.IOVSS1 sg13_lv_nmos ad=0.912p pd=5.18u as=0.912p ps=5.18u w=4.8u l=0.13u
X3325 user_project_wrapper_0.IOVSS1 user_project_wrapper_0.IOVSS1 dantenna l=1.26u w=27.78u
X3326 analog_io[20] a_311108_179669# VDD3 user_project_wrapper_0.IOVSS1 sg13_lv_nmos ad=3.4p pd=20.68u as=3.4p ps=20.68u w=10u l=0.15u
X3327 user_project_wrapper_0.sg13g2_IOPadAnalog_5.padres user_project_wrapper_0.IOVDD2 dpantenna l=0.64u w=4.98u
X3328 user_project_wrapper_0.IOVSS1 user_project_wrapper_0.sg13g2_IOPadVdd_1.sg13g2_RCClampInverter_noptap_0.out user_project_wrapper_0.VDD2 user_project_wrapper_0.IOVSS1 sg13_hv_nmos ad=1.408p pd=5.04u as=2.596p ps=5.58u w=4.4u l=0.6u
X3329 a_121105_39542# a_120775_35456# user_project_wrapper_0.IOVSS1 rppd l=20u w=1u
X3330 user_project_wrapper_0.IOVSS1 a_29676_258244# user_project_wrapper_0.analog_io[7] user_project_wrapper_0.IOVSS1 sg13_hv_nmos ad=1.408p pd=5.04u as=2.596p ps=5.58u w=4.4u l=0.6u
X3331 a_202114_326125# a_205385_326221# user_project_wrapper_0.IOVSS1 user_project_wrapper_0.IOVSS1 sg13_lv_pmos ad=1.824p pd=9.98u as=1.824p ps=9.98u w=9.6u l=0.13u
X3332 VDD3 a_296625_189595# a_296731_189665# VDD3 sg13_lv_pmos ad=0.2603p pd=1.75u as=0.2603p ps=1.75u w=1.37u l=0.35u
X3333 user_project_wrapper_0.IOVSS1 a_307232_196607# a_304995_198817# user_project_wrapper_0.IOVSS1 sg13_lv_nmos ad=0.6327p pd=3.71u as=0.6327p ps=3.71u w=3.33u l=0.2u
X3334 user_project_wrapper_0.IOVSS1 user_project_wrapper_0.sg13g2_IOPadVdd_3.sg13g2_RCClampInverter_noptap_0.out user_project_wrapper_0.IOVSS1 user_project_wrapper_0.IOVSS1 sg13_hv_nmos ad=2.596p pd=5.58u as=0 ps=0 w=4.4u l=0.6u
X3335 VDD3 a_311189_185546# a_311189_185546# VDD3 sg13_lv_pmos ad=3.4p pd=20.68u as=1.9p ps=10.38u w=10u l=1u
X3336 IOVDD3 a_355624_115444# analog_io[18] IOVDD3 sg13_hv_pmos ad=2.1312p pd=7.3u as=3.9294p ps=7.84u w=6.66u l=0.6u
X3337 user_project_wrapper_0.IOVSS1 a_194687_324142# user_project_wrapper_0.analog_io[30] user_project_wrapper_0.IOVSS1 sg13_lv_nmos ad=0.912p pd=5.18u as=0.912p ps=5.18u w=4.8u l=0.13u
X3338 user_project_wrapper_0.IOVDD4 a_278644_355624# user_project_wrapper_0.analog_io[35] user_project_wrapper_0.IOVDD4 sg13_hv_pmos ad=3.1302p pd=14.26u as=3.9294p ps=7.84u w=6.66u l=0.6u
X3339 user_project_wrapper_0.VDD2 user_project_wrapper_0.sg13g2_IOPadVdd_1.sg13g2_RCClampResistor_0.p2 user_project_wrapper_0.sg13g2_IOPadVdd_1.sg13g2_RCClampInverter_noptap_0.out user_project_wrapper_0.VDD2 sg13_hv_pmos ad=1.33p pd=7.38u as=1.33p ps=7.38u w=7u l=0.5u
X3340 user_project_wrapper_0.analog_io[0] user_project_wrapper_0.IOVDD1 dpantenna l=27.78u w=1.26u
X3341 a_59490_159238# user_project_wrapper_0.sg13g2_IOPadIn$1_0.sg13g2_LevelDown_noptap$1_0.sg13g2_SecondaryProtection$1$1_0.core user_project_wrapper_0.IOVSS1 user_project_wrapper_0.IOVSS1 sg13_hv_nmos ad=0.901p pd=5.98u as=0.901p ps=5.98u w=2.65u l=0.45u
X3342 a_82645_242401# user_project_wrapper_0.sg13g2_IOPadAnalog_8.padres user_project_wrapper_0.IOVSS1 user_project_wrapper_0.IOVSS1 sg13_lv_nmos ad=0.17p pd=1.68u as=0.17p ps=1.68u w=0.5u l=0.15u
X3343 user_project_wrapper_0.sg13g2_IOPadIOVdd_1.sg13g2_Clamp_N43N43D4R_0.gate user_project_wrapper_0.sg13g2_IOPadIOVdd_1.sg13g2_RCClampResistor_0.p2 user_project_wrapper_0.IOVDD1 user_project_wrapper_0.IOVDD1 sg13_hv_pmos ad=1.33p pd=7.38u as=1.33p ps=7.38u w=7u l=0.5u
X3344 user_project_wrapper_0.IOVSS1 a_301186_192011# a_296731_208493# user_project_wrapper_0.IOVSS1 sg13_lv_nmos ad=0.912p pd=5.18u as=0.912p ps=5.18u w=4.8u l=1.06u
X3345 VDD3 a_296625_189595# a_296731_189665# VDD3 sg13_lv_pmos ad=0.2603p pd=1.75u as=0.2603p ps=1.75u w=1.37u l=0.35u
X3346 user_project_wrapper_0.IOVSS1 a_194687_324142# user_project_wrapper_0.analog_io[30] user_project_wrapper_0.IOVSS1 sg13_lv_nmos ad=0.912p pd=5.18u as=0.912p ps=5.18u w=4.8u l=0.13u
X3347 user_project_wrapper_0.IOVSS1 user_project_wrapper_0.analog_io[34] dantenna l=1.26u w=27.78u
X3348 user_project_wrapper_0.IOVDD2 a_135844_41476# user_project_wrapper_0.analog_io[10] user_project_wrapper_0.IOVDD2 sg13_hv_pmos ad=2.1312p pd=7.3u as=3.9294p ps=7.84u w=6.66u l=0.6u
X3349 a_186960_110495# a_187518_108410# user_project_wrapper_0.IOVSS1 rppd l=10u w=1u
X3350 a_83492_130212# a_83070_130577# a_83398_130212# user_project_wrapper_0.IOVSS1 sg13_lv_nmos ad=0.1406p pd=1.12u as=0.2516p ps=2.16u w=0.74u l=0.13u
X3351 VDD3 a_309516_194555# a_309917_199879# VDD3 sg13_lv_pmos ad=0.19p pd=1.38u as=0.19p ps=1.38u w=1u l=0.7u
X3352 IOVDD3 a_355624_237844# analog_io[23] IOVDD3 sg13_hv_pmos ad=2.1312p pd=7.3u as=3.9294p ps=7.84u w=6.66u l=0.6u
X3353 user_project_wrapper_0.IOVDD2 user_project_wrapper_0.sg13g2_IOPadIOVdd_0.sg13g2_Clamp_N43N43D4R_0.gate user_project_wrapper_0.IOVSS1 user_project_wrapper_0.IOVSS1 sg13_hv_nmos ad=2.596p pd=5.58u as=1.408p ps=5.04u w=4.4u l=0.6u
X3354 a_309917_194695# a_309516_194555# VDD3 VDD3 sg13_lv_pmos ad=0.19p pd=1.38u as=0.19p ps=1.38u w=1u l=0.7u
X3355 VDD3 a_309516_194555# a_309917_194695# VDD3 sg13_lv_pmos ad=0.19p pd=1.38u as=0.19p ps=1.38u w=1u l=0.7u
X3356 user_project_wrapper_0.analog_io[14] a_217444_29676# user_project_wrapper_0.IOVSS1 user_project_wrapper_0.IOVSS1 sg13_hv_nmos ad=2.596p pd=5.58u as=1.408p ps=5.04u w=4.4u l=0.6u
X3357 user_project_wrapper_0.IOVSS1 user_project_wrapper_0.sg13g2_IOPadIOVdd_0.sg13g2_Clamp_N43N43D4R_0.gate user_project_wrapper_0.IOVDD2 user_project_wrapper_0.IOVSS1 sg13_hv_nmos ad=1.408p pd=5.04u as=2.596p ps=5.58u w=4.4u l=0.6u
X3358 user_project_wrapper_0.IOVSS1 user_project_wrapper_0.sg13g2_IOPadVdd_2.sg13g2_RCClampInverter_noptap_0.out user_project_wrapper_0.VDD1 user_project_wrapper_0.IOVSS1 sg13_hv_nmos ad=1.408p pd=5.04u as=2.596p ps=5.58u w=4.4u l=0.6u
X3359 user_project_wrapper_0.IOVDD1 a_41476_135844# user_project_wrapper_0.analog_io[1] user_project_wrapper_0.IOVDD1 sg13_hv_pmos ad=2.1312p pd=7.3u as=3.9294p ps=7.84u w=6.66u l=0.6u
X3360 a_314697_196700# a_314793_201808# a_315347_192648# user_project_wrapper_0.IOVSS1 sg13_lv_nmos ad=1.14p pd=6.38u as=1.14p ps=6.38u w=6u l=6.4u
X3361 user_project_wrapper_0.analog_io[4] a_41476_197044# user_project_wrapper_0.IOVDD1 user_project_wrapper_0.IOVDD1 sg13_hv_pmos ad=3.9294p pd=7.84u as=2.1312p ps=7.3u w=6.66u l=0.6u
X3362 user_project_wrapper_0.sg13g2_IOPadVdd_1.sg13g2_RCClampInverter_noptap_0.out user_project_wrapper_0.sg13g2_IOPadVdd_1.sg13g2_RCClampResistor_0.p2 user_project_wrapper_0.VDD2 user_project_wrapper_0.VDD2 sg13_hv_pmos ad=1.33p pd=7.38u as=1.33p ps=7.38u w=7u l=0.5u
X3363 user_project_wrapper_0.IOVDD2 user_project_wrapper_0.sg13g2_IOPadIOVdd_0.sg13g2_Clamp_N43N43D4R_0.gate user_project_wrapper_0.IOVSS1 user_project_wrapper_0.IOVSS1 sg13_hv_nmos ad=2.596p pd=5.58u as=1.408p ps=5.04u w=4.4u l=0.6u
X3364 VDD3 a_296625_208423# a_296731_208493# VDD3 sg13_lv_pmos ad=0.2603p pd=1.75u as=0.2603p ps=1.75u w=1.37u l=0.35u
X3365 user_project_wrapper_0.sg13g2_IOPadIOVdd_1.sg13g2_Clamp_N43N43D4R_0.gate user_project_wrapper_0.sg13g2_IOPadIOVdd_1.sg13g2_RCClampResistor_0.p2 user_project_wrapper_0.IOVDD1 user_project_wrapper_0.IOVDD1 sg13_hv_pmos ad=1.33p pd=7.38u as=1.33p ps=7.38u w=7u l=0.5u
X3366 a_304995_198817# a_307232_196607# user_project_wrapper_0.IOVSS1 user_project_wrapper_0.IOVSS1 sg13_lv_nmos ad=0.6327p pd=3.71u as=0.6327p ps=3.71u w=3.33u l=0.2u
X3367 user_project_wrapper_0.analog_io[7] a_29676_258244# user_project_wrapper_0.IOVSS1 user_project_wrapper_0.IOVSS1 sg13_hv_nmos ad=2.596p pd=5.58u as=1.408p ps=5.04u w=4.4u l=0.6u
X3368 user_project_wrapper_0.IOVSS1 user_project_wrapper_0.sg13g2_IOPadIOVdd_1.sg13g2_Clamp_N43N43D4R_0.gate user_project_wrapper_0.IOVDD1 user_project_wrapper_0.IOVSS1 sg13_hv_nmos ad=1.408p pd=5.04u as=2.596p ps=5.58u w=4.4u l=0.6u
X3369 a_88274_129061# a_86594_129426# user_project_wrapper_0.IOVSS1 user_project_wrapper_0.IOVSS1 sg13_lv_nmos ad=0.1406p pd=1.12u as=0.2516p ps=2.16u w=0.74u l=0.13u
X3370 user_project_wrapper_0.IOVSS1 a_369296_176644# analog_io[20] user_project_wrapper_0.IOVSS1 sg13_hv_nmos ad=1.408p pd=5.04u as=2.596p ps=5.58u w=4.4u l=0.6u
X3371 a_311108_179669# a_311189_185546# VDD3 VDD3 sg13_lv_pmos ad=1.9p pd=10.38u as=3.4p ps=20.68u w=10u l=1u
X3372 analog_io[23] a_369296_237844# user_project_wrapper_0.IOVSS1 user_project_wrapper_0.IOVSS1 sg13_hv_nmos ad=2.596p pd=5.58u as=1.408p ps=5.04u w=4.4u l=0.6u
X3373 user_project_wrapper_0.analog_io[6] a_41476_237844# user_project_wrapper_0.IOVDD1 user_project_wrapper_0.IOVDD1 sg13_hv_pmos ad=3.9294p pd=7.84u as=2.1312p ps=7.3u w=6.66u l=0.6u
X3374 user_project_wrapper_0.IOVSS1 a_213870_324142# user_project_wrapper_0.analog_io[35] user_project_wrapper_0.IOVSS1 sg13_lv_nmos ad=0.912p pd=5.18u as=0.912p ps=5.18u w=4.8u l=0.13u
X3375 user_project_wrapper_0.analog_io[27] a_182931_326125# user_project_wrapper_0.IOVSS1 user_project_wrapper_0.IOVSS1 sg13_lv_nmos ad=0.912p pd=5.18u as=0.912p ps=5.18u w=4.8u l=0.13u
X3376 a_309917_199879# a_309516_194555# VDD3 VDD3 sg13_lv_pmos ad=0.19p pd=1.38u as=0.19p ps=1.38u w=1u l=0.7u
X3377 user_project_wrapper_0.analog_io[35] a_278644_355624# user_project_wrapper_0.IOVDD4 user_project_wrapper_0.IOVDD4 sg13_hv_pmos ad=3.9294p pd=7.84u as=2.1312p ps=7.3u w=6.66u l=0.6u
X3378 user_project_wrapper_0.IOVSS1 a_29676_217444# user_project_wrapper_0.analog_io[5] user_project_wrapper_0.IOVSS1 sg13_hv_nmos ad=1.408p pd=5.04u as=2.596p ps=5.58u w=4.4u l=0.6u
X3379 user_project_wrapper_0.analog_io[27] a_115444_355624# user_project_wrapper_0.IOVDD4 user_project_wrapper_0.IOVDD4 sg13_hv_pmos ad=3.9294p pd=7.84u as=2.1312p ps=7.3u w=6.66u l=0.6u
X3380 user_project_wrapper_0.IOVDD4 user_project_wrapper_0.sg13g2_IOPadIOVdd_2.sg13g2_RCClampResistor_0.p2 user_project_wrapper_0.sg13g2_IOPadIOVdd_2.sg13g2_Clamp_N43N43D4R_0.gate user_project_wrapper_0.IOVDD4 sg13_hv_pmos ad=1.33p pd=7.38u as=1.33p ps=7.38u w=7u l=0.5u
X3381 user_project_wrapper_0.IOVDD1 user_project_wrapper_0.sg13g2_IOPadIOVdd_1.sg13g2_Clamp_N43N43D4R_0.gate user_project_wrapper_0.IOVSS1 user_project_wrapper_0.IOVSS1 sg13_hv_nmos ad=2.596p pd=5.58u as=1.408p ps=5.04u w=4.4u l=0.6u
X3382 user_project_wrapper_0.IOVSS1 a_194687_324142# user_project_wrapper_0.analog_io[30] user_project_wrapper_0.IOVSS1 sg13_lv_pmos ad=1.824p pd=9.98u as=1.824p ps=9.98u w=9.6u l=0.13u
X3383 a_296625_208423# a_304090_197941# a_304196_200821# user_project_wrapper_0.IOVSS1 sg13_lv_nmos ad=0.361p pd=2.28u as=0.646p ps=4.48u w=1.9u l=0.16u
X3384 user_project_wrapper_0.IOVDD4 a_258244_355624# user_project_wrapper_0.analog_io[34] user_project_wrapper_0.IOVDD4 sg13_hv_pmos ad=2.1312p pd=7.3u as=3.9294p ps=7.84u w=6.66u l=0.6u
X3385 user_project_wrapper_0.IOVSS1 analog_io[23] dantenna l=27.78u w=1.26u
X3386 user_project_wrapper_0.VDD2 user_project_wrapper_0.sg13g2_IOPadVdd_1.sg13g2_RCClampInverter_noptap_0.out user_project_wrapper_0.IOVSS1 user_project_wrapper_0.IOVSS1 sg13_hv_nmos ad=2.596p pd=5.58u as=1.408p ps=5.04u w=4.4u l=0.6u
X3387 user_project_wrapper_0.VDD1 user_project_wrapper_0.sg13g2_IOPadVdd_2.sg13g2_RCClampInverter_noptap_0.out user_project_wrapper_0.IOVSS1 user_project_wrapper_0.IOVSS1 sg13_hv_nmos ad=2.596p pd=5.58u as=1.408p ps=5.04u w=4.4u l=0.6u
X3388 user_project_wrapper_0.IOVSS1 a_301186_192011# a_296731_189665# user_project_wrapper_0.IOVSS1 sg13_lv_nmos ad=0.912p pd=5.18u as=0.912p ps=5.18u w=4.8u l=1.06u
X3389 a_296732_197880# a_301940_196388# a_296625_189595# VDD3 sg13_lv_pmos ad=0.7695p pd=4.43u as=0.7695p ps=4.43u w=4.05u l=0.5u
X3390 VDD3 a_309516_194555# a_309917_199879# VDD3 sg13_lv_pmos ad=0.19p pd=1.38u as=0.19p ps=1.38u w=1u l=0.7u
X3391 VDD3 a_296625_208423# a_296731_208493# VDD3 sg13_lv_pmos ad=0.2603p pd=1.75u as=0.2603p ps=1.75u w=1.37u l=0.35u
X3392 user_project_wrapper_0.IOVSS1 a_29676_197044# user_project_wrapper_0.analog_io[4] user_project_wrapper_0.IOVSS1 sg13_hv_nmos ad=2.068p pd=9.74u as=2.596p ps=5.58u w=4.4u l=0.6u
X3393 user_project_wrapper_0.IOVSS1 a_213376_328627# a_213462_327536# user_project_wrapper_0.IOVSS1 sg13_lv_pmos ad=1.824p pd=9.98u as=1.824p ps=9.98u w=9.6u l=0.13u
X3394 a_209905_328013# a_208939_327491# user_project_wrapper_0.IOVSS1 w_207887_327938# sg13_lv_pmos ad=0.38p pd=2.38u as=0.68p ps=4.68u w=2u l=0.13u
X3395 user_project_wrapper_0.IOVSS1 a_29676_115444# user_project_wrapper_0.IOVSS1 rppd l=3.54u w=0.5u
X3396 user_project_wrapper_0.IOVSS1 a_188834_326341# a_189858_328605# w_188704_327938# sg13_lv_pmos ad=0.68p pd=4.68u as=0.38p ps=2.38u w=2u l=0.13u
X3397 user_project_wrapper_0.IOVSS1 user_project_wrapper_0.sg13g2_IOPadOut4mA$1_1.sg13g2_GateLevelUpInv_noptap$1$1_0.ngate dantenna l=0.78u w=0.78u
X3398 a_210621_328605# TOP_ROILIFNEURON_0.MEM user_project_wrapper_0.IOVSS1 rppd l=0.5u w=0.5u
X3399 user_project_wrapper_0.sg13g2_IOPadIOVdd_1.sg13g2_Clamp_N43N43D4R_0.gate user_project_wrapper_0.sg13g2_IOPadIOVdd_1.sg13g2_RCClampResistor_0.p2 user_project_wrapper_0.IOVDD1 user_project_wrapper_0.IOVDD1 sg13_hv_pmos ad=1.33p pd=7.38u as=1.33p ps=7.38u w=7u l=0.5u
X3400 a_190297_329719# a_189756_329719# user_project_wrapper_0.IOVSS1 user_project_wrapper_0.IOVSS1 sg13_lv_nmos ad=0.34p pd=2.68u as=0.34p ps=2.68u w=1u l=0.13u
X3401 user_project_wrapper_0.IOVSS1 user_project_wrapper_0.sg13g2_IOPadIOVdd_1.sg13g2_Clamp_N43N43D4R_0.gate user_project_wrapper_0.IOVDD1 user_project_wrapper_0.IOVSS1 sg13_hv_nmos ad=1.408p pd=5.04u as=2.596p ps=5.58u w=4.4u l=0.6u
X3402 user_project_wrapper_0.IOVSS1 user_project_wrapper_0.sg13g2_IOPadVdd_2.sg13g2_RCClampInverter_noptap_0.out user_project_wrapper_0.VDD1 user_project_wrapper_0.IOVSS1 sg13_hv_nmos ad=1.408p pd=5.04u as=2.596p ps=5.58u w=4.4u l=0.6u
X3403 user_project_wrapper_0.IOVSS1 a_213870_324142# user_project_wrapper_0.analog_io[35] user_project_wrapper_0.IOVSS1 sg13_lv_pmos ad=1.824p pd=9.98u as=1.824p ps=9.98u w=9.6u l=0.13u
X3404 user_project_wrapper_0.IOVSS1 user_project_wrapper_0.sg13g2_IOPadVdd_3.sg13g2_RCClampInverter_noptap_0.out user_project_wrapper_0.IOVSS1 user_project_wrapper_0.IOVSS1 sg13_hv_nmos ad=2.596p pd=5.58u as=0 ps=0 w=4.4u l=0.6u
X3405 a_296731_189665# a_296625_189595# VDD3 VDD3 sg13_lv_pmos ad=0.2603p pd=1.75u as=0.2603p ps=1.75u w=1.37u l=0.35u
X3406 a_186731_92558# user_project_wrapper_0.analog_io[13] user_project_wrapper_0.IOVSS1 rppd l=10u w=1u
X3407 user_project_wrapper_0.IOVDD2 a_156244_41476# user_project_wrapper_0.analog_io[11] user_project_wrapper_0.IOVDD2 sg13_hv_pmos ad=2.1312p pd=7.3u as=3.9294p ps=7.84u w=6.66u l=0.6u
X3408 VDD3 a_309516_194555# a_309917_199879# VDD3 sg13_lv_pmos ad=0.19p pd=1.38u as=0.19p ps=1.38u w=1u l=0.7u
X3409 user_project_wrapper_0.analog_io[35] a_213870_324142# user_project_wrapper_0.IOVSS1 user_project_wrapper_0.IOVSS1 sg13_lv_nmos ad=0.912p pd=5.18u as=0.912p ps=5.18u w=4.8u l=0.13u
X3410 VDD3 a_314697_196700# a_314793_197200# VDD3 sg13_lv_pmos ad=1.14p pd=6.38u as=1.14p ps=6.38u w=6u l=2.5u
X3411 user_project_wrapper_0.IOVSS1 user_project_wrapper_0.sg13g2_IOPadAnalog_21.padres a_209041_329719# user_project_wrapper_0.IOVSS1 sg13_lv_nmos ad=0.34p pd=2.68u as=0.19p ps=1.38u w=1u l=0.13u
X3412 analog_io[19] a_369296_135844# user_project_wrapper_0.IOVSS1 user_project_wrapper_0.IOVSS1 sg13_hv_nmos ad=2.596p pd=5.58u as=1.408p ps=5.04u w=4.4u l=0.6u
X3413 user_project_wrapper_0.IOVSS1 a_197044_29676# user_project_wrapper_0.analog_io[13] user_project_wrapper_0.IOVSS1 sg13_hv_nmos ad=1.408p pd=5.04u as=2.596p ps=5.58u w=4.4u l=0.6u
X3414 user_project_wrapper_0.IOVSS1 user_project_wrapper_0.sg13g2_IOPadVdd_2.sg13g2_RCClampInverter_noptap_0.out user_project_wrapper_0.VDD1 user_project_wrapper_0.IOVSS1 sg13_hv_nmos ad=1.408p pd=5.04u as=2.596p ps=5.58u w=4.4u l=0.6u
X3415 VDD3 a_311108_215937# analog_io[23] user_project_wrapper_0.IOVSS1 sg13_lv_nmos ad=3.4p pd=20.68u as=3.4p ps=20.68u w=10u l=0.15u
X3416 user_project_wrapper_0.sg13g2_IOPadVdd_2.sg13g2_RCClampInverter_noptap_0.out user_project_wrapper_0.sg13g2_IOPadVdd_2.sg13g2_RCClampResistor_0.p2 user_project_wrapper_0.IOVSS1 user_project_wrapper_0.IOVSS1 sg13_hv_nmos ad=1.71p pd=9.38u as=1.71p ps=9.38u w=9u l=0.5u
X3417 user_project_wrapper_0.analog_io[15] a_237844_41476# user_project_wrapper_0.IOVDD2 user_project_wrapper_0.IOVDD2 sg13_hv_pmos ad=3.9294p pd=7.84u as=2.1312p ps=7.3u w=6.66u l=0.6u
X3418 user_project_wrapper_0.VDD1 a_78824_135221# a_78824_135221# user_project_wrapper_0.VDD1 sg13_lv_pmos ad=1.7p pd=10.68u as=0.95p ps=5.38u w=5u l=0.15u
X3419 a_309917_199879# a_296731_208493# a_307232_196607# VDD3 sg13_lv_pmos ad=0.24415p pd=1.665u as=0.24415p ps=1.665u w=1.285u l=0.35u
X3420 a_269355_100412# a_269079_100182# user_project_wrapper_0.IOVSS1 user_project_wrapper_0.IOVSS1 sg13_lv_nmos ad=0.2516p pd=2.16u as=0.1426p ps=1.16u w=0.74u l=0.13u
X3421 VDD3 a_296626_197740# a_296732_200582# VDD3 sg13_lv_pmos ad=1.33p pd=7.38u as=1.33p ps=7.38u w=7u l=0.7u
X3422 user_project_wrapper_0.analog_io[33] a_237844_355624# user_project_wrapper_0.IOVDD4 user_project_wrapper_0.IOVDD4 sg13_hv_pmos ad=3.9294p pd=7.84u as=2.1312p ps=7.3u w=6.66u l=0.6u
X3423 a_309516_194555# a_309516_194555# VDD3 VDD3 sg13_lv_pmos ad=0.19p pd=1.38u as=0.19p ps=1.38u w=1u l=0.7u
X3424 user_project_wrapper_0.IOVSS1 user_project_wrapper_0.sg13g2_IOPadVdd_1.sg13g2_RCClampInverter_noptap_0.out user_project_wrapper_0.VDD2 user_project_wrapper_0.IOVSS1 sg13_hv_nmos ad=1.408p pd=5.04u as=2.596p ps=5.58u w=4.4u l=0.6u
X3425 a_77995_364458# a_78325_360372# user_project_wrapper_0.IOVSS1 rppd l=20u w=1u
X3426 user_project_wrapper_0.VDD2 user_project_wrapper_0.sg13g2_IOPadVdd_1.sg13g2_RCClampInverter_noptap_0.out user_project_wrapper_0.IOVSS1 user_project_wrapper_0.IOVSS1 sg13_hv_nmos ad=2.596p pd=5.58u as=2.068p ps=9.74u w=4.4u l=0.6u
X3427 a_296731_189665# a_296625_189595# VDD3 VDD3 sg13_lv_pmos ad=0.2603p pd=1.75u as=0.2603p ps=1.75u w=1.37u l=0.35u
X3428 user_project_wrapper_0.IOVSS1 a_213870_324142# user_project_wrapper_0.analog_io[35] user_project_wrapper_0.IOVSS1 sg13_lv_pmos ad=1.824p pd=9.98u as=1.824p ps=9.98u w=9.6u l=0.13u
X3429 user_project_wrapper_0.IOVSS1 user_project_wrapper_0.sg13g2_IOPadVdd_2.sg13g2_RCClampInverter_noptap_0.out user_project_wrapper_0.VDD1 user_project_wrapper_0.IOVSS1 sg13_hv_nmos ad=1.408p pd=5.04u as=2.596p ps=5.58u w=4.4u l=0.6u
X3430 user_project_wrapper_0.analog_io[4] a_41476_197044# user_project_wrapper_0.IOVDD1 user_project_wrapper_0.IOVDD1 sg13_hv_pmos ad=3.9294p pd=7.84u as=2.1312p ps=7.3u w=6.66u l=0.6u
X3431 IOVDD3 user_project_wrapper_0.sg13g2_IOPadIOVdd_3.sg13g2_Clamp_N43N43D4R_0.gate user_project_wrapper_0.IOVSS1 user_project_wrapper_0.IOVSS1 sg13_hv_nmos ad=2.596p pd=5.58u as=1.408p ps=5.04u w=4.4u l=0.6u
X3432 a_296731_189665# a_296625_189595# VDD3 VDD3 sg13_lv_pmos ad=0.2603p pd=1.75u as=0.2603p ps=1.75u w=1.37u l=0.35u
X3433 analog_io[18] a_369296_115444# user_project_wrapper_0.IOVSS1 user_project_wrapper_0.IOVSS1 sg13_hv_nmos ad=2.596p pd=5.58u as=1.408p ps=5.04u w=4.4u l=0.6u
X3434 user_project_wrapper_0.IOVSS1 user_project_wrapper_0.sg13g2_IOPadAnalog_1.padres dantenna l=0.64u w=3.1u
X3435 a_296731_208493# a_296625_208423# VDD3 VDD3 sg13_lv_pmos ad=0.2603p pd=1.75u as=0.2603p ps=1.75u w=1.37u l=0.35u
X3436 a_190824_329719# a_189184_329719# a_190722_329719# user_project_wrapper_0.IOVSS1 sg13_lv_nmos ad=0.19p pd=1.38u as=0.19p ps=1.38u w=1u l=0.13u
X3437 user_project_wrapper_0.IOVSS1 a_213870_324142# user_project_wrapper_0.analog_io[35] user_project_wrapper_0.IOVSS1 sg13_lv_pmos ad=1.824p pd=9.98u as=1.824p ps=9.98u w=9.6u l=0.13u
X3438 VDD3 a_296625_189595# a_296731_189665# VDD3 sg13_lv_pmos ad=0.4658p pd=3.42u as=0.2603p ps=1.75u w=1.37u l=0.35u
X3439 a_309917_199879# a_309516_194555# VDD3 VDD3 sg13_lv_pmos ad=0.19p pd=1.38u as=0.19p ps=1.38u w=1u l=0.7u
X3440 VDD3 a_309516_194555# a_309917_199879# VDD3 sg13_lv_pmos ad=0.19p pd=1.38u as=0.19p ps=1.38u w=1u l=0.7u
X3441 analog_io[26] a_355624_278644# IOVDD3 IOVDD3 sg13_hv_pmos ad=3.9294p pd=7.84u as=2.1312p ps=7.3u w=6.66u l=0.6u
X3442 user_project_wrapper_0.IOVDD1 user_project_wrapper_0.sg13g2_IOPadIOVdd_1.sg13g2_Clamp_N43N43D4R_0.gate user_project_wrapper_0.IOVSS1 user_project_wrapper_0.IOVSS1 sg13_hv_nmos ad=2.596p pd=5.58u as=1.408p ps=5.04u w=4.4u l=0.6u
X3443 user_project_wrapper_0.IOVDD4 user_project_wrapper_0.sg13g2_IOPadIOVdd_2.sg13g2_Clamp_N43N43D4R_0.gate user_project_wrapper_0.IOVSS1 user_project_wrapper_0.IOVSS1 sg13_hv_nmos ad=2.596p pd=5.58u as=1.408p ps=5.04u w=4.4u l=0.6u
X3444 user_project_wrapper_0.analog_io[35] a_278644_355624# user_project_wrapper_0.IOVDD4 user_project_wrapper_0.IOVDD4 sg13_hv_pmos ad=3.9294p pd=7.84u as=2.1312p ps=7.3u w=6.66u l=0.6u
X3445 user_project_wrapper_0.IOVSS1 a_208171_324119# a_208103_324155# user_project_wrapper_0.IOVSS1 sg13_lv_nmos ad=0.34p pd=2.68u as=0.19p ps=1.38u w=1u l=0.13u
X3446 user_project_wrapper_0.IOVSS1 user_project_wrapper_0.sg13g2_IOPadIOVdd_0.sg13g2_Clamp_N43N43D4R_0.gate user_project_wrapper_0.IOVDD2 user_project_wrapper_0.IOVSS1 sg13_hv_nmos ad=1.408p pd=5.04u as=2.596p ps=5.58u w=4.4u l=0.6u
X3447 user_project_wrapper_0.VDD1 user_project_wrapper_0.sg13g2_IOPadVdd_2.sg13g2_RCClampResistor_0.p2 user_project_wrapper_0.sg13g2_IOPadVdd_2.sg13g2_RCClampInverter_noptap_0.out user_project_wrapper_0.VDD1 sg13_hv_pmos ad=1.33p pd=7.38u as=1.33p ps=7.38u w=7u l=0.5u
X3448 user_project_wrapper_0.IOVDD4 user_project_wrapper_0.sg13g2_IOPadIOVdd_2.sg13g2_Clamp_N43N43D4R_0.gate user_project_wrapper_0.IOVSS1 user_project_wrapper_0.IOVSS1 sg13_hv_nmos ad=2.596p pd=5.58u as=1.408p ps=5.04u w=4.4u l=0.6u
X3449 user_project_wrapper_0.IOVDD4 a_135844_355624# user_project_wrapper_0.analog_io[28] user_project_wrapper_0.IOVDD4 sg13_hv_pmos ad=3.1302p pd=14.26u as=3.9294p ps=7.84u w=6.66u l=0.6u
X3450 user_project_wrapper_0.IOVSS1 user_project_wrapper_0.sg13g2_IOPadVdd_1.sg13g2_RCClampResistor_0.p2 user_project_wrapper_0.sg13g2_IOPadVdd_1.sg13g2_RCClampInverter_noptap_0.out user_project_wrapper_0.IOVSS1 sg13_hv_nmos ad=1.71p pd=9.38u as=1.71p ps=9.38u w=9u l=0.5u
X3451 a_208017_327918# a_208017_327918# user_project_wrapper_0.IOVSS1 w_207887_327938# sg13_lv_pmos ad=0.68p pd=4.68u as=0.68p ps=4.68u w=2u l=0.13u
X3452 user_project_wrapper_0.IOVDD4 user_project_wrapper_0.sg13g2_IOPadIOVdd_2.sg13g2_Clamp_N43N43D4R_0.gate user_project_wrapper_0.IOVSS1 user_project_wrapper_0.IOVSS1 sg13_hv_nmos ad=2.596p pd=5.58u as=1.408p ps=5.04u w=4.4u l=0.6u
X3453 user_project_wrapper_0.IOVSS1 user_project_wrapper_0.sg13g2_IOPadVdd_3.sg13g2_RCClampInverter_noptap_0.out user_project_wrapper_0.IOVSS1 user_project_wrapper_0.IOVSS1 sg13_hv_nmos ad=2.596p pd=5.58u as=0 ps=0 w=4.4u l=0.6u
X3454 analog_io[23] a_355624_237844# IOVDD3 IOVDD3 sg13_hv_pmos ad=3.9294p pd=7.84u as=2.1312p ps=7.3u w=6.66u l=0.6u
X3455 user_project_wrapper_0.sg13g2_IOPadIOVdd_1.sg13g2_Clamp_N43N43D4R_0.gate user_project_wrapper_0.sg13g2_IOPadIOVdd_1.sg13g2_RCClampResistor_0.p2 user_project_wrapper_0.IOVDD1 user_project_wrapper_0.IOVDD1 sg13_hv_pmos ad=1.33p pd=7.38u as=1.33p ps=7.38u w=7u l=0.5u
X3456 a_210109_326377# a_208367_326377# a_210007_326377# w_207887_326203# sg13_lv_pmos ad=0.38p pd=2.38u as=0.38p ps=2.38u w=2u l=0.13u
X3457 a_296731_208493# a_296625_208423# VDD3 VDD3 sg13_lv_pmos ad=0.2603p pd=1.75u as=0.2603p ps=1.75u w=1.37u l=0.35u
X3458 user_project_wrapper_0.IOVSS1 user_project_wrapper_0.IOVSS1 user_project_wrapper_0.IOVSS1 rppd l=0.5u w=0.5u
X3459 user_project_wrapper_0.analog_io[35] a_278644_369296# user_project_wrapper_0.IOVSS1 user_project_wrapper_0.IOVSS1 sg13_hv_nmos ad=2.596p pd=5.58u as=1.408p ps=5.04u w=4.4u l=0.6u
X3460 VDD3 a_309516_194555# a_309917_199879# VDD3 sg13_lv_pmos ad=0.19p pd=1.38u as=0.19p ps=1.38u w=1u l=0.7u
X3461 user_project_wrapper_0.analog_io[27] a_115444_369296# user_project_wrapper_0.IOVSS1 user_project_wrapper_0.IOVSS1 sg13_hv_nmos ad=2.596p pd=5.58u as=1.408p ps=5.04u w=4.4u l=0.6u
X3462 VDD3 a_296625_189595# a_296731_189665# VDD3 sg13_lv_pmos ad=0.2603p pd=1.75u as=0.2603p ps=1.75u w=1.37u l=0.35u
X3463 user_project_wrapper_0.IOVSS1 a_369296_135844# analog_io[19] user_project_wrapper_0.IOVSS1 sg13_hv_nmos ad=1.408p pd=5.04u as=2.596p ps=5.58u w=4.4u l=0.6u
X3464 user_project_wrapper_0.IOVSS1 a_213462_327536# a_213870_324142# user_project_wrapper_0.IOVSS1 sg13_lv_nmos ad=0.912p pd=5.18u as=0.912p ps=5.18u w=4.8u l=0.13u
X3465 a_309917_194695# a_309516_194555# VDD3 VDD3 sg13_lv_pmos ad=0.19p pd=1.38u as=0.19p ps=1.38u w=1u l=0.7u
X3466 user_project_wrapper_0.IOVDD4 a_176644_355624# user_project_wrapper_0.analog_io[30] user_project_wrapper_0.IOVDD4 sg13_hv_pmos ad=2.1312p pd=7.3u as=3.9294p ps=7.84u w=6.66u l=0.6u
X3467 user_project_wrapper_0.IOVSS1 user_project_wrapper_0.sg13g2_IOPadIOVdd_3.sg13g2_Clamp_N43N43D4R_0.gate IOVDD3 user_project_wrapper_0.IOVSS1 sg13_hv_nmos ad=1.408p pd=5.04u as=2.596p ps=5.58u w=4.4u l=0.6u
X3468 user_project_wrapper_0.IOVSS1 user_project_wrapper_0.sg13g2_IOPadIOVdd_3.sg13g2_Clamp_N43N43D4R_0.gate IOVDD3 user_project_wrapper_0.IOVSS1 sg13_hv_nmos ad=1.408p pd=5.04u as=2.596p ps=5.58u w=4.4u l=0.6u
X3469 VDD3 a_296625_208423# a_296731_208493# VDD3 sg13_lv_pmos ad=0.4658p pd=3.42u as=0.2603p ps=1.75u w=1.37u l=0.35u
X3470 user_project_wrapper_0.IOVSS1 user_project_wrapper_0.sg13g2_IOPadIOVdd_2.sg13g2_Clamp_N43N43D4R_0.gate user_project_wrapper_0.IOVDD4 user_project_wrapper_0.IOVSS1 sg13_hv_nmos ad=1.408p pd=5.04u as=2.596p ps=5.58u w=4.4u l=0.6u
X3471 user_project_wrapper_0.IOVSS1 a_194687_324142# user_project_wrapper_0.analog_io[30] user_project_wrapper_0.IOVSS1 sg13_lv_nmos ad=0.912p pd=5.18u as=0.912p ps=5.18u w=4.8u l=0.13u
X3472 user_project_wrapper_0.analog_io[5] a_41476_217444# user_project_wrapper_0.IOVDD1 user_project_wrapper_0.IOVDD1 sg13_hv_pmos ad=3.9294p pd=7.84u as=2.1312p ps=7.3u w=6.66u l=0.6u
X3473 user_project_wrapper_0.IOVSS1 user_project_wrapper_0.sg13g2_IOPadIOVdd_2.sg13g2_Clamp_N43N43D4R_0.gate user_project_wrapper_0.IOVDD4 user_project_wrapper_0.IOVSS1 sg13_hv_nmos ad=1.408p pd=5.04u as=2.596p ps=5.58u w=4.4u l=0.6u
X3474 user_project_wrapper_0.IOVSS1 user_project_wrapper_0.sg13g2_IOPadVdd_3.sg13g2_RCClampResistor_0.p2 user_project_wrapper_0.IOVSS1 user_project_wrapper_0.IOVSS1 sg13_hv_nmos ad=1.71p pd=9.38u as=0 ps=0 w=9u l=9.5u
X3475 user_project_wrapper_0.IOVSS1 user_project_wrapper_0.sg13g2_IOPadVdd_0.sg13g2_RCClampInverter_noptap_0.out VDD3 user_project_wrapper_0.IOVSS1 sg13_hv_nmos ad=1.408p pd=5.04u as=2.596p ps=5.58u w=4.4u l=0.6u
X3476 user_project_wrapper_0.analog_io[6] a_41476_237844# user_project_wrapper_0.IOVDD1 user_project_wrapper_0.IOVDD1 sg13_hv_pmos ad=3.9294p pd=7.84u as=2.1312p ps=7.3u w=6.66u l=0.6u
X3477 user_project_wrapper_0.analog_io[13] a_186397_108409# user_project_wrapper_0.IOVSS1 rppd l=10u w=1u
X3478 user_project_wrapper_0.IOVDD4 a_278644_355624# user_project_wrapper_0.analog_io[35] user_project_wrapper_0.IOVDD4 sg13_hv_pmos ad=2.1312p pd=7.3u as=3.9294p ps=7.84u w=6.66u l=0.6u
X3479 user_project_wrapper_0.VDD2 user_project_wrapper_0.sg13g2_IOPadVdd_1.sg13g2_RCClampInverter_noptap_0.out user_project_wrapper_0.IOVSS1 user_project_wrapper_0.IOVSS1 sg13_hv_nmos ad=2.596p pd=5.58u as=1.408p ps=5.04u w=4.4u l=0.6u
X3480 IOVDD3 a_355624_156244# analog_io[20] IOVDD3 sg13_hv_pmos ad=2.1312p pd=7.3u as=3.9294p ps=7.84u w=6.66u l=0.6u
X3481 a_296625_189595# a_304090_197941# a_304196_197873# user_project_wrapper_0.IOVSS1 sg13_lv_nmos ad=0.361p pd=2.28u as=0.361p ps=2.28u w=1.9u l=0.16u
X3482 analog_io[23] a_355624_217444# IOVDD3 IOVDD3 sg13_hv_pmos ad=3.9294p pd=7.84u as=2.1312p ps=7.3u w=6.66u l=0.6u
X3483 user_project_wrapper_0.IOVDD4 a_115444_355624# user_project_wrapper_0.analog_io[27] user_project_wrapper_0.IOVDD4 sg13_hv_pmos ad=2.1312p pd=7.3u as=3.9294p ps=7.84u w=6.66u l=0.6u
X3484 user_project_wrapper_0.IOVSS1 user_project_wrapper_0.sg13g2_IOPadIOVdd_1.sg13g2_Clamp_N43N43D4R_0.gate user_project_wrapper_0.IOVDD1 user_project_wrapper_0.IOVSS1 sg13_hv_nmos ad=1.408p pd=5.04u as=2.596p ps=5.58u w=4.4u l=0.6u
X3485 a_296625_208423# a_304090_197941# a_304196_200821# user_project_wrapper_0.IOVSS1 sg13_lv_nmos ad=0.361p pd=2.28u as=0.361p ps=2.28u w=1.9u l=0.16u
X3486 user_project_wrapper_0.IOVDD2 a_156244_41476# user_project_wrapper_0.analog_io[11] user_project_wrapper_0.IOVDD2 sg13_hv_pmos ad=2.1312p pd=7.3u as=3.9294p ps=7.84u w=6.66u l=0.6u
X3487 user_project_wrapper_0.IOVSS1 user_project_wrapper_0.sg13g2_IOPadVdd_1.sg13g2_RCClampInverter_noptap_0.out user_project_wrapper_0.VDD2 user_project_wrapper_0.IOVSS1 sg13_hv_nmos ad=1.408p pd=5.04u as=2.596p ps=5.58u w=4.4u l=0.6u
X3488 VDD3 a_296626_197740# a_296732_197880# VDD3 sg13_lv_pmos ad=1.33p pd=7.38u as=1.33p ps=7.38u w=7u l=0.7u
X3489 user_project_wrapper_0.analog_io[30] a_194687_324142# user_project_wrapper_0.IOVSS1 user_project_wrapper_0.IOVSS1 sg13_lv_pmos ad=1.824p pd=9.98u as=1.824p ps=9.98u w=9.6u l=0.13u
X3490 IOVDD3 a_355624_278644# analog_io[26] IOVDD3 sg13_hv_pmos ad=2.1312p pd=7.3u as=3.9294p ps=7.84u w=6.66u l=0.6u
X3491 user_project_wrapper_0.IOVDD2 user_project_wrapper_0.sg13g2_IOPadIOVdd_0.sg13g2_RCClampResistor_0.p2 user_project_wrapper_0.sg13g2_IOPadIOVdd_0.sg13g2_Clamp_N43N43D4R_0.gate user_project_wrapper_0.IOVDD2 sg13_hv_pmos ad=1.33p pd=7.38u as=1.33p ps=7.38u w=7u l=0.5u
X3492 user_project_wrapper_0.analog_io[35] a_278644_355624# user_project_wrapper_0.IOVDD4 user_project_wrapper_0.IOVDD4 sg13_hv_pmos ad=3.9294p pd=7.84u as=2.1312p ps=7.3u w=6.66u l=0.6u
X3493 user_project_wrapper_0.IOVSS1 a_135844_29676# user_project_wrapper_0.analog_io[10] user_project_wrapper_0.IOVSS1 sg13_hv_nmos ad=1.408p pd=5.04u as=2.596p ps=5.58u w=4.4u l=0.6u
X3494 a_83079_128838# a_79025_136081# user_project_wrapper_0.IOVSS1 user_project_wrapper_0.IOVSS1 sg13_lv_nmos ad=0.2516p pd=2.16u as=0.2516p ps=2.16u w=0.74u l=0.13u
X3495 analog_io[26] a_369296_278644# user_project_wrapper_0.IOVSS1 user_project_wrapper_0.IOVSS1 sg13_hv_nmos ad=2.596p pd=5.58u as=1.408p ps=5.04u w=4.4u l=0.6u
X3496 user_project_wrapper_0.analog_io[15] a_237844_41476# user_project_wrapper_0.IOVDD2 user_project_wrapper_0.IOVDD2 sg13_hv_pmos ad=3.9294p pd=7.84u as=2.1312p ps=7.3u w=6.66u l=0.6u
X3497 a_303385_39542# a_303715_35456# user_project_wrapper_0.IOVSS1 rppd l=20u w=1u
X3498 analog_io[22] a_355624_197044# IOVDD3 IOVDD3 sg13_hv_pmos ad=3.9294p pd=7.84u as=2.1312p ps=7.3u w=6.66u l=0.6u
X3499 a_355624_176644# IOVDD3 IOVDD3 rppd l=12.9u w=0.5u
X3500 a_202114_326125# a_205385_326221# user_project_wrapper_0.IOVSS1 user_project_wrapper_0.IOVSS1 sg13_lv_pmos ad=1.824p pd=9.98u as=1.824p ps=9.98u w=9.6u l=0.13u
X3501 a_186431_100948# user_project_wrapper_0.analog_io[13] user_project_wrapper_0.IOVSS1 user_project_wrapper_0.IOVSS1 sg13_lv_nmos ad=1.19p pd=7.68u as=1.19p ps=7.68u w=3.5u l=0.18u
X3502 VDD3 a_309516_194555# a_309917_194695# VDD3 sg13_lv_pmos ad=0.19p pd=1.38u as=0.19p ps=1.38u w=1u l=0.7u
X3503 a_309917_199879# a_309516_194555# VDD3 VDD3 sg13_lv_pmos ad=0.19p pd=1.38u as=0.19p ps=1.38u w=1u l=0.7u
X3504 user_project_wrapper_0.IOVSS1 a_369296_237844# analog_io[23] user_project_wrapper_0.IOVSS1 sg13_hv_nmos ad=1.408p pd=5.04u as=2.596p ps=5.58u w=4.4u l=0.6u
X3505 user_project_wrapper_0.IOVSS1 a_301186_192011# a_301940_196388# user_project_wrapper_0.IOVSS1 sg13_lv_nmos ad=0.912p pd=5.18u as=1.632p ps=10.28u w=4.8u l=1.06u
X3506 user_project_wrapper_0.IOVSS1 a_213870_324142# user_project_wrapper_0.analog_io[35] user_project_wrapper_0.IOVSS1 sg13_lv_nmos ad=0.912p pd=5.18u as=0.912p ps=5.18u w=4.8u l=0.13u
X3507 VDD3 user_project_wrapper_0.sg13g2_IOPadVdd_0.sg13g2_RCClampResistor_0.p2 user_project_wrapper_0.sg13g2_IOPadVdd_0.sg13g2_RCClampInverter_noptap_0.out VDD3 sg13_hv_pmos ad=2.38p pd=14.68u as=1.33p ps=7.38u w=7u l=0.5u
X3508 user_project_wrapper_0.analog_io[0] user_project_wrapper_0.sg13g2_IOPadAnalog_8.padres user_project_wrapper_0.IOVSS1 rppd l=2u w=1u
X3509 IOVDD3 a_355624_237844# analog_io[23] IOVDD3 sg13_hv_pmos ad=2.1312p pd=7.3u as=3.9294p ps=7.84u w=6.66u l=0.6u
X3510 user_project_wrapper_0.analog_io[27] a_182931_326125# user_project_wrapper_0.IOVSS1 user_project_wrapper_0.IOVSS1 sg13_lv_nmos ad=0.912p pd=5.18u as=0.912p ps=5.18u w=4.8u l=0.13u
X3511 user_project_wrapper_0.IOVSS1 user_project_wrapper_0.IOVSS1 user_project_wrapper_0.IOVSS1 rppd l=0.5u w=0.5u
X3512 a_189858_327491# a_189756_328605# a_189756_327491# user_project_wrapper_0.IOVSS1 sg13_lv_nmos ad=0.19p pd=1.38u as=0.19p ps=1.38u w=1u l=0.13u
X3513 user_project_wrapper_0.sg13g2_IOPadIOVdd_1.sg13g2_Clamp_N43N43D4R_0.gate user_project_wrapper_0.sg13g2_IOPadIOVdd_1.sg13g2_RCClampResistor_0.p2 user_project_wrapper_0.IOVDD1 user_project_wrapper_0.IOVDD1 sg13_hv_pmos ad=1.33p pd=7.38u as=1.33p ps=7.38u w=7u l=0.5u
X3514 a_84598_130577# a_84288_130212# user_project_wrapper_0.VDD1 user_project_wrapper_0.VDD1 sg13_lv_pmos ad=0.2128p pd=1.5u as=0.3808p ps=2.92u w=1.12u l=0.13u
X3515 analog_io[20] a_355624_156244# IOVDD3 IOVDD3 sg13_hv_pmos ad=3.9294p pd=7.84u as=2.1312p ps=7.3u w=6.66u l=0.6u
X3516 user_project_wrapper_0.IOVDD4 user_project_wrapper_0.sg13g2_IOPadIOVdd_2.sg13g2_Clamp_N43N43D4R_0.gate user_project_wrapper_0.IOVSS1 user_project_wrapper_0.IOVSS1 sg13_hv_nmos ad=2.596p pd=5.58u as=1.408p ps=5.04u w=4.4u l=0.6u
X3517 user_project_wrapper_0.IOVSS1 a_194687_324142# user_project_wrapper_0.analog_io[30] user_project_wrapper_0.IOVSS1 sg13_lv_nmos ad=1.632p pd=10.28u as=0.912p ps=5.18u w=4.8u l=0.13u
X3518 user_project_wrapper_0.analog_io[29] a_156244_355624# user_project_wrapper_0.IOVDD4 user_project_wrapper_0.IOVDD4 sg13_hv_pmos ad=3.9294p pd=7.84u as=2.1312p ps=7.3u w=6.66u l=0.6u
X3519 a_35456_80635# a_39542_80965# user_project_wrapper_0.IOVSS1 rppd l=20u w=1u
X3520 user_project_wrapper_0.IOVSS1 user_project_wrapper_0.analog_io[10] dantenna l=1.26u w=27.78u
X3521 a_311846_195517# user_project_wrapper_0.sg13g2_IOPadAnalog_29.padres a_309917_194695# VDD3 sg13_lv_pmos ad=0.24415p pd=1.665u as=0.24415p ps=1.665u w=1.285u l=0.35u
X3522 user_project_wrapper_0.IOVSS1 a_29676_237844# user_project_wrapper_0.analog_io[6] user_project_wrapper_0.IOVSS1 sg13_hv_nmos ad=1.408p pd=5.04u as=2.596p ps=5.58u w=4.4u l=0.6u
X3523 a_300085_39542# a_299755_35456# user_project_wrapper_0.IOVSS1 rppd l=20u w=1u
X3524 analog_io[26] a_355624_278644# IOVDD3 IOVDD3 sg13_hv_pmos ad=3.9294p pd=7.84u as=2.1312p ps=7.3u w=6.66u l=0.6u
X3525 VDD3 a_296625_189595# a_296731_189665# VDD3 sg13_lv_pmos ad=0.2603p pd=1.75u as=0.2603p ps=1.75u w=1.37u l=0.35u
X3526 user_project_wrapper_0.IOVSS1 a_208855_324776# a_211321_324119# user_project_wrapper_0.IOVSS1 sg13_lv_nmos ad=0.34p pd=2.68u as=0.34p ps=2.68u w=1u l=0.65u
X3527 user_project_wrapper_0.IOVDD1 a_41476_217444# user_project_wrapper_0.analog_io[5] user_project_wrapper_0.IOVDD1 sg13_hv_pmos ad=2.1312p pd=7.3u as=3.9294p ps=7.84u w=6.66u l=0.6u
X3528 user_project_wrapper_0.VDD1 user_project_wrapper_0.sg13g2_IOPadVdd_2.sg13g2_RCClampInverter_noptap_0.out user_project_wrapper_0.IOVSS1 user_project_wrapper_0.IOVSS1 sg13_hv_nmos ad=2.596p pd=5.58u as=2.068p ps=9.74u w=4.4u l=0.6u
X3529 user_project_wrapper_0.analog_io[1] a_41476_135844# user_project_wrapper_0.IOVDD1 user_project_wrapper_0.IOVDD1 sg13_hv_pmos ad=3.9294p pd=7.84u as=2.1312p ps=7.3u w=6.66u l=0.6u
X3530 a_189756_328605# user_project_wrapper_0.IOVSS1 user_project_wrapper_0.IOVSS1 w_188704_327938# sg13_lv_pmos ad=0.38p pd=2.38u as=0.68p ps=4.68u w=2u l=0.13u
X3531 a_309917_199879# a_309516_194555# VDD3 VDD3 sg13_lv_pmos ad=0.19p pd=1.38u as=0.19p ps=1.38u w=1u l=0.7u
X3532 user_project_wrapper_0.IOVSS1 user_project_wrapper_0.sg13g2_IOPadIn$1_0.sg13g2_LevelDown_noptap$1_0.sg13g2_SecondaryProtection$1$1_0.core dantenna l=0.64u w=3.1u
X3533 user_project_wrapper_0.IOVSS1 user_project_wrapper_0.sg13g2_IOPadVdd_2.sg13g2_RCClampInverter_noptap_0.out user_project_wrapper_0.VDD1 user_project_wrapper_0.IOVSS1 sg13_hv_nmos ad=1.408p pd=5.04u as=2.596p ps=5.58u w=4.4u l=0.6u
X3534 QDLL_TOP_0.VOUT a_271172_100118# user_project_wrapper_0.IOVSS1 user_project_wrapper_0.IOVSS1 sg13_lv_nmos ad=0.1406p pd=1.12u as=0.2516p ps=2.16u w=0.74u l=0.13u
X3535 a_301186_192011# a_314697_196700# VDD3 VDD3 sg13_lv_pmos ad=1.14p pd=6.38u as=1.14p ps=6.38u w=6u l=2.5u
X3536 a_85977_125209# a_84332_125209# a_85875_125209# user_project_wrapper_0.VDD1 sg13_lv_pmos ad=0.2128p pd=1.5u as=0.2128p ps=1.5u w=1.12u l=0.13u
X3537 a_117805_39542# a_117475_35456# user_project_wrapper_0.IOVSS1 rppd l=20u w=1u
X3538 a_309917_194695# a_309516_194555# VDD3 VDD3 sg13_lv_pmos ad=0.19p pd=1.38u as=0.19p ps=1.38u w=1u l=0.7u
X3539 a_360372_76345# a_364458_76015# user_project_wrapper_0.IOVSS1 rppd l=20u w=1u
X3540 user_project_wrapper_0.VDD1 a_78824_124371# a_78824_124371# user_project_wrapper_0.VDD1 sg13_lv_pmos ad=1.7p pd=10.68u as=0.95p ps=5.38u w=5u l=0.15u
X3541 user_project_wrapper_0.IOVDD1 a_41476_115444# user_project_wrapper_0.analog_io[0] user_project_wrapper_0.IOVDD1 sg13_hv_pmos ad=2.1312p pd=7.3u as=3.9294p ps=7.84u w=6.66u l=0.6u
X3542 analog_io[23] IOVDD3 dpantenna l=27.78u w=1.26u
X3543 user_project_wrapper_0.IOVSS1 a_194687_324142# user_project_wrapper_0.analog_io[30] user_project_wrapper_0.IOVSS1 sg13_lv_pmos ad=1.824p pd=9.98u as=1.824p ps=9.98u w=9.6u l=0.13u
X3544 a_309917_199879# a_309516_194555# VDD3 VDD3 sg13_lv_pmos ad=0.19p pd=1.38u as=0.19p ps=1.38u w=1u l=0.7u
X3545 IOVDD3 user_project_wrapper_0.sg13g2_IOPadIOVdd_3.sg13g2_RCClampResistor_0.p2 user_project_wrapper_0.sg13g2_IOPadIOVdd_3.sg13g2_Clamp_N43N43D4R_0.gate IOVDD3 sg13_hv_pmos ad=1.33p pd=7.38u as=1.33p ps=7.38u w=7u l=0.5u
X3546 user_project_wrapper_0.IOVSS1 a_213870_324142# user_project_wrapper_0.analog_io[35] user_project_wrapper_0.IOVSS1 sg13_lv_nmos ad=0.912p pd=5.18u as=0.912p ps=5.18u w=4.8u l=0.13u
X3547 user_project_wrapper_0.IOVSS1 user_project_wrapper_0.sg13g2_IOPadIOVdd_2.sg13g2_Clamp_N43N43D4R_0.gate user_project_wrapper_0.IOVDD4 user_project_wrapper_0.IOVSS1 sg13_hv_nmos ad=1.408p pd=5.04u as=2.596p ps=5.58u w=4.4u l=0.6u
X3548 user_project_wrapper_0.sg13g2_IOPadAnalog_30.padres user_project_wrapper_0.IOVDD2 dpantenna l=0.64u w=4.98u
X3549 user_project_wrapper_0.sg13g2_IOPadVdd_1.sg13g2_RCClampInverter_noptap_0.out user_project_wrapper_0.sg13g2_IOPadVdd_1.sg13g2_RCClampResistor_0.p2 user_project_wrapper_0.VDD2 user_project_wrapper_0.VDD2 sg13_hv_pmos ad=1.33p pd=7.38u as=1.33p ps=7.38u w=7u l=0.5u
X3550 user_project_wrapper_0.IOVSS1 user_project_wrapper_0.sg13g2_IOPadVdd_1.sg13g2_RCClampResistor_0.p2 user_project_wrapper_0.sg13g2_IOPadVdd_1.sg13g2_RCClampInverter_noptap_0.out user_project_wrapper_0.IOVSS1 sg13_hv_nmos ad=1.71p pd=9.38u as=1.71p ps=9.38u w=9u l=0.5u
X3551 user_project_wrapper_0.IOVSS1 a_194687_324142# user_project_wrapper_0.analog_io[30] user_project_wrapper_0.IOVSS1 sg13_lv_pmos ad=1.824p pd=9.98u as=1.824p ps=9.98u w=9.6u l=0.13u
X3552 a_296731_189665# a_296625_189595# VDD3 VDD3 sg13_lv_pmos ad=0.2603p pd=1.75u as=0.2603p ps=1.75u w=1.37u l=0.35u
X3553 user_project_wrapper_0.IOVSS1 user_project_wrapper_0.sg13g2_IOPadVdd_2.sg13g2_RCClampInverter_noptap_0.out user_project_wrapper_0.VDD1 user_project_wrapper_0.IOVSS1 sg13_hv_nmos ad=1.408p pd=5.04u as=2.596p ps=5.58u w=4.4u l=0.6u
X3554 QDLL_TOP_0.CPIN a_191975_108410# user_project_wrapper_0.IOVSS1 rppd l=10u w=1u
X3555 VDD3 a_296625_208423# a_296731_208493# VDD3 sg13_lv_pmos ad=0.2603p pd=1.75u as=0.2603p ps=1.75u w=1.37u l=0.35u
X3556 user_project_wrapper_0.analog_io[5] a_41476_217444# user_project_wrapper_0.IOVDD1 user_project_wrapper_0.IOVDD1 sg13_hv_pmos ad=3.9294p pd=7.84u as=2.1312p ps=7.3u w=6.66u l=0.6u
X3557 user_project_wrapper_0.IOVSS1 QDLL_TOP_0.VOUT a_187914_101343# user_project_wrapper_0.IOVSS1 sg13_lv_nmos ad=79.8f pd=0.8u as=0.1428p ps=1.52u w=0.42u l=0.13u
X3558 IOVDD3 a_355624_156244# analog_io[20] IOVDD3 sg13_hv_pmos ad=3.1302p pd=14.26u as=3.9294p ps=7.84u w=6.66u l=0.6u
X3559 user_project_wrapper_0.IOVDD2 user_project_wrapper_0.sg13g2_IOPadIOVdd_0.sg13g2_RCClampResistor_0.p2 user_project_wrapper_0.sg13g2_IOPadIOVdd_0.sg13g2_Clamp_N43N43D4R_0.gate user_project_wrapper_0.IOVDD2 sg13_hv_pmos ad=1.33p pd=7.38u as=1.33p ps=7.38u w=7u l=0.5u
X3560 user_project_wrapper_0.IOVDD4 a_278644_355624# user_project_wrapper_0.analog_io[35] user_project_wrapper_0.IOVDD4 sg13_hv_pmos ad=2.1312p pd=7.3u as=3.9294p ps=7.84u w=6.66u l=0.6u
X3561 a_360372_302725# a_364458_302395# user_project_wrapper_0.IOVSS1 rppd l=20u w=1u
X3562 user_project_wrapper_0.sg13g2_IOPadVdd_1.sg13g2_RCClampInverter_noptap_0.out user_project_wrapper_0.sg13g2_IOPadVdd_1.sg13g2_RCClampResistor_0.p2 user_project_wrapper_0.VDD2 user_project_wrapper_0.VDD2 sg13_hv_pmos ad=1.33p pd=7.38u as=1.33p ps=7.38u w=7u l=0.5u
X3563 user_project_wrapper_0.VDD2 a_114175_35456# user_project_wrapper_0.IOVSS1 rppd l=20u w=1u
X3564 VDD3 user_project_wrapper_0.sg13g2_IOPadVdd_0.sg13g2_RCClampInverter_noptap_0.out user_project_wrapper_0.IOVSS1 user_project_wrapper_0.IOVSS1 sg13_hv_nmos ad=2.596p pd=5.58u as=1.408p ps=5.04u w=4.4u l=0.6u
X3565 user_project_wrapper_0.sg13g2_IOPadAnalog_1.padres analog_io[19] user_project_wrapper_0.IOVSS1 rppd l=2u w=1u
X3566 a_309917_199879# a_309516_194555# VDD3 VDD3 sg13_lv_pmos ad=0.19p pd=1.38u as=0.19p ps=1.38u w=1u l=0.7u
X3567 a_211084_330987# a_210051_330987# user_project_wrapper_0.IOVSS1 rhigh l=4u w=0.5u
X3568 user_project_wrapper_0.analog_io[16] a_258244_41476# user_project_wrapper_0.IOVDD2 user_project_wrapper_0.IOVDD2 sg13_hv_pmos ad=3.9294p pd=7.84u as=2.1312p ps=7.3u w=6.66u l=0.6u
X3569 user_project_wrapper_0.IOVSS1 a_189729_101343# a_190389_101343# user_project_wrapper_0.IOVSS1 sg13_lv_nmos ad=0.2516p pd=2.16u as=0.1443p ps=1.13u w=0.74u l=0.13u
X3570 a_191438_329719# TOP_ROILIFNEURON_0.MEM user_project_wrapper_0.IOVSS1 rppd l=0.5u w=0.5u
X3571 user_project_wrapper_0.IOVSS1 a_213870_324142# user_project_wrapper_0.analog_io[35] user_project_wrapper_0.IOVSS1 sg13_lv_pmos ad=1.824p pd=9.98u as=1.824p ps=9.98u w=9.6u l=0.13u
X3572 user_project_wrapper_0.sg13g2_IOPadIOVdd_1.sg13g2_Clamp_N43N43D4R_0.gate user_project_wrapper_0.sg13g2_IOPadIOVdd_1.sg13g2_RCClampResistor_0.p2 user_project_wrapper_0.IOVDD1 user_project_wrapper_0.IOVDD1 sg13_hv_pmos ad=1.33p pd=7.38u as=1.33p ps=7.38u w=7u l=0.5u
X3573 user_project_wrapper_0.IOVDD2 user_project_wrapper_0.sg13g2_IOPadIOVdd_0.sg13g2_RCClampResistor_0.p2 user_project_wrapper_0.sg13g2_IOPadIOVdd_0.sg13g2_Clamp_N43N43D4R_0.gate user_project_wrapper_0.IOVDD2 sg13_hv_pmos ad=1.33p pd=7.38u as=1.33p ps=7.38u w=7u l=0.5u
X3574 user_project_wrapper_0.IOVSS1 user_project_wrapper_0.sg13g2_IOPadIOVdd_1.sg13g2_Clamp_N43N43D4R_0.gate user_project_wrapper_0.IOVDD1 user_project_wrapper_0.IOVSS1 sg13_hv_nmos ad=1.408p pd=5.04u as=2.596p ps=5.58u w=4.4u l=0.6u
X3575 user_project_wrapper_0.IOVSS1 a_115444_369296# user_project_wrapper_0.analog_io[27] user_project_wrapper_0.IOVSS1 sg13_hv_nmos ad=1.408p pd=5.04u as=2.596p ps=5.58u w=4.4u l=0.6u
X3576 user_project_wrapper_0.IOVSS1 user_project_wrapper_0.sg13g2_IOPadVdd_3.sg13g2_RCClampResistor_0.p2 user_project_wrapper_0.sg13g2_IOPadVdd_3.sg13g2_RCClampInverter_noptap_0.out user_project_wrapper_0.IOVSS1 sg13_hv_pmos ad=1.33p pd=7.38u as=1.33p ps=7.38u w=7u l=0.5u
X3577 user_project_wrapper_0.IOVSS1 user_project_wrapper_0.sg13g2_IOPadVdd_3.sg13g2_RCClampResistor_0.p2 user_project_wrapper_0.IOVSS1 user_project_wrapper_0.IOVSS1 sg13_hv_nmos ad=1.71p pd=9.38u as=0 ps=0 w=9u l=9.5u
X3578 user_project_wrapper_0.IOVSS1 a_369296_115444# analog_io[18] user_project_wrapper_0.IOVSS1 sg13_hv_nmos ad=1.408p pd=5.04u as=2.596p ps=5.58u w=4.4u l=0.6u
X3579 user_project_wrapper_0.IOVDD1 a_41476_135844# user_project_wrapper_0.analog_io[1] user_project_wrapper_0.IOVDD1 sg13_hv_pmos ad=3.1302p pd=14.26u as=3.9294p ps=7.84u w=6.66u l=0.6u
X3580 user_project_wrapper_0.IOVSS1 a_213870_324142# user_project_wrapper_0.analog_io[35] user_project_wrapper_0.IOVSS1 sg13_lv_pmos ad=1.824p pd=9.98u as=1.824p ps=9.98u w=9.6u l=0.13u
X3581 user_project_wrapper_0.IOVSS1 user_project_wrapper_0.analog_io[30] dantenna l=1.26u w=27.78u
X3582 VDD3 a_309516_194555# a_309516_194555# VDD3 sg13_lv_pmos ad=0.19p pd=1.38u as=0.19p ps=1.38u w=1u l=0.7u
X3583 user_project_wrapper_0.analog_io[33] a_237844_369296# user_project_wrapper_0.IOVSS1 user_project_wrapper_0.IOVSS1 sg13_hv_nmos ad=2.596p pd=5.58u as=1.408p ps=5.04u w=4.4u l=0.6u
X3584 user_project_wrapper_0.IOVSS1 a_208171_324119# a_208103_324155# user_project_wrapper_0.IOVSS1 sg13_lv_nmos ad=0.19p pd=1.38u as=0.34p ps=2.68u w=1u l=0.13u
X3585 analog_io[23] IOVDD3 dpantenna l=27.78u w=1.26u
X3586 user_project_wrapper_0.IOVSS1 user_project_wrapper_0.sg13g2_IOPadIOVdd_1.sg13g2_Clamp_N43N43D4R_0.gate user_project_wrapper_0.IOVDD1 user_project_wrapper_0.IOVSS1 sg13_hv_nmos ad=1.408p pd=5.04u as=2.596p ps=5.58u w=4.4u l=0.6u
X3587 user_project_wrapper_0.analog_io[27] user_project_wrapper_0.IOVDD4 dpantenna l=1.26u w=27.78u
X3588 user_project_wrapper_0.IOVSS1 user_project_wrapper_0.IOVSS1 user_project_wrapper_0.IOVSS1 rhigh l=0.96u w=0.5u
X3589 user_project_wrapper_0.analog_io[35] a_213870_324142# user_project_wrapper_0.IOVSS1 user_project_wrapper_0.IOVSS1 sg13_lv_nmos ad=0.912p pd=5.18u as=0.912p ps=5.18u w=4.8u l=0.13u
X3590 a_208939_329719# user_project_wrapper_0.IOVSS1 user_project_wrapper_0.IOVSS1 w_207883_330166# sg13_lv_pmos ad=0.38p pd=2.38u as=0.68p ps=4.68u w=2u l=0.13u
X3591 user_project_wrapper_0.VDD2 user_project_wrapper_0.sg13g2_IOPadVdd_1.sg13g2_RCClampInverter_noptap_0.out user_project_wrapper_0.IOVSS1 user_project_wrapper_0.IOVSS1 sg13_hv_nmos ad=2.596p pd=5.58u as=1.408p ps=5.04u w=4.4u l=0.6u
X3592 analog_io[20] a_355624_156244# IOVDD3 IOVDD3 sg13_hv_pmos ad=3.9294p pd=7.84u as=2.1312p ps=7.3u w=6.66u l=0.6u
X3593 VDD3 user_project_wrapper_0.sg13g2_IOPadVdd_0.sg13g2_RCClampInverter_noptap_0.out user_project_wrapper_0.IOVSS1 user_project_wrapper_0.IOVSS1 sg13_hv_nmos ad=2.596p pd=5.58u as=1.408p ps=5.04u w=4.4u l=0.6u
X3594 user_project_wrapper_0.IOVSS1 a_156244_369296# user_project_wrapper_0.analog_io[29] user_project_wrapper_0.IOVSS1 sg13_hv_nmos ad=1.408p pd=5.04u as=2.596p ps=5.58u w=4.4u l=0.6u
X3595 user_project_wrapper_0.IOVDD4 user_project_wrapper_0.sg13g2_IOPadIOVdd_2.sg13g2_Clamp_N43N43D4R_0.gate user_project_wrapper_0.IOVSS1 user_project_wrapper_0.IOVSS1 sg13_hv_nmos ad=2.596p pd=5.58u as=1.408p ps=5.04u w=4.4u l=0.6u
X3596 user_project_wrapper_0.VDD1 user_project_wrapper_0.sg13g2_IOPadVdd_2.sg13g2_RCClampInverter_noptap_0.out user_project_wrapper_0.IOVSS1 user_project_wrapper_0.IOVSS1 sg13_hv_nmos ad=2.596p pd=5.58u as=1.408p ps=5.04u w=4.4u l=0.6u
X3597 a_296731_189665# a_301186_192011# user_project_wrapper_0.IOVSS1 user_project_wrapper_0.IOVSS1 sg13_lv_nmos ad=0.912p pd=5.18u as=0.912p ps=5.18u w=4.8u l=1.06u
X3598 user_project_wrapper_0.IOVSS1 a_369296_197044# analog_io[22] user_project_wrapper_0.IOVSS1 sg13_hv_nmos ad=1.408p pd=5.04u as=2.596p ps=5.58u w=4.4u l=0.6u
X3599 user_project_wrapper_0.IOVSS1 a_202114_326125# user_project_wrapper_0.analog_io[32] user_project_wrapper_0.IOVSS1 sg13_lv_nmos ad=0.912p pd=5.18u as=0.912p ps=5.18u w=4.8u l=0.13u
X3600 user_project_wrapper_0.VDD2 user_project_wrapper_0.sg13g2_IOPadVdd_1.sg13g2_RCClampResistor_0.p2 user_project_wrapper_0.sg13g2_IOPadVdd_1.sg13g2_RCClampInverter_noptap_0.out user_project_wrapper_0.VDD2 sg13_hv_pmos ad=1.33p pd=7.38u as=1.33p ps=7.38u w=7u l=0.5u
X3601 IOVDD3 a_355624_115444# analog_io[18] IOVDD3 sg13_hv_pmos ad=2.1312p pd=7.3u as=3.9294p ps=7.84u w=6.66u l=0.6u
X3602 user_project_wrapper_0.IOVSS1 user_project_wrapper_0.sg13g2_IOPadIOVdd_3.sg13g2_Clamp_N43N43D4R_0.gate IOVDD3 user_project_wrapper_0.IOVSS1 sg13_hv_nmos ad=1.408p pd=5.04u as=2.596p ps=5.58u w=4.4u l=0.6u
X3603 IOVDD3 user_project_wrapper_0.sg13g2_IOPadIOVdd_3.sg13g2_RCClampResistor_0.p2 user_project_wrapper_0.sg13g2_IOPadIOVdd_3.sg13g2_Clamp_N43N43D4R_0.gate IOVDD3 sg13_hv_pmos ad=1.33p pd=7.38u as=1.33p ps=7.38u w=7u l=0.5u
X3604 a_189184_328605# user_project_wrapper_0.IOVSS1 user_project_wrapper_0.IOVSS1 w_188704_327938# sg13_lv_pmos ad=0.38p pd=2.38u as=0.68p ps=4.68u w=2u l=0.13u
X3605 user_project_wrapper_0.sg13g2_IOPadAnalog_18.padres user_project_wrapper_0.IOVDD4 dpantenna l=0.64u w=4.98u
X3606 analog_io[18] a_369296_115444# user_project_wrapper_0.IOVSS1 user_project_wrapper_0.IOVSS1 sg13_hv_nmos ad=2.596p pd=5.58u as=1.408p ps=5.04u w=4.4u l=0.6u
X3607 user_project_wrapper_0.IOVSS1 a_213870_324142# user_project_wrapper_0.analog_io[35] user_project_wrapper_0.IOVSS1 sg13_lv_pmos ad=1.824p pd=9.98u as=1.824p ps=9.98u w=9.6u l=0.13u
X3608 analog_io[25] a_355624_258244# IOVDD3 IOVDD3 sg13_hv_pmos ad=3.9294p pd=7.84u as=2.1312p ps=7.3u w=6.66u l=0.6u
X3609 IOVDD3 a_355624_197044# analog_io[22] IOVDD3 sg13_hv_pmos ad=2.1312p pd=7.3u as=3.9294p ps=7.84u w=6.66u l=0.6u
X3610 a_296731_208493# a_296625_208423# VDD3 VDD3 sg13_lv_pmos ad=0.2603p pd=1.75u as=0.4658p ps=3.42u w=1.37u l=0.35u
X3611 user_project_wrapper_0.sg13g2_IOPadVdd_1.sg13g2_RCClampInverter_noptap_0.out user_project_wrapper_0.sg13g2_IOPadVdd_1.sg13g2_RCClampResistor_0.p2 user_project_wrapper_0.VDD2 user_project_wrapper_0.VDD2 sg13_hv_pmos ad=1.33p pd=7.38u as=2.38p ps=14.68u w=7u l=0.5u
X3612 user_project_wrapper_0.IOVSS1 user_project_wrapper_0.sg13g2_IOPadIOVdd_1.sg13g2_Clamp_N43N43D4R_0.gate user_project_wrapper_0.IOVDD1 user_project_wrapper_0.IOVSS1 sg13_hv_nmos ad=1.408p pd=5.04u as=2.596p ps=5.58u w=4.4u l=0.6u
X3613 user_project_wrapper_0.IOVSS1 a_194687_324142# user_project_wrapper_0.analog_io[30] user_project_wrapper_0.IOVSS1 sg13_lv_nmos ad=0.912p pd=5.18u as=0.912p ps=5.18u w=4.8u l=0.13u
X3614 user_project_wrapper_0.IOVDD2 user_project_wrapper_0.sg13g2_IOPadIOVdd_0.sg13g2_Clamp_N43N43D4R_0.gate user_project_wrapper_0.IOVSS1 user_project_wrapper_0.IOVSS1 sg13_hv_nmos ad=2.596p pd=5.58u as=1.408p ps=5.04u w=4.4u l=0.6u
X3615 IOVDD3 a_355624_217444# analog_io[23] IOVDD3 sg13_hv_pmos ad=2.1312p pd=7.3u as=3.9294p ps=7.84u w=6.66u l=0.6u
X3616 user_project_wrapper_0.IOVSS1 user_project_wrapper_0.sg13g2_IOPadIOVdd_2.sg13g2_Clamp_N43N43D4R_0.gate user_project_wrapper_0.IOVDD4 user_project_wrapper_0.IOVSS1 sg13_hv_nmos ad=1.408p pd=5.04u as=2.596p ps=5.58u w=4.4u l=0.6u
X3617 user_project_wrapper_0.IOVSS1 user_project_wrapper_0.sg13g2_IOPadAnalog_17.padres a_189286_329719# user_project_wrapper_0.IOVSS1 sg13_lv_nmos ad=0.34p pd=2.68u as=0.19p ps=1.38u w=1u l=0.13u
X3618 a_200038_338690# user_project_wrapper_0.sg13g2_IOPadIn$1_2.sg13g2_LevelDown_noptap$1_0.sg13g2_SecondaryProtection$1$1_0.core user_project_wrapper_0.IOVSS1 user_project_wrapper_0.IOVSS1 sg13_hv_pmos ad=1.581p pd=9.98u as=1.581p ps=9.98u w=4.65u l=0.45u
X3619 user_project_wrapper_0.IOVSS1 user_project_wrapper_0.sg13g2_IOPadIOVdd_2.sg13g2_Clamp_N43N43D4R_0.gate user_project_wrapper_0.IOVDD4 user_project_wrapper_0.IOVSS1 sg13_hv_nmos ad=1.408p pd=5.04u as=2.596p ps=5.58u w=4.4u l=0.6u
X3620 a_309917_194695# a_309516_194555# VDD3 VDD3 sg13_lv_pmos ad=0.19p pd=1.38u as=0.19p ps=1.38u w=1u l=0.7u
X3621 user_project_wrapper_0.analog_io[33] a_237844_355624# user_project_wrapper_0.IOVDD4 user_project_wrapper_0.IOVDD4 sg13_hv_pmos ad=3.9294p pd=7.84u as=2.1312p ps=7.3u w=6.66u l=0.6u
X3622 user_project_wrapper_0.IOVDD2 user_project_wrapper_0.sg13g2_IOPadIOVdd_0.sg13g2_Clamp_N43N43D4R_0.gate user_project_wrapper_0.IOVSS1 user_project_wrapper_0.IOVSS1 sg13_hv_nmos ad=2.596p pd=5.58u as=1.408p ps=5.04u w=4.4u l=0.6u
X3623 user_project_wrapper_0.IOVSS1 user_project_wrapper_0.IOVSS1 user_project_wrapper_0.IOVSS1 rppd l=0.5u w=0.5u
X3624 user_project_wrapper_0.IOVSS1 user_project_wrapper_0.sg13g2_IOPadIOVdd_2.sg13g2_Clamp_N43N43D4R_0.gate user_project_wrapper_0.IOVDD4 user_project_wrapper_0.IOVSS1 sg13_hv_nmos ad=1.408p pd=5.04u as=2.596p ps=5.58u w=4.4u l=0.6u
X3625 a_301940_196388# a_301940_196388# VDD3 VDD3 sg13_lv_pmos ad=0.697p pd=4.78u as=0.3895p ps=2.43u w=2.05u l=0.35u
X3626 QDLL_TOP_0.VDD a_190389_99046# user_project_wrapper_0.analog_io[14] QDLL_TOP_0.VDD sg13_lv_pmos ad=0.2128p pd=1.5u as=0.2128p ps=1.5u w=1.12u l=0.13u
X3627 analog_io[25] a_355624_258244# IOVDD3 IOVDD3 sg13_hv_pmos ad=3.9294p pd=7.84u as=2.1312p ps=7.3u w=6.66u l=0.6u
X3628 user_project_wrapper_0.IOVSS1 user_project_wrapper_0.sg13g2_IOPadAnalog_13.padres dantenna l=0.64u w=3.1u
X3629 user_project_wrapper_0.IOVDD2 user_project_wrapper_0.sg13g2_IOPadIOVdd_0.sg13g2_RCClampResistor_0.p2 user_project_wrapper_0.sg13g2_IOPadIOVdd_0.sg13g2_Clamp_N43N43D4R_0.gate user_project_wrapper_0.IOVDD2 sg13_hv_pmos ad=1.33p pd=7.38u as=1.33p ps=7.38u w=7u l=0.5u
X3630 a_77995_364458# a_77665_360372# user_project_wrapper_0.IOVSS1 rppd l=20u w=1u
X3631 user_project_wrapper_0.IOVSS1 a_156244_29676# user_project_wrapper_0.analog_io[11] user_project_wrapper_0.IOVSS1 sg13_hv_nmos ad=1.408p pd=5.04u as=2.596p ps=5.58u w=4.4u l=0.6u
X3632 VDD3 a_296625_189595# a_296731_189665# VDD3 sg13_lv_pmos ad=0.4658p pd=3.42u as=0.2603p ps=1.75u w=1.37u l=0.35u
X3633 user_project_wrapper_0.IOVDD1 a_41476_217444# user_project_wrapper_0.analog_io[5] user_project_wrapper_0.IOVDD1 sg13_hv_pmos ad=2.1312p pd=7.3u as=3.9294p ps=7.84u w=6.66u l=0.6u
X3634 user_project_wrapper_0.VDD2 user_project_wrapper_0.sg13g2_IOPadVdd_1.sg13g2_RCClampInverter_noptap_0.out user_project_wrapper_0.IOVSS1 user_project_wrapper_0.IOVSS1 sg13_hv_nmos ad=2.596p pd=5.58u as=1.408p ps=5.04u w=4.4u l=0.6u
X3635 user_project_wrapper_0.IOVDD2 user_project_wrapper_0.sg13g2_IOPadIOVdd_0.sg13g2_Clamp_N43N43D4R_0.gate user_project_wrapper_0.IOVSS1 user_project_wrapper_0.IOVSS1 sg13_hv_nmos ad=2.596p pd=5.58u as=1.408p ps=5.04u w=4.4u l=0.6u
X3636 user_project_wrapper_0.analog_io[13] a_197044_41476# user_project_wrapper_0.IOVDD2 user_project_wrapper_0.IOVDD2 sg13_hv_pmos ad=3.9294p pd=7.84u as=2.1312p ps=7.3u w=6.66u l=0.6u
X3637 user_project_wrapper_0.IOVSS1 user_project_wrapper_0.sg13g2_IOPadVdd_3.sg13g2_RCClampResistor_0.p2 user_project_wrapper_0.sg13g2_IOPadVdd_3.sg13g2_RCClampInverter_noptap_0.out user_project_wrapper_0.IOVSS1 sg13_hv_pmos ad=1.33p pd=7.38u as=1.33p ps=7.38u w=7u l=0.5u
X3638 a_82826_124842# user_project_wrapper_0.sg13g2_IOPadIn$1_0.p2c user_project_wrapper_0.VDD1 user_project_wrapper_0.VDD1 sg13_lv_pmos ad=0.3808p pd=2.92u as=0.3808p ps=2.92u w=1.12u l=0.13u
X3639 user_project_wrapper_0.IOVSS1 a_213870_324142# user_project_wrapper_0.analog_io[35] user_project_wrapper_0.IOVSS1 sg13_lv_nmos ad=0.912p pd=5.18u as=0.912p ps=5.18u w=4.8u l=0.13u
X3640 user_project_wrapper_0.VDD1 user_project_wrapper_0.sg13g2_IOPadVdd_2.sg13g2_RCClampInverter_noptap_0.out user_project_wrapper_0.IOVSS1 user_project_wrapper_0.IOVSS1 sg13_hv_nmos ad=2.596p pd=5.58u as=1.408p ps=5.04u w=4.4u l=0.6u
X3641 user_project_wrapper_0.analog_io[1] a_41476_135844# user_project_wrapper_0.IOVDD1 user_project_wrapper_0.IOVDD1 sg13_hv_pmos ad=3.9294p pd=7.84u as=3.1302p ps=14.26u w=6.66u l=0.6u
X3642 user_project_wrapper_0.IOVSS1 user_project_wrapper_0.analog_io[1] dantenna l=27.78u w=1.26u
X3643 user_project_wrapper_0.analog_io[27] a_182931_326125# user_project_wrapper_0.IOVSS1 user_project_wrapper_0.IOVSS1 sg13_lv_nmos ad=0.912p pd=5.18u as=0.912p ps=5.18u w=4.8u l=0.13u
X3644 user_project_wrapper_0.analog_io[35] a_278644_355624# user_project_wrapper_0.IOVDD4 user_project_wrapper_0.IOVDD4 sg13_hv_pmos ad=3.9294p pd=7.84u as=2.1312p ps=7.3u w=6.66u l=0.6u
X3645 analog_io[23] a_355624_217444# IOVDD3 IOVDD3 sg13_hv_pmos ad=3.9294p pd=7.84u as=2.1312p ps=7.3u w=6.66u l=0.6u
X3646 a_309917_199879# a_309516_194555# VDD3 VDD3 sg13_lv_pmos ad=0.19p pd=1.38u as=0.19p ps=1.38u w=1u l=0.7u
X3647 user_project_wrapper_0.analog_io[15] a_237844_29676# user_project_wrapper_0.IOVSS1 user_project_wrapper_0.IOVSS1 sg13_hv_nmos ad=2.596p pd=5.58u as=1.408p ps=5.04u w=4.4u l=0.6u
X3648 user_project_wrapper_0.IOVSS1 a_369296_115444# analog_io[18] user_project_wrapper_0.IOVSS1 sg13_hv_nmos ad=1.408p pd=5.04u as=2.596p ps=5.58u w=4.4u l=0.6u
X3649 a_296731_208493# a_296625_208423# VDD3 VDD3 sg13_lv_pmos ad=0.2603p pd=1.75u as=0.2603p ps=1.75u w=1.37u l=0.35u
X3650 user_project_wrapper_0.IOVDD1 a_41476_258244# user_project_wrapper_0.analog_io[7] user_project_wrapper_0.IOVDD1 sg13_hv_pmos ad=2.1312p pd=7.3u as=3.9294p ps=7.84u w=6.66u l=0.6u
X3651 user_project_wrapper_0.IOVSS1 user_project_wrapper_0.analog_io[13] dantenna l=1.26u w=27.78u
X3652 user_project_wrapper_0.IOVSS1 a_194687_324142# user_project_wrapper_0.analog_io[30] user_project_wrapper_0.IOVSS1 sg13_lv_nmos ad=0.912p pd=5.18u as=0.912p ps=5.18u w=4.8u l=0.13u
X3653 VDD3 user_project_wrapper_0.sg13g2_IOPadVdd_0.sg13g2_RCClampInverter_noptap_0.out user_project_wrapper_0.IOVSS1 user_project_wrapper_0.IOVSS1 sg13_hv_nmos ad=2.596p pd=5.58u as=2.068p ps=9.74u w=4.4u l=0.6u
X3654 user_project_wrapper_0.IOVSS1 user_project_wrapper_0.IOVDD4 dpantenna l=27.78u w=1.26u
X3655 VDD3 a_311108_179669# analog_io[20] user_project_wrapper_0.IOVSS1 sg13_lv_nmos ad=3.4p pd=20.68u as=3.4p ps=20.68u w=10u l=0.15u
X3656 VDD3 user_project_wrapper_0.sg13g2_IOPadVdd_0.sg13g2_RCClampInverter_noptap_0.out user_project_wrapper_0.IOVSS1 user_project_wrapper_0.IOVSS1 sg13_hv_nmos ad=2.596p pd=5.58u as=1.408p ps=5.04u w=4.4u l=0.6u
X3657 VDD3 a_309516_194555# a_309917_194695# VDD3 sg13_lv_pmos ad=0.19p pd=1.38u as=0.19p ps=1.38u w=1u l=0.7u
X3658 analog_io[22] a_355624_197044# IOVDD3 IOVDD3 sg13_hv_pmos ad=3.9294p pd=7.84u as=2.1312p ps=7.3u w=6.66u l=0.6u
X3659 a_307232_196607# a_296731_208493# a_309917_199879# VDD3 sg13_lv_pmos ad=0.24415p pd=1.665u as=0.24415p ps=1.665u w=1.285u l=0.35u
X3660 user_project_wrapper_0.analog_io[29] a_156244_355624# user_project_wrapper_0.IOVDD4 user_project_wrapper_0.IOVDD4 sg13_hv_pmos ad=3.9294p pd=7.84u as=2.1312p ps=7.3u w=6.66u l=0.6u
X3661 user_project_wrapper_0.IOVDD2 user_project_wrapper_0.sg13g2_IOPadIOVdd_0.sg13g2_Clamp_N43N43D4R_0.gate user_project_wrapper_0.IOVSS1 user_project_wrapper_0.IOVSS1 sg13_hv_nmos ad=2.596p pd=5.58u as=1.408p ps=5.04u w=4.4u l=0.6u
X3662 IOVDD3 a_355624_135844# analog_io[19] IOVDD3 sg13_hv_pmos ad=2.1312p pd=7.3u as=3.9294p ps=7.84u w=6.66u l=0.6u
X3663 user_project_wrapper_0.IOVSS1 user_project_wrapper_0.IOVSS1 user_project_wrapper_0.IOVSS1 rppd l=0.5u w=0.5u
X3664 a_271172_100118# a_270512_100118# user_project_wrapper_0.IOVSS1 user_project_wrapper_0.IOVSS1 sg13_lv_nmos ad=0.1443p pd=1.13u as=0.1406p ps=1.12u w=0.74u l=0.13u
X3665 a_87832_241383# user_project_wrapper_0.sg13g2_IOPadOut4mA$1_1.c2p user_project_wrapper_0.IOVSS1 user_project_wrapper_0.IOVSS1 sg13_lv_nmos ad=0.2516p pd=2.16u as=0.2516p ps=2.16u w=0.74u l=0.13u
X3666 a_213870_324142# a_213462_327536# user_project_wrapper_0.IOVSS1 user_project_wrapper_0.IOVSS1 sg13_lv_nmos ad=0.912p pd=5.18u as=1.632p ps=10.28u w=4.8u l=0.13u
X3667 user_project_wrapper_0.analog_io[4] a_29676_197044# user_project_wrapper_0.IOVSS1 user_project_wrapper_0.IOVSS1 sg13_hv_nmos ad=2.596p pd=5.58u as=1.408p ps=5.04u w=4.4u l=0.6u
X3668 a_307232_196607# a_296731_189665# a_309917_194695# VDD3 sg13_lv_pmos ad=0.24415p pd=1.665u as=0.24415p ps=1.665u w=1.285u l=0.35u
X3669 user_project_wrapper_0.IOVDD2 user_project_wrapper_0.sg13g2_IOPadIOVdd_0.sg13g2_Clamp_N43N43D4R_0.gate user_project_wrapper_0.IOVSS1 user_project_wrapper_0.IOVSS1 sg13_hv_nmos ad=2.596p pd=5.58u as=1.408p ps=5.04u w=4.4u l=0.6u
X3670 user_project_wrapper_0.IOVDD2 user_project_wrapper_0.sg13g2_IOPadIOVdd_0.sg13g2_Clamp_N43N43D4R_0.gate user_project_wrapper_0.IOVSS1 user_project_wrapper_0.IOVSS1 sg13_hv_nmos ad=2.596p pd=5.58u as=1.408p ps=5.04u w=4.4u l=0.6u
X3671 a_296731_208493# a_296625_208423# VDD3 VDD3 sg13_lv_pmos ad=0.2603p pd=1.75u as=0.2603p ps=1.75u w=1.37u l=0.35u
X3672 user_project_wrapper_0.IOVSS1 user_project_wrapper_0.sg13g2_IOPadIOVdd_1.sg13g2_RCClampResistor_0.p2 user_project_wrapper_0.sg13g2_IOPadIOVdd_1.sg13g2_Clamp_N43N43D4R_0.gate user_project_wrapper_0.IOVSS1 sg13_hv_nmos ad=1.71p pd=9.38u as=1.71p ps=9.38u w=9u l=0.5u
X3673 IOVDD3 a_355624_237844# analog_io[23] IOVDD3 sg13_hv_pmos ad=2.1312p pd=7.3u as=3.9294p ps=7.84u w=6.66u l=0.6u
X3674 IOVDD3 a_355624_258244# analog_io[25] IOVDD3 sg13_hv_pmos ad=2.1312p pd=7.3u as=3.9294p ps=7.84u w=6.66u l=0.6u
X3675 user_project_wrapper_0.analog_io[13] a_197044_41476# user_project_wrapper_0.IOVDD2 user_project_wrapper_0.IOVDD2 sg13_hv_pmos ad=3.9294p pd=7.84u as=3.1302p ps=14.26u w=6.66u l=0.6u
X3676 user_project_wrapper_0.IOVDD1 user_project_wrapper_0.sg13g2_IOPadIOVdd_1.sg13g2_Clamp_N43N43D4R_0.gate user_project_wrapper_0.IOVSS1 user_project_wrapper_0.IOVSS1 sg13_hv_nmos ad=2.596p pd=5.58u as=1.408p ps=5.04u w=4.4u l=0.6u
X3677 user_project_wrapper_0.sg13g2_IOPadAnalog_6.padres user_project_wrapper_0.IOVDD2 dpantenna l=0.64u w=4.98u
X3678 user_project_wrapper_0.IOVSS1 a_213870_324142# user_project_wrapper_0.analog_io[35] user_project_wrapper_0.IOVSS1 sg13_lv_nmos ad=0.912p pd=5.18u as=0.912p ps=5.18u w=4.8u l=0.13u
X3679 user_project_wrapper_0.IOVSS1 user_project_wrapper_0.IOVSS1 user_project_wrapper_0.IOVSS1 rppd l=0.5u w=0.5u
X3680 user_project_wrapper_0.IOVSS1 user_project_wrapper_0.sg13g2_IOPadVdd_0.sg13g2_RCClampInverter_noptap_0.out VDD3 user_project_wrapper_0.IOVSS1 sg13_hv_nmos ad=1.408p pd=5.04u as=2.596p ps=5.58u w=4.4u l=0.6u
X3681 user_project_wrapper_0.IOVSS1 user_project_wrapper_0.sg13g2_IOPadIOVdd_2.sg13g2_Clamp_N43N43D4R_0.gate user_project_wrapper_0.IOVDD4 user_project_wrapper_0.IOVSS1 sg13_hv_nmos ad=1.408p pd=5.04u as=2.596p ps=5.58u w=4.4u l=0.6u
X3682 a_296731_208493# a_301186_192011# user_project_wrapper_0.IOVSS1 user_project_wrapper_0.IOVSS1 sg13_lv_nmos ad=0.912p pd=5.18u as=0.912p ps=5.18u w=4.8u l=1.06u
X3683 VDD3 a_296625_208423# a_296731_208493# VDD3 sg13_lv_pmos ad=0.2603p pd=1.75u as=0.2603p ps=1.75u w=1.37u l=0.35u
X3684 user_project_wrapper_0.IOVSS1 user_project_wrapper_0.sg13g2_IOPadVdd_3.sg13g2_RCClampInverter_noptap_0.out user_project_wrapper_0.IOVSS1 user_project_wrapper_0.IOVSS1 sg13_hv_nmos ad=1.408p pd=5.04u as=0 ps=0 w=4.4u l=0.6u
X3685 IOVDD3 a_355624_217444# analog_io[23] IOVDD3 sg13_hv_pmos ad=2.1312p pd=7.3u as=3.9294p ps=7.84u w=6.66u l=0.6u
X3686 user_project_wrapper_0.IOVSS1 user_project_wrapper_0.sg13g2_IOPadAnalog_22.padres a_208469_325263# user_project_wrapper_0.IOVSS1 sg13_lv_nmos ad=0.34p pd=2.68u as=0.19p ps=1.38u w=1u l=0.13u
X3687 user_project_wrapper_0.IOVDD2 a_156244_41476# user_project_wrapper_0.analog_io[11] user_project_wrapper_0.IOVDD2 sg13_hv_pmos ad=2.1312p pd=7.3u as=3.9294p ps=7.84u w=6.66u l=0.6u
X3688 a_189858_326377# a_189756_327491# a_189756_326377# w_188704_326203# sg13_lv_pmos ad=0.38p pd=2.38u as=0.38p ps=2.38u w=2u l=0.13u
X3689 user_project_wrapper_0.IOVSS1 a_237844_369296# user_project_wrapper_0.analog_io[33] user_project_wrapper_0.IOVSS1 sg13_hv_nmos ad=1.408p pd=5.04u as=2.596p ps=5.58u w=4.4u l=0.6u
X3690 user_project_wrapper_0.analog_io[27] a_182931_326125# user_project_wrapper_0.IOVSS1 user_project_wrapper_0.IOVSS1 sg13_lv_pmos ad=1.824p pd=9.98u as=1.824p ps=9.98u w=9.6u l=0.13u
X3691 user_project_wrapper_0.IOVSS1 user_project_wrapper_0.sg13g2_IOPadVdd_1.sg13g2_RCClampInverter_noptap_0.out user_project_wrapper_0.VDD2 user_project_wrapper_0.IOVSS1 sg13_hv_nmos ad=1.408p pd=5.04u as=2.596p ps=5.58u w=4.4u l=0.6u
X3692 user_project_wrapper_0.IOVSS1 user_project_wrapper_0.sg13g2_IOPadIOVdd_1.sg13g2_RCClampResistor_0.p2 user_project_wrapper_0.sg13g2_IOPadIOVdd_1.sg13g2_Clamp_N43N43D4R_0.gate user_project_wrapper_0.IOVSS1 sg13_hv_nmos ad=1.71p pd=9.38u as=1.71p ps=9.38u w=9u l=0.5u
X3693 a_304196_200821# a_304090_197941# a_296625_208423# user_project_wrapper_0.IOVSS1 sg13_lv_nmos ad=0.646p pd=4.48u as=0.361p ps=2.28u w=1.9u l=0.16u
X3694 user_project_wrapper_0.sg13g2_IOPadIOVdd_3.sg13g2_RCClampResistor_0.p2 a_364458_305695# user_project_wrapper_0.IOVSS1 rppd l=20u w=1u
X3695 user_project_wrapper_0.analog_io[15] a_190389_101343# QDLL_TOP_0.VDD QDLL_TOP_0.VDD sg13_lv_pmos ad=0.2128p pd=1.5u as=0.2128p ps=1.5u w=1.12u l=0.13u
X3696 VDD3 a_309516_194555# a_309516_194555# VDD3 sg13_lv_pmos ad=0.19p pd=1.38u as=0.19p ps=1.38u w=1u l=0.7u
X3697 user_project_wrapper_0.IOVSS1 user_project_wrapper_0.sg13g2_IOPadVdd_1.sg13g2_RCClampInverter_noptap_0.out user_project_wrapper_0.VDD2 user_project_wrapper_0.IOVSS1 sg13_hv_nmos ad=1.408p pd=5.04u as=2.596p ps=5.58u w=4.4u l=0.6u
X3698 user_project_wrapper_0.IOVSS1 user_project_wrapper_0.sg13g2_IOPadIOVdd_1.sg13g2_Clamp_N43N43D4R_0.gate user_project_wrapper_0.IOVDD1 user_project_wrapper_0.IOVSS1 sg13_hv_nmos ad=1.408p pd=5.04u as=2.596p ps=5.58u w=4.4u l=0.6u
X3699 VDD3 a_296625_208423# a_296731_208493# VDD3 sg13_lv_pmos ad=0.2603p pd=1.75u as=0.2603p ps=1.75u w=1.37u l=0.35u
X3700 VDD3 a_311108_215937# analog_io[23] user_project_wrapper_0.IOVSS1 sg13_lv_nmos ad=3.4p pd=20.68u as=3.4p ps=20.68u w=10u l=0.15u
X3701 a_303715_364458# a_303385_360372# user_project_wrapper_0.IOVSS1 rppd l=20u w=1u
X3702 QDLL_TOP_0.VOUT a_271172_100118# user_project_wrapper_0.IOVSS1 user_project_wrapper_0.IOVSS1 sg13_lv_nmos ad=0.1406p pd=1.12u as=0.1406p ps=1.12u w=0.74u l=0.13u
X3703 user_project_wrapper_0.IOVDD1 a_41476_197044# user_project_wrapper_0.analog_io[4] user_project_wrapper_0.IOVDD1 sg13_hv_pmos ad=2.1312p pd=7.3u as=3.9294p ps=7.84u w=6.66u l=0.6u
X3704 user_project_wrapper_0.analog_io[29] a_156244_355624# user_project_wrapper_0.IOVDD4 user_project_wrapper_0.IOVDD4 sg13_hv_pmos ad=3.9294p pd=7.84u as=2.1312p ps=7.3u w=6.66u l=0.6u
X3705 user_project_wrapper_0.IOVSS1 a_194687_324142# user_project_wrapper_0.analog_io[30] user_project_wrapper_0.IOVSS1 sg13_lv_pmos ad=1.824p pd=9.98u as=1.824p ps=9.98u w=9.6u l=0.13u
X3706 user_project_wrapper_0.IOVSS1 user_project_wrapper_0.sg13g2_IOPadIOVdd_0.sg13g2_Clamp_N43N43D4R_0.gate user_project_wrapper_0.IOVDD2 user_project_wrapper_0.IOVSS1 sg13_hv_nmos ad=1.408p pd=5.04u as=2.596p ps=5.58u w=4.4u l=0.6u
X3707 a_296731_189665# a_301186_192011# user_project_wrapper_0.IOVSS1 user_project_wrapper_0.IOVSS1 sg13_lv_nmos ad=0.912p pd=5.18u as=0.912p ps=5.18u w=4.8u l=1.06u
X3708 a_79025_137844# a_78219_135283# a_79038_136536# user_project_wrapper_0.VDD1 sg13_lv_pmos ad=1.7p pd=10.68u as=0.95p ps=5.38u w=5u l=0.3u
X3709 user_project_wrapper_0.IOVSS1 user_project_wrapper_0.sg13g2_IOPadAnalog_16.padres dantenna l=3.1u w=0.64u
X3710 IOVDD3 a_355624_156244# analog_io[20] IOVDD3 sg13_hv_pmos ad=2.1312p pd=7.3u as=3.9294p ps=7.84u w=6.66u l=0.6u
X3711 VDD3 a_296625_208423# a_296731_208493# VDD3 sg13_lv_pmos ad=0.2603p pd=1.75u as=0.2603p ps=1.75u w=1.37u l=0.35u
X3712 analog_io[23] a_355624_217444# IOVDD3 IOVDD3 sg13_hv_pmos ad=3.9294p pd=7.84u as=2.1312p ps=7.3u w=6.66u l=0.6u
X3713 user_project_wrapper_0.IOVSS1 a_194193_328627# a_194279_327536# user_project_wrapper_0.IOVSS1 sg13_lv_nmos ad=0.912p pd=5.18u as=0.912p ps=5.18u w=4.8u l=0.13u
X3714 user_project_wrapper_0.VDD1 user_project_wrapper_0.sg13g2_IOPadVdd_2.sg13g2_RCClampInverter_noptap_0.out user_project_wrapper_0.IOVSS1 user_project_wrapper_0.IOVSS1 sg13_hv_nmos ad=2.596p pd=5.58u as=1.408p ps=5.04u w=4.4u l=0.6u
X3715 a_309917_199879# user_project_wrapper_0.sg13g2_IOPadAnalog_29.padres a_311846_195517# VDD3 sg13_lv_pmos ad=0.24415p pd=1.665u as=0.24415p ps=1.665u w=1.285u l=0.35u
X3716 a_189395_101343# a_189148_101407# user_project_wrapper_0.IOVSS1 user_project_wrapper_0.IOVSS1 sg13_lv_nmos ad=0.2516p pd=2.16u as=0.1405p ps=1.15u w=0.74u l=0.13u
X3717 user_project_wrapper_0.IOVSS1 a_202114_326125# user_project_wrapper_0.analog_io[32] user_project_wrapper_0.IOVSS1 sg13_lv_nmos ad=0.912p pd=5.18u as=0.912p ps=5.18u w=4.8u l=0.13u
X3718 IOVDD3 user_project_wrapper_0.sg13g2_IOPadIOVdd_3.sg13g2_Clamp_N43N43D4R_0.gate user_project_wrapper_0.IOVSS1 user_project_wrapper_0.IOVSS1 sg13_hv_nmos ad=2.596p pd=5.58u as=1.408p ps=5.04u w=4.4u l=0.6u
X3719 user_project_wrapper_0.analog_io[32] a_217444_369296# user_project_wrapper_0.IOVSS1 user_project_wrapper_0.IOVSS1 sg13_hv_nmos ad=2.596p pd=5.58u as=1.408p ps=5.04u w=4.4u l=0.6u
X3720 IOVDD3 user_project_wrapper_0.sg13g2_IOPadIOVdd_3.sg13g2_Clamp_N43N43D4R_0.gate user_project_wrapper_0.IOVSS1 user_project_wrapper_0.IOVSS1 sg13_hv_nmos ad=2.596p pd=5.58u as=1.408p ps=5.04u w=4.4u l=0.6u
X3721 user_project_wrapper_0.IOVSS1 a_213870_324142# user_project_wrapper_0.analog_io[35] user_project_wrapper_0.IOVSS1 sg13_lv_pmos ad=1.824p pd=9.98u as=1.824p ps=9.98u w=9.6u l=0.13u
X3722 user_project_wrapper_0.analog_io[28] a_135844_355624# user_project_wrapper_0.IOVDD4 user_project_wrapper_0.IOVDD4 sg13_hv_pmos ad=3.9294p pd=7.84u as=2.1312p ps=7.3u w=6.66u l=0.6u
X3723 user_project_wrapper_0.IOVSS1 user_project_wrapper_0.IOVSS1 user_project_wrapper_0.IOVSS1 rppd l=0.5u w=0.5u
X3724 analog_io[20] a_369296_156244# user_project_wrapper_0.IOVSS1 user_project_wrapper_0.IOVSS1 sg13_hv_nmos ad=2.596p pd=5.58u as=1.408p ps=5.04u w=4.4u l=0.6u
X3725 user_project_wrapper_0.IOVSS1 user_project_wrapper_0.sg13g2_IOPadVdd_1.sg13g2_RCClampInverter_noptap_0.out user_project_wrapper_0.VDD2 user_project_wrapper_0.IOVSS1 sg13_hv_nmos ad=1.408p pd=5.04u as=2.596p ps=5.58u w=4.4u l=0.6u
X3726 user_project_wrapper_0.IOVDD1 user_project_wrapper_0.sg13g2_IOPadIOVdd_1.sg13g2_Clamp_N43N43D4R_0.gate user_project_wrapper_0.IOVSS1 user_project_wrapper_0.IOVSS1 sg13_hv_nmos ad=2.596p pd=5.58u as=1.408p ps=5.04u w=4.4u l=0.6u
X3727 user_project_wrapper_0.IOVSS1 user_project_wrapper_0.IOVSS1 user_project_wrapper_0.IOVSS1 rhigh l=4u w=0.5u
X3728 a_190926_328605# a_189184_328605# a_190824_328605# w_188704_327938# sg13_lv_pmos ad=0.38p pd=2.38u as=0.38p ps=2.38u w=2u l=0.13u
X3729 user_project_wrapper_0.analog_io[10] a_135844_41476# user_project_wrapper_0.IOVDD2 user_project_wrapper_0.IOVDD2 sg13_hv_pmos ad=3.9294p pd=7.84u as=2.1312p ps=7.3u w=6.66u l=0.6u
X3730 a_296731_189665# a_301186_192011# user_project_wrapper_0.IOVSS1 user_project_wrapper_0.IOVSS1 sg13_lv_nmos ad=0.912p pd=5.18u as=0.912p ps=5.18u w=4.8u l=1.06u
X3731 user_project_wrapper_0.IOVDD4 a_278644_355624# user_project_wrapper_0.analog_io[35] user_project_wrapper_0.IOVDD4 sg13_hv_pmos ad=2.1312p pd=7.3u as=3.9294p ps=7.84u w=6.66u l=0.6u
X3732 user_project_wrapper_0.sg13g2_IOPadOut4mA$1_1.c2p a_86970_241383# user_project_wrapper_0.VDD1 user_project_wrapper_0.VDD1 sg13_lv_pmos ad=0.3808p pd=2.92u as=0.3808p ps=2.92u w=1.12u l=0.13u
X3733 user_project_wrapper_0.IOVDD4 a_115444_355624# user_project_wrapper_0.analog_io[27] user_project_wrapper_0.IOVDD4 sg13_hv_pmos ad=2.1312p pd=7.3u as=3.9294p ps=7.84u w=6.66u l=0.6u
X3734 user_project_wrapper_0.IOVDD2 user_project_wrapper_0.sg13g2_IOPadIOVdd_0.sg13g2_RCClampResistor_0.p2 user_project_wrapper_0.sg13g2_IOPadIOVdd_0.sg13g2_Clamp_N43N43D4R_0.gate user_project_wrapper_0.IOVDD2 sg13_hv_pmos ad=1.33p pd=7.38u as=1.33p ps=7.38u w=7u l=0.5u
X3735 user_project_wrapper_0.IOVSS1 user_project_wrapper_0.sg13g2_IOPadVdd_1.sg13g2_RCClampInverter_noptap_0.out user_project_wrapper_0.VDD2 user_project_wrapper_0.IOVSS1 sg13_hv_nmos ad=1.408p pd=5.04u as=2.596p ps=5.58u w=4.4u l=0.6u
X3736 user_project_wrapper_0.IOVSS1 user_project_wrapper_0.sg13g2_IOPadVdd_3.sg13g2_RCClampInverter_noptap_0.out user_project_wrapper_0.IOVSS1 user_project_wrapper_0.IOVSS1 sg13_hv_nmos ad=1.408p pd=5.04u as=0 ps=0 w=4.4u l=0.6u
X3737 user_project_wrapper_0.VDD1 a_87468_125419# a_88393_125210# user_project_wrapper_0.VDD1 sg13_lv_pmos ad=0.3808p pd=2.92u as=0.2128p ps=1.5u w=1.12u l=0.13u
X3738 user_project_wrapper_0.IOVDD2 a_176644_41476# user_project_wrapper_0.analog_io[12] user_project_wrapper_0.IOVDD2 sg13_hv_pmos ad=2.1312p pd=7.3u as=3.9294p ps=7.84u w=6.66u l=0.6u
X3739 user_project_wrapper_0.analog_io[34] a_258244_369296# user_project_wrapper_0.IOVSS1 user_project_wrapper_0.IOVSS1 sg13_hv_nmos ad=2.596p pd=5.58u as=1.408p ps=5.04u w=4.4u l=0.6u
X3740 user_project_wrapper_0.IOVSS1 user_project_wrapper_0.IOVSS1 user_project_wrapper_0.IOVSS1 rhigh l=4u w=0.5u
X3741 VDD3 a_309516_194555# a_309917_199879# VDD3 sg13_lv_pmos ad=0.19p pd=1.38u as=0.19p ps=1.38u w=1u l=0.7u
X3742 a_313884_185173# a_296731_189665# a_311189_185546# user_project_wrapper_0.IOVSS1 sg13_lv_nmos ad=1.9p pd=10.38u as=1.9p ps=10.38u w=10u l=0.5u
X3743 user_project_wrapper_0.IOVSS1 a_79038_136536# a_79038_136536# user_project_wrapper_0.IOVSS1 sg13_lv_nmos ad=0.1428p pd=1.52u as=0.1428p ps=1.52u w=0.42u l=0.56u
X3744 user_project_wrapper_0.IOVSS1 a_115444_369296# user_project_wrapper_0.analog_io[27] user_project_wrapper_0.IOVSS1 sg13_hv_nmos ad=2.068p pd=9.74u as=2.596p ps=5.58u w=4.4u l=0.6u
X3745 user_project_wrapper_0.IOVSS1 a_190389_101343# user_project_wrapper_0.analog_io[15] user_project_wrapper_0.IOVSS1 sg13_lv_nmos ad=0.1406p pd=1.12u as=0.1406p ps=1.12u w=0.74u l=0.13u
X3746 user_project_wrapper_0.IOVSS1 user_project_wrapper_0.sg13g2_IOPadIOVdd_0.sg13g2_Clamp_N43N43D4R_0.gate user_project_wrapper_0.IOVDD2 user_project_wrapper_0.IOVSS1 sg13_hv_nmos ad=1.408p pd=5.04u as=2.596p ps=5.58u w=4.4u l=0.6u
X3747 a_296732_200582# a_301940_196388# a_296625_208423# VDD3 sg13_lv_pmos ad=1.377p pd=8.78u as=0.7695p ps=4.43u w=4.05u l=0.5u
X3748 user_project_wrapper_0.IOVSS1 user_project_wrapper_0.sg13g2_IOPadIOVdd_0.sg13g2_Clamp_N43N43D4R_0.gate user_project_wrapper_0.IOVDD2 user_project_wrapper_0.IOVSS1 sg13_hv_nmos ad=1.408p pd=5.04u as=2.596p ps=5.58u w=4.4u l=0.6u
X3749 user_project_wrapper_0.IOVSS1 a_205385_326221# a_202114_326125# user_project_wrapper_0.IOVSS1 sg13_lv_nmos ad=1.632p pd=10.28u as=0.912p ps=5.18u w=4.8u l=0.13u
X3750 user_project_wrapper_0.IOVSS1 a_29676_115444# user_project_wrapper_0.analog_io[0] user_project_wrapper_0.IOVSS1 sg13_hv_nmos ad=1.408p pd=5.04u as=2.596p ps=5.58u w=4.4u l=0.6u
X3751 a_296731_189665# a_296625_189595# VDD3 VDD3 sg13_lv_pmos ad=0.2603p pd=1.75u as=0.4658p ps=3.42u w=1.37u l=0.35u
X3752 user_project_wrapper_0.IOVSS1 user_project_wrapper_0.sg13g2_IOPadIOVdd_0.sg13g2_Clamp_N43N43D4R_0.gate user_project_wrapper_0.IOVDD2 user_project_wrapper_0.IOVSS1 sg13_hv_nmos ad=1.408p pd=5.04u as=2.596p ps=5.58u w=4.4u l=0.6u
X3753 user_project_wrapper_0.IOVSS1 user_project_wrapper_0.sg13g2_IOPadIOVdd_2.sg13g2_Clamp_N43N43D4R_0.gate user_project_wrapper_0.IOVDD4 user_project_wrapper_0.IOVSS1 sg13_hv_nmos ad=1.408p pd=5.04u as=2.596p ps=5.58u w=4.4u l=0.6u
X3754 a_191901_330987# TOP_ROILIFNEURON_0.MEM user_project_wrapper_0.IOVSS1 rhigh l=4u w=0.5u
X3755 user_project_wrapper_0.IOVSS1 user_project_wrapper_0.sg13g2_IOPadVdd_0.sg13g2_RCClampInverter_noptap_0.out VDD3 user_project_wrapper_0.IOVSS1 sg13_hv_nmos ad=1.408p pd=5.04u as=2.596p ps=5.58u w=4.4u l=0.6u
X3756 user_project_wrapper_0.sg13g2_IOPadVdd_2.sg13g2_RCClampInverter_noptap_0.out user_project_wrapper_0.sg13g2_IOPadVdd_2.sg13g2_RCClampResistor_0.p2 user_project_wrapper_0.VDD1 user_project_wrapper_0.VDD1 sg13_hv_pmos ad=1.33p pd=7.38u as=1.33p ps=7.38u w=7u l=0.5u
X3757 a_309917_194695# a_309516_194555# VDD3 VDD3 sg13_lv_pmos ad=0.19p pd=1.38u as=0.19p ps=1.38u w=1u l=0.7u
X3758 user_project_wrapper_0.IOVSS1 user_project_wrapper_0.sg13g2_IOPadIOVdd_1.sg13g2_Clamp_N43N43D4R_0.gate user_project_wrapper_0.IOVDD1 user_project_wrapper_0.IOVSS1 sg13_hv_nmos ad=1.408p pd=5.04u as=2.596p ps=5.58u w=4.4u l=0.6u
X3759 user_project_wrapper_0.IOVSS1 a_194687_324142# user_project_wrapper_0.analog_io[30] user_project_wrapper_0.IOVSS1 sg13_lv_nmos ad=0.912p pd=5.18u as=0.912p ps=5.18u w=4.8u l=0.13u
X3760 VDD3 a_296625_189595# a_296731_189665# VDD3 sg13_lv_pmos ad=0.4658p pd=3.42u as=0.2603p ps=1.75u w=1.37u l=0.35u
X3761 a_189835_330987# a_190721_331163# user_project_wrapper_0.IOVSS1 rhigh l=4u w=0.5u
X3762 user_project_wrapper_0.IOVSS1 user_project_wrapper_0.sg13g2_IOPadVdd_2.sg13g2_RCClampInverter_noptap_0.out user_project_wrapper_0.VDD1 user_project_wrapper_0.IOVSS1 sg13_hv_nmos ad=1.408p pd=5.04u as=2.596p ps=5.58u w=4.4u l=0.6u
X3763 a_309917_194695# a_309516_194555# VDD3 VDD3 sg13_lv_pmos ad=0.19p pd=1.38u as=0.19p ps=1.38u w=1u l=0.7u
X3764 IOVDD3 user_project_wrapper_0.sg13g2_IOPadIOVdd_3.sg13g2_Clamp_N43N43D4R_0.gate user_project_wrapper_0.IOVSS1 user_project_wrapper_0.IOVSS1 sg13_hv_nmos ad=2.596p pd=5.58u as=1.408p ps=5.04u w=4.4u l=0.6u
X3765 user_project_wrapper_0.ui_PAD[31] user_project_wrapper_0.sg13g2_IOPadIn$1_2.sg13g2_LevelDown_noptap$1_0.sg13g2_SecondaryProtection$1$1_0.core user_project_wrapper_0.IOVSS1 rppd l=2u w=1u
X3766 user_project_wrapper_0.IOVSS1 a_301186_192011# a_296731_208493# user_project_wrapper_0.IOVSS1 sg13_lv_nmos ad=0.912p pd=5.18u as=0.912p ps=5.18u w=4.8u l=1.06u
X3767 a_190389_101343# a_189729_101343# QDLL_TOP_0.VDD QDLL_TOP_0.VDD sg13_lv_pmos ad=0.2128p pd=1.5u as=0.2128p ps=1.5u w=1.12u l=0.13u
X3768 VDD3 user_project_wrapper_0.sg13g2_IOPadVdd_0.sg13g2_RCClampResistor_0.p2 user_project_wrapper_0.sg13g2_IOPadVdd_0.sg13g2_RCClampInverter_noptap_0.out VDD3 sg13_hv_pmos ad=1.33p pd=7.38u as=1.33p ps=7.38u w=7u l=0.5u
X3769 user_project_wrapper_0.VDD2 user_project_wrapper_0.sg13g2_IOPadVdd_1.sg13g2_RCClampInverter_noptap_0.out user_project_wrapper_0.IOVSS1 user_project_wrapper_0.IOVSS1 sg13_hv_nmos ad=2.596p pd=5.58u as=1.408p ps=5.04u w=4.4u l=0.6u
X3770 a_82846_240684# a_82645_240231# user_project_wrapper_0.VDD1 user_project_wrapper_0.VDD1 sg13_lv_pmos ad=0.95p pd=5.38u as=1.7p ps=10.68u w=5u l=0.15u
X3771 a_76675_364458# a_77005_360372# user_project_wrapper_0.IOVSS1 rppd l=20u w=1u
X3772 user_project_wrapper_0.analog_io[7] a_29676_258244# user_project_wrapper_0.IOVSS1 user_project_wrapper_0.IOVSS1 sg13_hv_nmos ad=2.596p pd=5.58u as=1.408p ps=5.04u w=4.4u l=0.6u
X3773 user_project_wrapper_0.IOVSS1 a_194279_327536# a_194687_324142# user_project_wrapper_0.IOVSS1 sg13_lv_pmos ad=1.824p pd=9.98u as=1.824p ps=9.98u w=9.6u l=0.13u
X3774 a_271172_100118# a_270512_100118# user_project_wrapper_0.IOVSS1 user_project_wrapper_0.IOVSS1 sg13_lv_nmos ad=0.1406p pd=1.12u as=0.1406p ps=1.12u w=0.74u l=0.13u
X3775 a_296731_208493# a_301186_192011# user_project_wrapper_0.IOVSS1 user_project_wrapper_0.IOVSS1 sg13_lv_nmos ad=0.912p pd=5.18u as=0.912p ps=5.18u w=4.8u l=1.06u
X3776 user_project_wrapper_0.VDD2 user_project_wrapper_0.sg13g2_IOPadVdd_1.sg13g2_RCClampInverter_noptap_0.out user_project_wrapper_0.IOVSS1 user_project_wrapper_0.IOVSS1 sg13_hv_nmos ad=3.256p pd=10.28u as=1.408p ps=5.04u w=4.4u l=0.6u
X3777 user_project_wrapper_0.IOVSS1 user_project_wrapper_0.sg13g2_IOPadVdd_2.sg13g2_RCClampInverter_noptap_0.out user_project_wrapper_0.VDD1 user_project_wrapper_0.IOVSS1 sg13_hv_nmos ad=1.408p pd=5.04u as=2.596p ps=5.58u w=4.4u l=0.6u
X3778 a_309917_199879# a_309516_194555# VDD3 VDD3 sg13_lv_pmos ad=0.19p pd=1.38u as=0.19p ps=1.38u w=1u l=0.7u
X3779 user_project_wrapper_0.analog_io[7] a_41476_258244# user_project_wrapper_0.IOVDD1 user_project_wrapper_0.IOVDD1 sg13_hv_pmos ad=3.9294p pd=7.84u as=2.1312p ps=7.3u w=6.66u l=0.6u
X3780 user_project_wrapper_0.sg13g2_IOPadVdd_1.sg13g2_RCClampInverter_noptap_0.out user_project_wrapper_0.sg13g2_IOPadVdd_1.sg13g2_RCClampResistor_0.p2 user_project_wrapper_0.VDD2 user_project_wrapper_0.VDD2 sg13_hv_pmos ad=1.33p pd=7.38u as=1.33p ps=7.38u w=7u l=0.5u
X3781 user_project_wrapper_0.IOVDD1 a_41476_197044# user_project_wrapper_0.analog_io[4] user_project_wrapper_0.IOVDD1 sg13_hv_pmos ad=2.1312p pd=7.3u as=3.9294p ps=7.84u w=6.66u l=0.6u
X3782 user_project_wrapper_0.IOVDD4 a_217444_355624# user_project_wrapper_0.analog_io[32] user_project_wrapper_0.IOVDD4 sg13_hv_pmos ad=3.1302p pd=14.26u as=3.9294p ps=7.84u w=6.66u l=0.6u
X3783 a_82433_130212# a_79025_138251# user_project_wrapper_0.VDD1 user_project_wrapper_0.VDD1 sg13_lv_pmos ad=0.3808p pd=2.92u as=0.3808p ps=2.92u w=1.12u l=0.13u
X3784 user_project_wrapper_0.IOVSS1 a_301186_192011# a_296731_208493# user_project_wrapper_0.IOVSS1 sg13_lv_nmos ad=0.912p pd=5.18u as=0.912p ps=5.18u w=4.8u l=1.06u
X3785 user_project_wrapper_0.IOVSS1 a_202114_326125# user_project_wrapper_0.analog_io[32] user_project_wrapper_0.IOVSS1 sg13_lv_pmos ad=1.824p pd=9.98u as=1.824p ps=9.98u w=9.6u l=0.13u
X3786 user_project_wrapper_0.IOVSS1 user_project_wrapper_0.IOVSS1 dantenna l=27.78u w=1.26u
X3787 user_project_wrapper_0.IOVSS1 user_project_wrapper_0.sg13g2_IOPadIOVdd_3.sg13g2_RCClampResistor_0.p2 user_project_wrapper_0.IOVSS1 user_project_wrapper_0.IOVSS1 sg13_hv_nmos ad=1.71p pd=9.38u as=0 ps=0 w=9u l=9.5u
X3788 user_project_wrapper_0.IOVSS1 user_project_wrapper_0.analog_io[7] dantenna l=27.78u w=1.26u
X3789 user_project_wrapper_0.analog_io[30] a_194687_324142# user_project_wrapper_0.IOVSS1 user_project_wrapper_0.IOVSS1 sg13_lv_nmos ad=0.912p pd=5.18u as=0.912p ps=5.18u w=4.8u l=0.13u
X3790 user_project_wrapper_0.IOVSS1 a_213870_324142# user_project_wrapper_0.analog_io[35] user_project_wrapper_0.IOVSS1 sg13_lv_nmos ad=0.912p pd=5.18u as=0.912p ps=5.18u w=4.8u l=0.13u
X3791 a_79025_137844# user_project_wrapper_0.sg13g2_IOPadAnalog_9.padres a_79038_137002# user_project_wrapper_0.VDD1 sg13_lv_pmos ad=1.7p pd=10.68u as=0.95p ps=5.38u w=5u l=0.3u
X3792 a_296731_208493# a_296625_208423# VDD3 VDD3 sg13_lv_pmos ad=0.2603p pd=1.75u as=0.2603p ps=1.75u w=1.37u l=0.35u
X3793 a_313884_185173# analog_io[20] a_311108_179669# user_project_wrapper_0.IOVSS1 sg13_lv_nmos ad=1.9p pd=10.38u as=1.9p ps=10.38u w=10u l=0.5u
X3794 a_208367_325263# a_208103_324155# user_project_wrapper_0.IOVSS1 user_project_wrapper_0.IOVSS1 sg13_lv_nmos ad=0.19p pd=1.38u as=0.34p ps=2.68u w=1u l=0.13u
X3795 user_project_wrapper_0.analog_io[33] user_project_wrapper_0.sg13g2_IOPadAnalog_21.padres user_project_wrapper_0.IOVSS1 rppd l=2u w=1u
X3796 VDD3 a_296625_189595# a_296731_189665# VDD3 sg13_lv_pmos ad=0.2603p pd=1.75u as=0.2603p ps=1.75u w=1.37u l=0.35u
X3797 user_project_wrapper_0.analog_io[13] a_197044_29676# user_project_wrapper_0.IOVSS1 user_project_wrapper_0.IOVSS1 sg13_hv_nmos ad=2.596p pd=5.58u as=2.068p ps=9.74u w=4.4u l=0.6u
X3798 VDD3 a_296625_189595# a_296731_189665# VDD3 sg13_lv_pmos ad=0.2603p pd=1.75u as=0.2603p ps=1.75u w=1.37u l=0.35u
X3799 a_304196_200821# a_304090_197941# a_296625_208423# user_project_wrapper_0.IOVSS1 sg13_lv_nmos ad=0.361p pd=2.28u as=0.361p ps=2.28u w=1.9u l=0.16u
X3800 VDD3 a_309516_194555# a_309516_194555# VDD3 sg13_lv_pmos ad=0.19p pd=1.38u as=0.19p ps=1.38u w=1u l=0.7u
X3801 user_project_wrapper_0.IOVDD2 a_176644_41476# user_project_wrapper_0.analog_io[12] user_project_wrapper_0.IOVDD2 sg13_hv_pmos ad=2.1312p pd=7.3u as=3.9294p ps=7.84u w=6.66u l=0.6u
X3802 a_188184_99046# a_187914_99087# user_project_wrapper_0.IOVSS1 user_project_wrapper_0.IOVSS1 sg13_lv_nmos ad=0.1428p pd=1.52u as=79.8f ps=0.8u w=0.42u l=0.5u
X3803 user_project_wrapper_0.IOVSS1 user_project_wrapper_0.sg13g2_IOPadVdd_0.sg13g2_RCClampResistor_0.p2 user_project_wrapper_0.IOVSS1 user_project_wrapper_0.IOVSS1 sg13_hv_nmos ad=3.06p pd=18.68u as=0 ps=0 w=9u l=9.5u
X3804 VDD3 user_project_wrapper_0.sg13g2_IOPadVdd_0.sg13g2_RCClampInverter_noptap_0.out user_project_wrapper_0.IOVSS1 user_project_wrapper_0.IOVSS1 sg13_hv_nmos ad=2.596p pd=5.58u as=1.408p ps=5.04u w=4.4u l=0.6u
X3805 IOVDD3 user_project_wrapper_0.sg13g2_IOPadIOVdd_3.sg13g2_RCClampResistor_0.p2 user_project_wrapper_0.sg13g2_IOPadIOVdd_3.sg13g2_Clamp_N43N43D4R_0.gate IOVDD3 sg13_hv_pmos ad=1.33p pd=7.38u as=1.33p ps=7.38u w=7u l=0.5u
X3806 user_project_wrapper_0.VDD2 user_project_wrapper_0.sg13g2_IOPadVdd_1.sg13g2_RCClampInverter_noptap_0.out user_project_wrapper_0.IOVSS1 user_project_wrapper_0.IOVSS1 sg13_hv_nmos ad=2.596p pd=5.58u as=1.408p ps=5.04u w=4.4u l=0.6u
X3807 user_project_wrapper_0.VDD1 user_project_wrapper_0.sg13g2_IOPadVdd_2.sg13g2_RCClampInverter_noptap_0.out user_project_wrapper_0.IOVSS1 user_project_wrapper_0.IOVSS1 sg13_hv_nmos ad=2.596p pd=5.58u as=1.408p ps=5.04u w=4.4u l=0.6u
X3808 user_project_wrapper_0.analog_io[15] a_190389_101343# QDLL_TOP_0.VDD QDLL_TOP_0.VDD sg13_lv_pmos ad=0.2128p pd=1.5u as=0.2128p ps=1.5u w=1.12u l=0.13u
X3809 user_project_wrapper_0.IOVSS1 user_project_wrapper_0.sg13g2_IOPadIOVdd_0.sg13g2_RCClampResistor_0.p2 user_project_wrapper_0.IOVSS1 user_project_wrapper_0.IOVSS1 sg13_hv_nmos ad=1.71p pd=9.38u as=0 ps=0 w=9u l=9.5u
X3810 user_project_wrapper_0.IOVSS1 user_project_wrapper_0.sg13g2_IOPadIOVdd_3.sg13g2_RCClampResistor_0.p2 user_project_wrapper_0.IOVSS1 user_project_wrapper_0.IOVSS1 sg13_hv_nmos ad=1.71p pd=9.38u as=0 ps=0 w=9u l=9.5u
X3811 user_project_wrapper_0.sg13g2_IOPadVdd_2.sg13g2_RCClampInverter_noptap_0.out user_project_wrapper_0.sg13g2_IOPadVdd_2.sg13g2_RCClampResistor_0.p2 user_project_wrapper_0.VDD1 user_project_wrapper_0.VDD1 sg13_hv_pmos ad=1.33p pd=7.38u as=1.33p ps=7.38u w=7u l=0.5u
X3812 a_79025_126994# a_78221_125094# a_79038_125686# user_project_wrapper_0.VDD1 sg13_lv_pmos ad=1.7p pd=10.68u as=0.95p ps=5.38u w=5u l=0.3u
X3813 user_project_wrapper_0.IOVSS1 a_156244_29676# user_project_wrapper_0.analog_io[11] user_project_wrapper_0.IOVSS1 sg13_hv_nmos ad=1.408p pd=5.04u as=2.596p ps=5.58u w=4.4u l=0.6u
X3814 user_project_wrapper_0.VDD1 a_83050_125173# a_82974_125209# user_project_wrapper_0.VDD1 sg13_lv_pmos ad=0.3808p pd=2.92u as=0.2128p ps=1.5u w=1.12u l=0.13u
X3815 user_project_wrapper_0.IOVSS1 user_project_wrapper_0.sg13g2_IOPadIOVdd_1.sg13g2_Clamp_N43N43D4R_0.gate user_project_wrapper_0.IOVDD1 user_project_wrapper_0.IOVSS1 sg13_hv_nmos ad=1.408p pd=5.04u as=2.596p ps=5.58u w=4.4u l=0.6u
X3816 user_project_wrapper_0.sg13g2_IOPadOut4mA$1_0.sg13g2_GateLevelUpInv_noptap$1$1_0.pgate a_57810_180219# user_project_wrapper_0.IOVDD1 user_project_wrapper_0.IOVDD1 sg13_hv_pmos ad=1.326p pd=8.48u as=1.326p ps=8.48u w=3.9u l=0.45u
X3817 user_project_wrapper_0.analog_io[35] a_213870_324142# user_project_wrapper_0.IOVSS1 user_project_wrapper_0.IOVSS1 sg13_lv_nmos ad=0.912p pd=5.18u as=0.912p ps=5.18u w=4.8u l=0.13u
X3818 a_84598_130212# a_84288_130212# user_project_wrapper_0.IOVSS1 user_project_wrapper_0.IOVSS1 sg13_lv_nmos ad=0.1406p pd=1.12u as=0.2516p ps=2.16u w=0.74u l=0.13u
X3819 a_35456_79315# a_39542_79645# user_project_wrapper_0.IOVSS1 rppd l=20u w=1u
X3820 QDLL_TOP_0.VOUT a_271172_100118# user_project_wrapper_0.IOVSS1 user_project_wrapper_0.IOVSS1 sg13_lv_nmos ad=0.1406p pd=1.12u as=0.1406p ps=1.12u w=0.74u l=0.13u
X3821 user_project_wrapper_0.IOVSS1 user_project_wrapper_0.sg13g2_IOPadVdd_3.sg13g2_RCClampInverter_noptap_0.out user_project_wrapper_0.IOVSS1 user_project_wrapper_0.IOVSS1 sg13_hv_nmos ad=2.596p pd=5.58u as=0 ps=0 w=4.4u l=0.6u
X3822 user_project_wrapper_0.IOVSS1 a_29676_237844# user_project_wrapper_0.analog_io[6] user_project_wrapper_0.IOVSS1 sg13_hv_nmos ad=1.408p pd=5.04u as=2.596p ps=5.58u w=4.4u l=0.6u
X3823 user_project_wrapper_0.IOVDD1 user_project_wrapper_0.sg13g2_IOPadIOVdd_1.sg13g2_Clamp_N43N43D4R_0.gate user_project_wrapper_0.IOVSS1 user_project_wrapper_0.IOVSS1 sg13_hv_nmos ad=2.596p pd=5.58u as=1.408p ps=5.04u w=4.4u l=0.6u
X3824 VDD3 a_296625_208423# a_296731_208493# VDD3 sg13_lv_pmos ad=0.2603p pd=1.75u as=0.2603p ps=1.75u w=1.37u l=0.35u
X3825 user_project_wrapper_0.IOVSS1 a_29676_258244# user_project_wrapper_0.analog_io[7] user_project_wrapper_0.IOVSS1 sg13_hv_nmos ad=1.408p pd=5.04u as=2.596p ps=5.58u w=4.4u l=0.6u
X3826 user_project_wrapper_0.analog_io[30] a_176644_369296# user_project_wrapper_0.IOVSS1 user_project_wrapper_0.IOVSS1 sg13_hv_nmos ad=2.596p pd=5.58u as=1.408p ps=5.04u w=4.4u l=0.6u
X3827 user_project_wrapper_0.sg13g2_IOPadAnalog_28.padres user_project_wrapper_0.IOVDD1 dpantenna l=4.98u w=0.64u
X3828 a_296732_200582# a_296626_197740# VDD3 VDD3 sg13_lv_pmos ad=1.33p pd=7.38u as=1.33p ps=7.38u w=7u l=0.7u
X3829 VDD3 a_309516_194555# a_309917_199879# VDD3 sg13_lv_pmos ad=0.19p pd=1.38u as=0.19p ps=1.38u w=1u l=0.7u
X3830 user_project_wrapper_0.IOVDD4 a_135844_355624# user_project_wrapper_0.analog_io[28] user_project_wrapper_0.IOVDD4 sg13_hv_pmos ad=2.1312p pd=7.3u as=3.9294p ps=7.84u w=6.66u l=0.6u
X3831 user_project_wrapper_0.analog_io[27] a_182931_326125# user_project_wrapper_0.IOVSS1 user_project_wrapper_0.IOVSS1 sg13_lv_pmos ad=1.824p pd=9.98u as=1.824p ps=9.98u w=9.6u l=0.13u
X3832 VDD3 a_309516_194555# a_309917_199879# VDD3 sg13_lv_pmos ad=0.19p pd=1.38u as=0.19p ps=1.38u w=1u l=0.7u
X3833 user_project_wrapper_0.IOVSS1 a_190389_99046# user_project_wrapper_0.analog_io[14] user_project_wrapper_0.IOVSS1 sg13_lv_nmos ad=0.2516p pd=2.16u as=0.1406p ps=1.12u w=0.74u l=0.13u
X3834 user_project_wrapper_0.analog_io[34] a_258244_355624# user_project_wrapper_0.IOVDD4 user_project_wrapper_0.IOVDD4 sg13_hv_pmos ad=3.9294p pd=7.84u as=2.1312p ps=7.3u w=6.66u l=0.6u
X3835 user_project_wrapper_0.IOVSS1 user_project_wrapper_0.analog_io[11] dantenna l=1.26u w=27.78u
X3836 user_project_wrapper_0.IOVSS1 a_194193_328627# a_194279_327536# user_project_wrapper_0.IOVSS1 sg13_lv_nmos ad=0.912p pd=5.18u as=0.912p ps=5.18u w=4.8u l=0.13u
X3837 user_project_wrapper_0.IOVSS1 a_369296_278644# analog_io[26] user_project_wrapper_0.IOVSS1 sg13_hv_nmos ad=1.408p pd=5.04u as=2.596p ps=5.58u w=4.4u l=0.6u
X3838 user_project_wrapper_0.analog_io[27] a_182931_326125# user_project_wrapper_0.IOVSS1 user_project_wrapper_0.IOVSS1 sg13_lv_pmos ad=1.824p pd=9.98u as=1.824p ps=9.98u w=9.6u l=0.13u
X3839 user_project_wrapper_0.IOVDD4 a_176644_355624# user_project_wrapper_0.analog_io[30] user_project_wrapper_0.IOVDD4 sg13_hv_pmos ad=2.1312p pd=7.3u as=3.9294p ps=7.84u w=6.66u l=0.6u
X3840 a_86594_129426# a_86507_129255# user_project_wrapper_0.VDD1 user_project_wrapper_0.VDD1 sg13_lv_pmos ad=0.2128p pd=1.5u as=0.3808p ps=2.92u w=1.12u l=0.13u
X3841 analog_io[25] a_355624_258244# IOVDD3 IOVDD3 sg13_hv_pmos ad=3.9294p pd=7.84u as=2.1312p ps=7.3u w=6.66u l=0.6u
X3842 user_project_wrapper_0.IOVSS1 a_258244_369296# user_project_wrapper_0.analog_io[34] user_project_wrapper_0.IOVSS1 sg13_hv_nmos ad=1.408p pd=5.04u as=2.596p ps=5.58u w=4.4u l=0.6u
X3843 user_project_wrapper_0.uo_PAD[8] user_project_wrapper_0.sg13g2_IOPadOut4mA$1_1.sg13g2_GateLevelUpInv_noptap$1$1_0.pgate user_project_wrapper_0.IOVDD1 user_project_wrapper_0.IOVDD1 sg13_hv_pmos ad=3.9294p pd=7.84u as=3.1302p ps=14.26u w=6.66u l=0.6u
X3844 user_project_wrapper_0.IOVSS1 a_202114_326125# user_project_wrapper_0.analog_io[32] user_project_wrapper_0.IOVSS1 sg13_lv_nmos ad=0.912p pd=5.18u as=0.912p ps=5.18u w=4.8u l=0.13u
X3845 analog_io[22] a_369296_197044# user_project_wrapper_0.IOVSS1 user_project_wrapper_0.IOVSS1 sg13_hv_nmos ad=2.596p pd=5.58u as=2.068p ps=9.74u w=4.4u l=0.6u
X3846 user_project_wrapper_0.IOVSS1 a_301186_192011# a_296731_189665# user_project_wrapper_0.IOVSS1 sg13_lv_nmos ad=0.912p pd=5.18u as=0.912p ps=5.18u w=4.8u l=1.06u
X3847 user_project_wrapper_0.IOVSS1 user_project_wrapper_0.sg13g2_IOPadVdd_3.sg13g2_RCClampInverter_noptap_0.out user_project_wrapper_0.IOVSS1 user_project_wrapper_0.IOVSS1 sg13_hv_nmos ad=1.408p pd=5.04u as=0 ps=0 w=4.4u l=0.6u
X3848 user_project_wrapper_0.IOVSS1 user_project_wrapper_0.sg13g2_IOPadVdd_0.sg13g2_RCClampResistor_0.p2 user_project_wrapper_0.IOVSS1 user_project_wrapper_0.IOVSS1 sg13_hv_nmos ad=1.71p pd=9.38u as=0 ps=0 w=9u l=9.5u
X3849 user_project_wrapper_0.IOVSS1 a_311846_195517# a_311846_195517# user_project_wrapper_0.IOVSS1 sg13_lv_nmos ad=0.6327p pd=3.71u as=0.6327p ps=3.71u w=3.33u l=0.2u
X3850 analog_io[23] a_369296_217444# user_project_wrapper_0.IOVSS1 user_project_wrapper_0.IOVSS1 sg13_hv_nmos ad=2.596p pd=5.58u as=1.408p ps=5.04u w=4.4u l=0.6u
X3851 a_209684_326377# a_208367_326377# user_project_wrapper_0.IOVSS1 user_project_wrapper_0.IOVSS1 sg13_lv_nmos ad=0.34p pd=2.68u as=0.34p ps=2.68u w=1u l=0.13u
X3852 user_project_wrapper_0.IOVSS1 user_project_wrapper_0.sg13g2_IOPadVdd_3.sg13g2_RCClampInverter_noptap_0.out user_project_wrapper_0.IOVSS1 user_project_wrapper_0.IOVSS1 sg13_hv_nmos ad=1.408p pd=5.04u as=0 ps=0 w=4.4u l=0.6u
X3853 user_project_wrapper_0.IOVDD4 user_project_wrapper_0.sg13g2_IOPadIOVdd_2.sg13g2_RCClampResistor_0.p2 user_project_wrapper_0.sg13g2_IOPadIOVdd_2.sg13g2_Clamp_N43N43D4R_0.gate user_project_wrapper_0.IOVDD4 sg13_hv_pmos ad=1.33p pd=7.38u as=1.33p ps=7.38u w=7u l=0.5u
X3854 user_project_wrapper_0.IOVSS1 user_project_wrapper_0.sg13g2_IOPadAnalog_8.padres dantenna l=0.64u w=3.1u
X3855 user_project_wrapper_0.IOVDD1 user_project_wrapper_0.sg13g2_IOPadIOVdd_1.sg13g2_Clamp_N43N43D4R_0.gate user_project_wrapper_0.IOVSS1 user_project_wrapper_0.IOVSS1 sg13_hv_nmos ad=2.596p pd=5.58u as=1.408p ps=5.04u w=4.4u l=0.6u
X3856 a_88291_125210# a_87627_124843# a_87851_125174# user_project_wrapper_0.VDD1 sg13_lv_pmos ad=0.2128p pd=1.5u as=0.2128p ps=1.5u w=1.12u l=0.13u
X3857 user_project_wrapper_0.analog_io[11] a_156244_41476# user_project_wrapper_0.IOVDD2 user_project_wrapper_0.IOVDD2 sg13_hv_pmos ad=3.9294p pd=7.84u as=3.1302p ps=14.26u w=6.66u l=0.6u
X3858 user_project_wrapper_0.sg13g2_IOPadAnalog_4.padres user_project_wrapper_0.IOVDD2 dpantenna l=0.64u w=4.98u
X3859 VDD3 a_296625_208423# a_296731_208493# VDD3 sg13_lv_pmos ad=0.2603p pd=1.75u as=0.2603p ps=1.75u w=1.37u l=0.35u
X3860 analog_io[20] a_369296_176644# user_project_wrapper_0.IOVSS1 user_project_wrapper_0.IOVSS1 sg13_hv_nmos ad=2.596p pd=5.58u as=1.408p ps=5.04u w=4.4u l=0.6u
X3861 user_project_wrapper_0.IOVSS1 user_project_wrapper_0.IOVSS1 user_project_wrapper_0.IOVSS1 rppd l=0.5u w=0.5u
X3862 a_209905_329327# a_208939_328605# user_project_wrapper_0.IOVSS1 user_project_wrapper_0.IOVSS1 sg13_lv_nmos ad=0.19p pd=1.38u as=0.34p ps=2.68u w=1u l=0.13u
X3863 user_project_wrapper_0.sg13g2_IOPadVdd_0.sg13g2_RCClampResistor_0.p2 a_364458_81295# user_project_wrapper_0.IOVSS1 rppd l=20u w=1u
X3864 user_project_wrapper_0.analog_io[5] a_29676_217444# user_project_wrapper_0.IOVSS1 user_project_wrapper_0.IOVSS1 sg13_hv_nmos ad=2.596p pd=5.58u as=1.408p ps=5.04u w=4.4u l=0.6u
X3865 user_project_wrapper_0.IOVSS1 user_project_wrapper_0.sg13g2_IOPadVdd_3.sg13g2_RCClampResistor_0.p2 user_project_wrapper_0.IOVSS1 user_project_wrapper_0.IOVSS1 sg13_hv_nmos ad=1.71p pd=9.38u as=0 ps=0 w=9u l=9.5u
X3866 user_project_wrapper_0.analog_io[10] a_135844_29676# user_project_wrapper_0.IOVSS1 user_project_wrapper_0.IOVSS1 sg13_hv_nmos ad=2.596p pd=5.58u as=1.408p ps=5.04u w=4.4u l=0.6u
X3867 a_304196_197873# a_304090_197941# a_296625_189595# user_project_wrapper_0.IOVSS1 sg13_lv_nmos ad=0.361p pd=2.28u as=0.361p ps=2.28u w=1.9u l=0.16u
X3868 VDD3 a_296626_197740# a_296626_197740# VDD3 sg13_lv_pmos ad=0.266p pd=1.78u as=0.266p ps=1.78u w=1.4u l=0.35u
X3869 user_project_wrapper_0.IOVSS1 a_194687_324142# user_project_wrapper_0.analog_io[30] user_project_wrapper_0.IOVSS1 sg13_lv_nmos ad=0.912p pd=5.18u as=0.912p ps=5.18u w=4.8u l=0.13u
X3870 user_project_wrapper_0.IOVSS1 a_190389_101343# user_project_wrapper_0.analog_io[15] user_project_wrapper_0.IOVSS1 sg13_lv_nmos ad=0.1406p pd=1.12u as=0.1406p ps=1.12u w=0.74u l=0.13u
X3871 user_project_wrapper_0.IOVSS1 a_369296_135844# analog_io[19] user_project_wrapper_0.IOVSS1 sg13_hv_nmos ad=1.408p pd=5.04u as=2.596p ps=5.58u w=4.4u l=0.6u
X3872 user_project_wrapper_0.IOVDD1 a_41476_135844# user_project_wrapper_0.analog_io[1] user_project_wrapper_0.IOVDD1 sg13_hv_pmos ad=2.1312p pd=7.3u as=3.9294p ps=7.84u w=6.66u l=0.6u
X3873 user_project_wrapper_0.analog_io[4] a_41476_197044# user_project_wrapper_0.IOVDD1 user_project_wrapper_0.IOVDD1 sg13_hv_pmos ad=3.9294p pd=7.84u as=2.1312p ps=7.3u w=6.66u l=0.6u
X3874 a_304196_200821# a_304090_197941# a_296625_208423# user_project_wrapper_0.IOVSS1 sg13_lv_nmos ad=0.361p pd=2.28u as=0.361p ps=2.28u w=1.9u l=0.16u
X3875 user_project_wrapper_0.IOVSS1 user_project_wrapper_0.sg13g2_IOPadIOVdd_3.sg13g2_Clamp_N43N43D4R_0.gate IOVDD3 user_project_wrapper_0.IOVSS1 sg13_hv_nmos ad=1.408p pd=5.04u as=2.596p ps=5.58u w=4.4u l=0.6u
X3876 user_project_wrapper_0.IOVSS1 user_project_wrapper_0.sg13g2_IOPadIOVdd_3.sg13g2_Clamp_N43N43D4R_0.gate IOVDD3 user_project_wrapper_0.IOVSS1 sg13_hv_nmos ad=1.408p pd=5.04u as=2.596p ps=5.58u w=4.4u l=0.6u
X3877 user_project_wrapper_0.IOVSS1 user_project_wrapper_0.sg13g2_IOPadVdd_3.sg13g2_RCClampInverter_noptap_0.out user_project_wrapper_0.IOVSS1 user_project_wrapper_0.IOVSS1 sg13_hv_nmos ad=1.408p pd=5.04u as=0 ps=0 w=4.4u l=0.6u
X3878 a_192745_324776# TOP_ROILIFNEURON_0.MEM user_project_wrapper_0.IOVSS1 w_188806_323975# sg13_lv_pmos ad=0.38p pd=2.38u as=0.38p ps=2.38u w=2u l=0.13u
X3879 user_project_wrapper_0.IOVSS1 user_project_wrapper_0.sg13g2_IOPadVdd_1.sg13g2_RCClampInverter_noptap_0.out user_project_wrapper_0.VDD2 user_project_wrapper_0.IOVSS1 sg13_hv_nmos ad=1.408p pd=5.04u as=2.596p ps=5.58u w=4.4u l=0.6u
X3880 a_309917_194695# a_309516_194555# VDD3 VDD3 sg13_lv_pmos ad=0.19p pd=1.38u as=0.19p ps=1.38u w=1u l=0.7u
X3881 user_project_wrapper_0.IOVSS1 user_project_wrapper_0.sg13g2_IOPadOut4mA$1_1.sg13g2_GateLevelUpInv_noptap$1$1_0.ngate user_project_wrapper_0.uo_PAD[8] user_project_wrapper_0.IOVSS1 sg13_hv_nmos ad=2.068p pd=9.74u as=2.596p ps=5.58u w=4.4u l=0.6u
X3882 a_309917_199879# a_296731_208493# a_307232_196607# VDD3 sg13_lv_pmos ad=0.24415p pd=1.665u as=0.24415p ps=1.665u w=1.285u l=0.35u
X3883 user_project_wrapper_0.IOVSS1 a_205385_326221# a_202114_326125# user_project_wrapper_0.IOVSS1 sg13_lv_nmos ad=0.912p pd=5.18u as=0.912p ps=5.18u w=4.8u l=0.13u
X3884 user_project_wrapper_0.VDD1 user_project_wrapper_0.sg13g2_IOPadVdd_2.sg13g2_RCClampInverter_noptap_0.out user_project_wrapper_0.IOVSS1 user_project_wrapper_0.IOVSS1 sg13_hv_nmos ad=2.596p pd=5.58u as=1.408p ps=5.04u w=4.4u l=0.6u
X3885 user_project_wrapper_0.IOVSS1 user_project_wrapper_0.sg13g2_IOPadIOVdd_1.sg13g2_Clamp_N43N43D4R_0.gate user_project_wrapper_0.IOVDD1 user_project_wrapper_0.IOVSS1 sg13_hv_nmos ad=1.408p pd=5.04u as=2.596p ps=5.58u w=4.4u l=0.6u
X3886 user_project_wrapper_0.IOVSS1 user_project_wrapper_0.sg13g2_IOPadVdd_3.sg13g2_RCClampInverter_noptap_0.out user_project_wrapper_0.IOVSS1 user_project_wrapper_0.IOVSS1 sg13_hv_nmos ad=2.596p pd=5.58u as=0 ps=0 w=4.4u l=0.6u
X3887 a_296731_189665# a_296625_189595# VDD3 VDD3 sg13_lv_pmos ad=0.2603p pd=1.75u as=0.2603p ps=1.75u w=1.37u l=0.35u
X3888 VDD3 a_296625_208423# a_296731_208493# VDD3 sg13_lv_pmos ad=0.2603p pd=1.75u as=0.2603p ps=1.75u w=1.37u l=0.35u
X3889 user_project_wrapper_0.analog_io[32] a_217444_355624# user_project_wrapper_0.IOVDD4 user_project_wrapper_0.IOVDD4 sg13_hv_pmos ad=3.9294p pd=7.84u as=2.1312p ps=7.3u w=6.66u l=0.6u
X3890 user_project_wrapper_0.IOVSS1 a_192138_324119# a_191800_324119# user_project_wrapper_0.IOVSS1 sg13_lv_nmos ad=0.34p pd=2.68u as=0.34p ps=2.68u w=1u l=0.65u
X3891 a_79025_131334# user_project_wrapper_0.sg13g2_IOPadAnalog_9.padres a_79038_130492# user_project_wrapper_0.VDD1 sg13_lv_pmos ad=1.7p pd=10.68u as=0.95p ps=5.38u w=5u l=0.3u
X3892 VDD3 a_309516_194555# a_309917_199879# VDD3 sg13_lv_pmos ad=0.19p pd=1.38u as=0.19p ps=1.38u w=1u l=0.7u
X3893 user_project_wrapper_0.IOVSS1 a_369296_217444# analog_io[23] user_project_wrapper_0.IOVSS1 sg13_hv_nmos ad=2.068p pd=9.74u as=2.596p ps=5.58u w=4.4u l=0.6u
X3894 user_project_wrapper_0.IOVSS1 user_project_wrapper_0.sg13g2_IOPadIOVdd_3.sg13g2_Clamp_N43N43D4R_0.gate IOVDD3 user_project_wrapper_0.IOVSS1 sg13_hv_nmos ad=1.408p pd=5.04u as=2.596p ps=5.58u w=4.4u l=0.6u
X3895 a_369296_135844# user_project_wrapper_0.IOVSS1 user_project_wrapper_0.IOVSS1 rppd l=3.54u w=0.5u
X3896 user_project_wrapper_0.IOVSS1 a_301186_192011# a_296731_208493# user_project_wrapper_0.IOVSS1 sg13_lv_nmos ad=0.912p pd=5.18u as=0.912p ps=5.18u w=4.8u l=1.06u
X3897 user_project_wrapper_0.IOVSS1 a_190389_99046# user_project_wrapper_0.analog_io[14] user_project_wrapper_0.IOVSS1 sg13_lv_nmos ad=0.1406p pd=1.12u as=0.1406p ps=1.12u w=0.74u l=0.13u
X3898 user_project_wrapper_0.IOVSS1 a_189729_99046# a_190389_99046# user_project_wrapper_0.IOVSS1 sg13_lv_nmos ad=0.1406p pd=1.12u as=0.1406p ps=1.12u w=0.74u l=0.13u
X3899 a_190389_101343# a_189729_101343# QDLL_TOP_0.VDD QDLL_TOP_0.VDD sg13_lv_pmos ad=0.2128p pd=1.5u as=0.3808p ps=2.92u w=1.12u l=0.13u
X3900 user_project_wrapper_0.IOVSS1 user_project_wrapper_0.sg13g2_IOPadIOVdd_0.sg13g2_RCClampResistor_0.p2 user_project_wrapper_0.IOVSS1 user_project_wrapper_0.IOVSS1 sg13_hv_nmos ad=1.71p pd=9.38u as=0 ps=0 w=9u l=9.5u
X3901 a_313884_185173# a_296731_189665# a_311189_185546# user_project_wrapper_0.IOVSS1 sg13_lv_nmos ad=1.9p pd=10.38u as=1.9p ps=10.38u w=10u l=0.5u
X3902 user_project_wrapper_0.analog_io[32] a_217444_369296# user_project_wrapper_0.IOVSS1 user_project_wrapper_0.IOVSS1 sg13_hv_nmos ad=2.596p pd=5.58u as=1.408p ps=5.04u w=4.4u l=0.6u
X3903 analog_io[26] a_355624_278644# IOVDD3 IOVDD3 sg13_hv_pmos ad=3.9294p pd=7.84u as=2.1312p ps=7.3u w=6.66u l=0.6u
X3904 user_project_wrapper_0.IOVDD1 user_project_wrapper_0.sg13g2_IOPadIOVdd_1.sg13g2_Clamp_N43N43D4R_0.gate user_project_wrapper_0.IOVSS1 user_project_wrapper_0.IOVSS1 sg13_hv_nmos ad=2.596p pd=5.58u as=1.408p ps=5.04u w=4.4u l=0.6u
X3905 user_project_wrapper_0.IOVSS1 user_project_wrapper_0.sg13g2_IOPadVdd_0.sg13g2_RCClampResistor_0.p2 user_project_wrapper_0.IOVSS1 user_project_wrapper_0.IOVSS1 sg13_hv_nmos ad=1.71p pd=9.38u as=0 ps=0 w=9u l=9.5u
X3906 VDD3 user_project_wrapper_0.sg13g2_IOPadVdd_0.sg13g2_RCClampInverter_noptap_0.out user_project_wrapper_0.IOVSS1 user_project_wrapper_0.IOVSS1 sg13_hv_nmos ad=2.596p pd=5.58u as=1.408p ps=5.04u w=4.4u l=0.6u
X3907 a_296732_200582# a_301940_196388# a_296625_208423# VDD3 sg13_lv_pmos ad=0.7695p pd=4.43u as=0.7695p ps=4.43u w=4.05u l=0.5u
X3908 a_271172_100118# a_270512_100118# user_project_wrapper_0.IOVSS1 user_project_wrapper_0.IOVSS1 sg13_lv_nmos ad=0.1406p pd=1.12u as=0.1406p ps=1.12u w=0.74u l=0.13u
X3909 user_project_wrapper_0.IOVSS1 a_194279_327536# a_194687_324142# user_project_wrapper_0.IOVSS1 sg13_lv_pmos ad=1.824p pd=9.98u as=1.824p ps=9.98u w=9.6u l=0.13u
X3910 user_project_wrapper_0.IOVDD2 user_project_wrapper_0.sg13g2_IOPadIOVdd_0.sg13g2_RCClampResistor_0.p2 user_project_wrapper_0.sg13g2_IOPadIOVdd_0.sg13g2_Clamp_N43N43D4R_0.gate user_project_wrapper_0.IOVDD2 sg13_hv_pmos ad=1.33p pd=7.38u as=1.33p ps=7.38u w=7u l=0.5u
X3911 user_project_wrapper_0.VDD1 user_project_wrapper_0.sg13g2_IOPadVdd_2.sg13g2_RCClampInverter_noptap_0.out user_project_wrapper_0.IOVSS1 user_project_wrapper_0.IOVSS1 sg13_hv_nmos ad=2.596p pd=5.58u as=1.408p ps=5.04u w=4.4u l=0.6u
X3912 user_project_wrapper_0.IOVSS1 analog_io[25] dantenna l=27.78u w=1.26u
X3913 user_project_wrapper_0.IOVSS1 a_191234_325263# a_191438_325263# user_project_wrapper_0.IOVSS1 sg13_lv_nmos ad=0.19p pd=1.38u as=0.19p ps=1.38u w=1u l=0.13u
X3914 user_project_wrapper_0.IOVSS1 a_190389_101343# user_project_wrapper_0.analog_io[15] user_project_wrapper_0.IOVSS1 sg13_lv_nmos ad=0.1406p pd=1.12u as=0.1406p ps=1.12u w=0.74u l=0.13u
X3915 user_project_wrapper_0.IOVDD1 a_41476_258244# user_project_wrapper_0.analog_io[7] user_project_wrapper_0.IOVDD1 sg13_hv_pmos ad=2.1312p pd=7.3u as=3.9294p ps=7.84u w=6.66u l=0.6u
X3916 VDD3 a_309516_194555# a_309917_199879# VDD3 sg13_lv_pmos ad=0.19p pd=1.38u as=0.19p ps=1.38u w=1u l=0.7u
X3917 user_project_wrapper_0.IOVSS1 a_307232_196607# a_304995_198817# user_project_wrapper_0.IOVSS1 sg13_lv_nmos ad=0.6327p pd=3.71u as=0.6327p ps=3.71u w=3.33u l=0.2u
X3918 IOVDD3 user_project_wrapper_0.sg13g2_IOPadIOVdd_3.sg13g2_RCClampResistor_0.p2 user_project_wrapper_0.sg13g2_IOPadIOVdd_3.sg13g2_Clamp_N43N43D4R_0.gate IOVDD3 sg13_hv_pmos ad=1.33p pd=7.38u as=1.33p ps=7.38u w=7u l=0.5u
X3919 user_project_wrapper_0.IOVSS1 a_202114_326125# user_project_wrapper_0.analog_io[32] user_project_wrapper_0.IOVSS1 sg13_lv_pmos ad=1.824p pd=9.98u as=1.824p ps=9.98u w=9.6u l=0.13u
X3920 user_project_wrapper_0.IOVSS1 user_project_wrapper_0.sg13g2_IOPadVdd_3.sg13g2_RCClampInverter_noptap_0.out user_project_wrapper_0.IOVSS1 user_project_wrapper_0.IOVSS1 sg13_hv_nmos ad=1.408p pd=5.04u as=0 ps=0 w=4.4u l=0.6u
X3921 user_project_wrapper_0.IOVSS1 user_project_wrapper_0.sg13g2_IOPadVdd_3.sg13g2_RCClampInverter_noptap_0.out user_project_wrapper_0.IOVSS1 user_project_wrapper_0.IOVSS1 sg13_hv_nmos ad=1.408p pd=5.04u as=0 ps=0 w=4.4u l=0.6u
X3922 user_project_wrapper_0.IOVDD4 user_project_wrapper_0.sg13g2_IOPadIOVdd_2.sg13g2_RCClampResistor_0.p2 user_project_wrapper_0.sg13g2_IOPadIOVdd_2.sg13g2_Clamp_N43N43D4R_0.gate user_project_wrapper_0.IOVDD4 sg13_hv_pmos ad=1.33p pd=7.38u as=1.33p ps=7.38u w=7u l=0.5u
X3923 VDD3 a_296625_189595# a_296731_189665# VDD3 sg13_lv_pmos ad=0.4658p pd=3.42u as=0.2603p ps=1.75u w=1.37u l=0.35u
X3924 a_296731_208493# a_301186_192011# user_project_wrapper_0.IOVSS1 user_project_wrapper_0.IOVSS1 sg13_lv_nmos ad=1.632p pd=10.28u as=0.912p ps=5.18u w=4.8u l=1.06u
X3925 user_project_wrapper_0.analog_io[30] a_194687_324142# user_project_wrapper_0.IOVSS1 user_project_wrapper_0.IOVSS1 sg13_lv_nmos ad=0.912p pd=5.18u as=0.912p ps=5.18u w=4.8u l=0.13u
X3926 VDD3 a_309516_194555# a_309516_194555# VDD3 sg13_lv_pmos ad=0.19p pd=1.38u as=0.19p ps=1.38u w=1u l=0.7u
X3927 user_project_wrapper_0.sg13g2_IOPadVdd_0.sg13g2_RCClampInverter_noptap_0.out user_project_wrapper_0.sg13g2_IOPadVdd_0.sg13g2_RCClampResistor_0.p2 VDD3 VDD3 sg13_hv_pmos ad=1.33p pd=7.38u as=1.33p ps=7.38u w=7u l=0.5u
X3928 a_190814_324870# a_190757_324686# user_project_wrapper_0.IOVSS1 user_project_wrapper_0.IOVSS1 sg13_lv_nmos ad=0.19p pd=1.38u as=0.19p ps=1.38u w=1u l=0.13u
X3929 user_project_wrapper_0.analog_io[34] a_258244_369296# user_project_wrapper_0.IOVSS1 user_project_wrapper_0.IOVSS1 sg13_hv_nmos ad=2.596p pd=5.58u as=1.408p ps=5.04u w=4.4u l=0.6u
X3930 user_project_wrapper_0.IOVSS1 user_project_wrapper_0.IOVSS1 user_project_wrapper_0.IOVSS1 rppd l=0.5u w=0.5u
X3931 a_296731_208493# a_296625_208423# VDD3 VDD3 sg13_lv_pmos ad=0.2603p pd=1.75u as=0.2603p ps=1.75u w=1.37u l=0.35u
X3932 user_project_wrapper_0.IOVSS1 user_project_wrapper_0.sg13g2_IOPadVdd_1.sg13g2_RCClampInverter_noptap_0.out user_project_wrapper_0.VDD2 user_project_wrapper_0.IOVSS1 sg13_hv_nmos ad=1.408p pd=5.04u as=2.596p ps=5.58u w=4.4u l=0.6u
X3933 user_project_wrapper_0.IOVSS1 a_189395_99046# a_189729_99046# user_project_wrapper_0.IOVSS1 sg13_lv_nmos ad=0.2516p pd=2.16u as=0.1406p ps=1.12u w=0.74u l=0.13u
X3934 user_project_wrapper_0.IOVSS1 a_194279_327536# a_194687_324142# user_project_wrapper_0.IOVSS1 sg13_lv_pmos ad=1.824p pd=9.98u as=1.824p ps=9.98u w=9.6u l=0.13u
X3935 a_296731_208493# a_296625_208423# VDD3 VDD3 sg13_lv_pmos ad=0.2603p pd=1.75u as=0.4658p ps=3.42u w=1.37u l=0.35u
X3936 VDD3 a_309516_194555# a_309917_199879# VDD3 sg13_lv_pmos ad=0.34p pd=2.68u as=0.19p ps=1.38u w=1u l=0.7u
X3937 user_project_wrapper_0.IOVDD4 a_258244_355624# user_project_wrapper_0.analog_io[34] user_project_wrapper_0.IOVDD4 sg13_hv_pmos ad=2.1312p pd=7.3u as=3.9294p ps=7.84u w=6.66u l=0.6u
X3938 user_project_wrapper_0.IOVSS1 a_202114_326125# user_project_wrapper_0.analog_io[32] user_project_wrapper_0.IOVSS1 sg13_lv_pmos ad=1.824p pd=9.98u as=1.824p ps=9.98u w=9.6u l=0.13u
X3939 user_project_wrapper_0.IOVSS1 a_194687_324142# user_project_wrapper_0.analog_io[30] user_project_wrapper_0.IOVSS1 sg13_lv_pmos ad=1.824p pd=9.98u as=1.824p ps=9.98u w=9.6u l=0.13u
X3940 a_311846_195517# user_project_wrapper_0.sg13g2_IOPadAnalog_29.padres a_309917_199879# VDD3 sg13_lv_pmos ad=0.24415p pd=1.665u as=0.24415p ps=1.665u w=1.285u l=0.35u
X3941 user_project_wrapper_0.IOVSS1 a_369296_258244# analog_io[25] user_project_wrapper_0.IOVSS1 sg13_hv_nmos ad=1.408p pd=5.04u as=2.596p ps=5.58u w=4.4u l=0.6u
X3942 user_project_wrapper_0.analog_io[35] a_213870_324142# user_project_wrapper_0.IOVSS1 user_project_wrapper_0.IOVSS1 sg13_lv_nmos ad=0.912p pd=5.18u as=0.912p ps=5.18u w=4.8u l=0.13u
X3943 user_project_wrapper_0.analog_io[28] a_135844_369296# user_project_wrapper_0.IOVSS1 user_project_wrapper_0.IOVSS1 sg13_hv_nmos ad=2.596p pd=5.58u as=1.408p ps=5.04u w=4.4u l=0.6u
X3944 VDD3 user_project_wrapper_0.sg13g2_IOPadVdd_0.sg13g2_RCClampInverter_noptap_0.out user_project_wrapper_0.IOVSS1 user_project_wrapper_0.IOVSS1 sg13_hv_nmos ad=2.596p pd=5.58u as=1.408p ps=5.04u w=4.4u l=0.6u
X3945 user_project_wrapper_0.IOVDD1 user_project_wrapper_0.sg13g2_IOPadIOVdd_1.sg13g2_Clamp_N43N43D4R_0.gate user_project_wrapper_0.IOVSS1 user_project_wrapper_0.IOVSS1 sg13_hv_nmos ad=2.596p pd=5.58u as=1.408p ps=5.04u w=4.4u l=0.6u
X3946 user_project_wrapper_0.IOVSS1 a_176644_29676# user_project_wrapper_0.analog_io[12] user_project_wrapper_0.IOVSS1 sg13_hv_nmos ad=1.408p pd=5.04u as=2.596p ps=5.58u w=4.4u l=0.6u
X3947 a_296731_189665# a_296625_189595# VDD3 VDD3 sg13_lv_pmos ad=0.2603p pd=1.75u as=0.2603p ps=1.75u w=1.37u l=0.35u
X3948 user_project_wrapper_0.analog_io[4] a_41476_197044# user_project_wrapper_0.IOVDD1 user_project_wrapper_0.IOVDD1 sg13_hv_pmos ad=3.9294p pd=7.84u as=2.1312p ps=7.3u w=6.66u l=0.6u
X3949 user_project_wrapper_0.IOVSS1 user_project_wrapper_0.sg13g2_IOPadVdd_3.sg13g2_RCClampInverter_noptap_0.out user_project_wrapper_0.IOVSS1 user_project_wrapper_0.IOVSS1 sg13_hv_nmos ad=2.596p pd=5.58u as=0 ps=0 w=4.4u l=0.6u
X3950 user_project_wrapper_0.IOVSS1 a_205385_326221# a_202114_326125# user_project_wrapper_0.IOVSS1 sg13_lv_pmos ad=1.824p pd=9.98u as=1.824p ps=9.98u w=9.6u l=0.13u
X3951 user_project_wrapper_0.IOVDD2 a_176644_41476# user_project_wrapper_0.analog_io[12] user_project_wrapper_0.IOVDD2 sg13_hv_pmos ad=2.1312p pd=7.3u as=3.9294p ps=7.84u w=6.66u l=0.6u
X3952 user_project_wrapper_0.analog_io[30] a_194687_324142# user_project_wrapper_0.IOVSS1 user_project_wrapper_0.IOVSS1 sg13_lv_nmos ad=0.912p pd=5.18u as=0.912p ps=5.18u w=4.8u l=0.13u
X3953 a_304196_200821# a_304889_199957# a_304995_198817# user_project_wrapper_0.IOVSS1 sg13_lv_nmos ad=0.209p pd=1.48u as=0.209p ps=1.48u w=1.1u l=0.15u
X3954 user_project_wrapper_0.IOVSS1 user_project_wrapper_0.sg13g2_IOPadOut4mA$1_1.c2p a_58798_281249# user_project_wrapper_0.IOVSS1 sg13_lv_nmos ad=0.935p pd=6.18u as=0.935p ps=6.18u w=2.75u l=0.13u
X3955 user_project_wrapper_0.IOVSS1 user_project_wrapper_0.sg13g2_IOPadVdd_3.sg13g2_RCClampResistor_0.p2 user_project_wrapper_0.IOVSS1 user_project_wrapper_0.IOVSS1 sg13_hv_nmos ad=1.71p pd=9.38u as=0 ps=0 w=9u l=9.5u
X3956 user_project_wrapper_0.sg13g2_IOPadVdd_1.sg13g2_RCClampInverter_noptap_0.out user_project_wrapper_0.sg13g2_IOPadVdd_1.sg13g2_RCClampResistor_0.p2 user_project_wrapper_0.VDD2 user_project_wrapper_0.VDD2 sg13_hv_pmos ad=1.33p pd=7.38u as=1.33p ps=7.38u w=7u l=0.5u
X3957 a_360372_305365# a_364458_305695# user_project_wrapper_0.IOVSS1 rppd l=20u w=1u
X3958 user_project_wrapper_0.analog_io[6] a_41476_237844# user_project_wrapper_0.IOVDD1 user_project_wrapper_0.IOVDD1 sg13_hv_pmos ad=3.9294p pd=7.84u as=2.1312p ps=7.3u w=6.66u l=0.6u
X3959 user_project_wrapper_0.IOVSS1 user_project_wrapper_0.sg13g2_IOPadVdd_3.sg13g2_RCClampInverter_noptap_0.out user_project_wrapper_0.IOVSS1 user_project_wrapper_0.IOVSS1 sg13_hv_nmos ad=2.596p pd=5.58u as=0 ps=0 w=4.4u l=0.6u
X3960 user_project_wrapper_0.IOVSS1 a_190389_99046# user_project_wrapper_0.analog_io[14] user_project_wrapper_0.IOVSS1 sg13_lv_nmos ad=0.1406p pd=1.12u as=0.1406p ps=1.12u w=0.74u l=0.13u
X3961 user_project_wrapper_0.analog_io[30] a_176644_369296# user_project_wrapper_0.IOVSS1 user_project_wrapper_0.IOVSS1 sg13_hv_nmos ad=2.596p pd=5.58u as=1.408p ps=5.04u w=4.4u l=0.6u
X3962 user_project_wrapper_0.IOVSS1 a_190297_329719# a_190926_330241# w_188700_330166# sg13_lv_pmos ad=0.68p pd=4.68u as=0.38p ps=2.38u w=2u l=0.13u
X3963 a_76675_364458# a_76345_360372# user_project_wrapper_0.IOVSS1 rppd l=20u w=1u
X3964 user_project_wrapper_0.IOVDD2 user_project_wrapper_0.sg13g2_IOPadIOVdd_0.sg13g2_RCClampResistor_0.p2 user_project_wrapper_0.sg13g2_IOPadIOVdd_0.sg13g2_Clamp_N43N43D4R_0.gate user_project_wrapper_0.IOVDD2 sg13_hv_pmos ad=1.33p pd=7.38u as=1.33p ps=7.38u w=7u l=0.5u
X3965 user_project_wrapper_0.IOVSS1 a_210417_325263# a_210621_325263# user_project_wrapper_0.IOVSS1 sg13_lv_nmos ad=0.19p pd=1.38u as=0.19p ps=1.38u w=1u l=0.13u
X3966 user_project_wrapper_0.sg13g2_IOPadVdd_2.sg13g2_RCClampInverter_noptap_0.out user_project_wrapper_0.sg13g2_IOPadVdd_2.sg13g2_RCClampResistor_0.p2 user_project_wrapper_0.VDD1 user_project_wrapper_0.VDD1 sg13_hv_pmos ad=1.33p pd=7.38u as=1.33p ps=7.38u w=7u l=0.5u
X3967 VDD3 a_296625_189595# a_296731_189665# VDD3 sg13_lv_pmos ad=0.2603p pd=1.75u as=0.2603p ps=1.75u w=1.37u l=0.35u
X3968 user_project_wrapper_0.analog_io[28] a_135844_355624# user_project_wrapper_0.IOVDD4 user_project_wrapper_0.IOVDD4 sg13_hv_pmos ad=3.9294p pd=7.84u as=2.1312p ps=7.3u w=6.66u l=0.6u
X3969 user_project_wrapper_0.IOVSS1 user_project_wrapper_0.sg13g2_IOPadVdd_2.sg13g2_RCClampInverter_noptap_0.out user_project_wrapper_0.VDD1 user_project_wrapper_0.IOVSS1 sg13_hv_nmos ad=1.408p pd=5.04u as=2.596p ps=5.58u w=4.4u l=0.6u
X3970 user_project_wrapper_0.VDD1 a_82645_240231# a_82846_240684# user_project_wrapper_0.VDD1 sg13_lv_pmos ad=1.7p pd=10.68u as=0.95p ps=5.38u w=5u l=0.15u
X3971 VDD3 a_309516_194555# a_309917_194695# VDD3 sg13_lv_pmos ad=0.19p pd=1.38u as=0.19p ps=1.38u w=1u l=0.7u
X3972 user_project_wrapper_0.IOVSS1 a_190686_324119# a_190455_324119# w_188806_323975# sg13_lv_pmos ad=0.38p pd=2.38u as=0.68p ps=4.68u w=2u l=0.13u
X3973 a_309917_199879# a_309516_194555# VDD3 VDD3 sg13_lv_pmos ad=0.19p pd=1.38u as=0.19p ps=1.38u w=1u l=0.7u
X3974 a_210007_329719# a_209684_329719# a_209905_330241# w_207883_330166# sg13_lv_pmos ad=0.38p pd=2.38u as=0.38p ps=2.38u w=2u l=0.13u
X3975 user_project_wrapper_0.analog_io[35] a_213870_324142# user_project_wrapper_0.IOVSS1 user_project_wrapper_0.IOVSS1 sg13_lv_nmos ad=0.912p pd=5.18u as=0.912p ps=5.18u w=4.8u l=0.13u
X3976 a_209480_326377# a_208939_326377# user_project_wrapper_0.IOVSS1 user_project_wrapper_0.IOVSS1 sg13_lv_nmos ad=0.34p pd=2.68u as=0.34p ps=2.68u w=1u l=0.13u
X3977 QDLL_TOP_0.VDD a_269355_100412# a_269543_100118# QDLL_TOP_0.VDD sg13_lv_pmos ad=0.2481p pd=1.56u as=0.1428p ps=1.52u w=0.42u l=0.13u
X3978 user_project_wrapper_0.IOVSS1 user_project_wrapper_0.sg13g2_IOPadVdd_3.sg13g2_RCClampInverter_noptap_0.out user_project_wrapper_0.IOVSS1 user_project_wrapper_0.IOVSS1 sg13_hv_nmos ad=2.068p pd=9.74u as=0 ps=0 w=4.4u l=0.6u
X3979 user_project_wrapper_0.IOVSS1 user_project_wrapper_0.sg13g2_IOPadIOVdd_3.sg13g2_Clamp_N43N43D4R_0.gate IOVDD3 user_project_wrapper_0.IOVSS1 sg13_hv_nmos ad=1.408p pd=5.04u as=2.596p ps=5.58u w=4.4u l=0.6u
X3980 user_project_wrapper_0.analog_io[33] a_237844_355624# user_project_wrapper_0.IOVDD4 user_project_wrapper_0.IOVDD4 sg13_hv_pmos ad=3.9294p pd=7.84u as=2.1312p ps=7.3u w=6.66u l=0.6u
X3981 a_313884_211353# a_296731_208493# a_311189_211724# user_project_wrapper_0.IOVSS1 sg13_lv_nmos ad=1.9p pd=10.38u as=1.9p ps=10.38u w=10u l=0.5u
X3982 user_project_wrapper_0.IOVSS1 user_project_wrapper_0.sg13g2_IOPadVdd_3.sg13g2_RCClampInverter_noptap_0.out user_project_wrapper_0.IOVSS1 user_project_wrapper_0.IOVSS1 sg13_hv_nmos ad=1.408p pd=5.04u as=0 ps=0 w=4.4u l=0.6u
X3983 a_83079_128838# a_79025_136081# user_project_wrapper_0.VDD1 user_project_wrapper_0.VDD1 sg13_lv_pmos ad=0.3808p pd=2.92u as=0.3808p ps=2.92u w=1.12u l=0.13u
X3984 user_project_wrapper_0.IOVSS1 a_369296_176644# analog_io[20] user_project_wrapper_0.IOVSS1 sg13_hv_nmos ad=1.408p pd=5.04u as=2.596p ps=5.58u w=4.4u l=0.6u
X3985 analog_io[23] a_369296_237844# user_project_wrapper_0.IOVSS1 user_project_wrapper_0.IOVSS1 sg13_hv_nmos ad=2.596p pd=5.58u as=1.408p ps=5.04u w=4.4u l=0.6u
X3986 user_project_wrapper_0.analog_io[6] a_41476_237844# user_project_wrapper_0.IOVDD1 user_project_wrapper_0.IOVDD1 sg13_hv_pmos ad=3.9294p pd=7.84u as=2.1312p ps=7.3u w=6.66u l=0.6u
X3987 user_project_wrapper_0.IOVDD4 a_217444_355624# user_project_wrapper_0.analog_io[32] user_project_wrapper_0.IOVDD4 sg13_hv_pmos ad=2.1312p pd=7.3u as=3.9294p ps=7.84u w=6.66u l=0.6u
X3988 a_186731_92558# a_187294_90472# user_project_wrapper_0.IOVSS1 rppd l=10u w=1u
X3989 user_project_wrapper_0.analog_io[27] a_182931_326125# user_project_wrapper_0.IOVSS1 user_project_wrapper_0.IOVSS1 sg13_lv_pmos ad=1.824p pd=9.98u as=1.824p ps=9.98u w=9.6u l=0.13u
X3990 a_73375_364458# a_73705_360372# user_project_wrapper_0.IOVSS1 rppd l=20u w=1u
X3991 user_project_wrapper_0.VDD2 user_project_wrapper_0.sg13g2_IOPadVdd_1.sg13g2_RCClampResistor_0.p2 user_project_wrapper_0.sg13g2_IOPadVdd_1.sg13g2_RCClampInverter_noptap_0.out user_project_wrapper_0.VDD2 sg13_hv_pmos ad=1.33p pd=7.38u as=1.33p ps=7.38u w=7u l=0.5u
X3992 user_project_wrapper_0.IOVSS1 user_project_wrapper_0.sg13g2_IOPadVdd_0.sg13g2_RCClampInverter_noptap_0.out VDD3 user_project_wrapper_0.IOVSS1 sg13_hv_nmos ad=1.408p pd=5.04u as=2.596p ps=5.58u w=4.4u l=0.6u
X3993 analog_io[23] a_311108_215937# VDD3 user_project_wrapper_0.IOVSS1 sg13_lv_nmos ad=3.4p pd=20.68u as=3.4p ps=20.68u w=10u l=0.15u
X3994 user_project_wrapper_0.IOVSS1 user_project_wrapper_0.sg13g2_IOPadVdd_3.sg13g2_RCClampInverter_noptap_0.out user_project_wrapper_0.IOVSS1 user_project_wrapper_0.IOVSS1 sg13_hv_nmos ad=2.596p pd=5.58u as=0 ps=0 w=4.4u l=0.6u
X3995 user_project_wrapper_0.IOVDD2 a_176644_41476# user_project_wrapper_0.analog_io[12] user_project_wrapper_0.IOVDD2 sg13_hv_pmos ad=2.1312p pd=7.3u as=3.9294p ps=7.84u w=6.66u l=0.6u
X3996 user_project_wrapper_0.IOVSS1 a_194279_327536# a_194687_324142# user_project_wrapper_0.IOVSS1 sg13_lv_nmos ad=0.912p pd=5.18u as=0.912p ps=5.18u w=4.8u l=0.13u
X3997 user_project_wrapper_0.VDD1 user_project_wrapper_0.sg13g2_IOPadVdd_2.sg13g2_RCClampInverter_noptap_0.out user_project_wrapper_0.IOVSS1 user_project_wrapper_0.IOVSS1 sg13_hv_nmos ad=2.596p pd=5.58u as=1.408p ps=5.04u w=4.4u l=0.6u
X3998 user_project_wrapper_0.analog_io[11] a_156244_29676# user_project_wrapper_0.IOVSS1 user_project_wrapper_0.IOVSS1 sg13_hv_nmos ad=2.596p pd=5.58u as=2.068p ps=9.74u w=4.4u l=0.6u
X3999 a_309917_194695# a_309516_194555# VDD3 VDD3 sg13_lv_pmos ad=0.19p pd=1.38u as=0.19p ps=1.38u w=1u l=0.7u
X4000 VDD3 a_309516_194555# a_309917_194695# VDD3 sg13_lv_pmos ad=0.19p pd=1.38u as=0.19p ps=1.38u w=1u l=0.7u
X4001 user_project_wrapper_0.analog_io[7] a_29676_258244# user_project_wrapper_0.IOVSS1 user_project_wrapper_0.IOVSS1 sg13_hv_nmos ad=2.596p pd=5.58u as=1.408p ps=5.04u w=4.4u l=0.6u
X4002 user_project_wrapper_0.analog_io[35] a_278644_355624# user_project_wrapper_0.IOVDD4 user_project_wrapper_0.IOVDD4 sg13_hv_pmos ad=3.9294p pd=7.84u as=2.1312p ps=7.3u w=6.66u l=0.6u
X4003 user_project_wrapper_0.analog_io[30] a_176644_369296# user_project_wrapper_0.IOVSS1 user_project_wrapper_0.IOVSS1 sg13_hv_nmos ad=2.596p pd=5.58u as=1.408p ps=5.04u w=4.4u l=0.6u
X4004 analog_io[18] a_355624_115444# IOVDD3 IOVDD3 sg13_hv_pmos ad=3.9294p pd=7.84u as=2.1312p ps=7.3u w=6.66u l=0.6u
X4005 a_305035_364458# a_305365_360372# user_project_wrapper_0.IOVSS1 rppd l=20u w=1u
X4006 user_project_wrapper_0.IOVDD2 a_135844_41476# user_project_wrapper_0.analog_io[10] user_project_wrapper_0.IOVDD2 sg13_hv_pmos ad=2.1312p pd=7.3u as=3.9294p ps=7.84u w=6.66u l=0.6u
X4007 user_project_wrapper_0.IOVSS1 a_202114_326125# user_project_wrapper_0.analog_io[32] user_project_wrapper_0.IOVSS1 sg13_lv_nmos ad=0.912p pd=5.18u as=0.912p ps=5.18u w=4.8u l=0.13u
X4008 user_project_wrapper_0.VDD1 user_project_wrapper_0.sg13g2_IOPadVdd_2.sg13g2_RCClampInverter_noptap_0.out user_project_wrapper_0.IOVSS1 user_project_wrapper_0.IOVSS1 sg13_hv_nmos ad=2.596p pd=5.58u as=1.408p ps=5.04u w=4.4u l=0.6u
X4009 user_project_wrapper_0.IOVDD1 user_project_wrapper_0.sg13g2_IOPadIOVdd_1.sg13g2_RCClampResistor_0.p2 user_project_wrapper_0.sg13g2_IOPadIOVdd_1.sg13g2_Clamp_N43N43D4R_0.gate user_project_wrapper_0.IOVDD1 sg13_hv_pmos ad=1.33p pd=7.38u as=1.33p ps=7.38u w=7u l=0.5u
X4010 a_85211_124842# a_84332_125209# user_project_wrapper_0.VDD1 user_project_wrapper_0.VDD1 sg13_lv_pmos ad=0.3808p pd=2.92u as=0.3808p ps=2.92u w=1.12u l=0.13u
X4011 user_project_wrapper_0.IOVDD4 a_135844_355624# user_project_wrapper_0.analog_io[28] user_project_wrapper_0.IOVDD4 sg13_hv_pmos ad=3.1302p pd=14.26u as=3.9294p ps=7.84u w=6.66u l=0.6u
X4012 VDD3 user_project_wrapper_0.sg13g2_IOPadVdd_0.sg13g2_RCClampInverter_noptap_0.out user_project_wrapper_0.IOVSS1 user_project_wrapper_0.IOVSS1 sg13_hv_nmos ad=2.596p pd=5.58u as=1.408p ps=5.04u w=4.4u l=0.6u
X4013 user_project_wrapper_0.sg13g2_IOPadVdd_2.sg13g2_RCClampInverter_noptap_0.out user_project_wrapper_0.sg13g2_IOPadVdd_2.sg13g2_RCClampResistor_0.p2 user_project_wrapper_0.IOVSS1 user_project_wrapper_0.IOVSS1 sg13_hv_nmos ad=1.71p pd=9.38u as=1.71p ps=9.38u w=9u l=0.5u
X4014 user_project_wrapper_0.IOVSS1 a_369296_258244# analog_io[25] user_project_wrapper_0.IOVSS1 sg13_hv_nmos ad=1.408p pd=5.04u as=2.596p ps=5.58u w=4.4u l=0.6u
X4015 user_project_wrapper_0.IOVSS1 user_project_wrapper_0.analog_io[27] dantenna l=1.26u w=27.78u
X4016 user_project_wrapper_0.IOVDD1 user_project_wrapper_0.sg13g2_IOPadIOVdd_1.sg13g2_Clamp_N43N43D4R_0.gate user_project_wrapper_0.IOVSS1 user_project_wrapper_0.IOVSS1 sg13_hv_nmos ad=2.596p pd=5.58u as=1.408p ps=5.04u w=4.4u l=0.6u
X4017 user_project_wrapper_0.IOVSS1 user_project_wrapper_0.sg13g2_IOPadVdd_0.sg13g2_RCClampResistor_0.p2 user_project_wrapper_0.sg13g2_IOPadVdd_0.sg13g2_RCClampInverter_noptap_0.out user_project_wrapper_0.IOVSS1 sg13_hv_nmos ad=1.71p pd=9.38u as=1.71p ps=9.38u w=9u l=0.5u
X4018 IOVDD3 a_355624_176644# analog_io[20] IOVDD3 sg13_hv_pmos ad=2.1312p pd=7.3u as=3.9294p ps=7.84u w=6.66u l=0.6u
X4019 analog_io[23] a_355624_237844# IOVDD3 IOVDD3 sg13_hv_pmos ad=3.9294p pd=7.84u as=2.1312p ps=7.3u w=6.66u l=0.6u
X4020 QDLL_TOP_0.VOUT a_271172_100118# QDLL_TOP_0.VDD QDLL_TOP_0.VDD sg13_lv_pmos ad=0.2128p pd=1.5u as=0.4368p ps=3.02u w=1.12u l=0.13u
X4021 VDD3 a_309516_194555# a_309917_194695# VDD3 sg13_lv_pmos ad=0.19p pd=1.38u as=0.19p ps=1.38u w=1u l=0.7u
X4022 a_311108_179669# analog_io[20] a_313884_185173# user_project_wrapper_0.IOVSS1 sg13_lv_nmos ad=1.9p pd=10.38u as=1.9p ps=10.38u w=10u l=0.5u
X4023 a_296732_200582# a_301940_196388# a_296625_208423# VDD3 sg13_lv_pmos ad=1.377p pd=8.78u as=0.7695p ps=4.43u w=4.05u l=0.5u
X4024 VDD3 a_309516_194555# a_309917_199879# VDD3 sg13_lv_pmos ad=0.19p pd=1.38u as=0.19p ps=1.38u w=1u l=0.7u
X4025 user_project_wrapper_0.IOVSS1 user_project_wrapper_0.sg13g2_IOPadVdd_2.sg13g2_RCClampInverter_noptap_0.out user_project_wrapper_0.VDD1 user_project_wrapper_0.IOVSS1 sg13_hv_nmos ad=1.408p pd=5.04u as=2.596p ps=5.58u w=4.4u l=0.6u
X4026 a_189190_110495# a_189748_108410# user_project_wrapper_0.IOVSS1 rppd l=10u w=1u
X4027 user_project_wrapper_0.IOVDD4 a_176644_355624# user_project_wrapper_0.analog_io[30] user_project_wrapper_0.IOVDD4 sg13_hv_pmos ad=2.1312p pd=7.3u as=3.9294p ps=7.84u w=6.66u l=0.6u
X4028 user_project_wrapper_0.sg13g2_IOPadIOVdd_3.sg13g2_Clamp_N43N43D4R_0.gate user_project_wrapper_0.sg13g2_IOPadIOVdd_3.sg13g2_RCClampResistor_0.p2 user_project_wrapper_0.IOVSS1 user_project_wrapper_0.IOVSS1 sg13_hv_nmos ad=1.71p pd=9.38u as=1.71p ps=9.38u w=9u l=0.5u
X4029 user_project_wrapper_0.IOVSS1 a_258244_369296# user_project_wrapper_0.analog_io[34] user_project_wrapper_0.IOVSS1 sg13_hv_nmos ad=1.408p pd=5.04u as=2.596p ps=5.58u w=4.4u l=0.6u
X4030 user_project_wrapper_0.analog_io[29] user_project_wrapper_0.sg13g2_IOPadAnalog_17.padres user_project_wrapper_0.IOVSS1 rppd l=2u w=1u
X4031 user_project_wrapper_0.sg13g2_IOPadVdd_0.sg13g2_RCClampInverter_noptap_0.out user_project_wrapper_0.sg13g2_IOPadVdd_0.sg13g2_RCClampResistor_0.p2 VDD3 VDD3 sg13_hv_pmos ad=1.33p pd=7.38u as=1.33p ps=7.38u w=7u l=0.5u
X4032 VDD3 user_project_wrapper_0.sg13g2_IOPadVdd_0.sg13g2_RCClampInverter_noptap_0.out user_project_wrapper_0.IOVSS1 user_project_wrapper_0.IOVSS1 sg13_hv_nmos ad=2.596p pd=5.58u as=1.408p ps=5.04u w=4.4u l=0.6u
X4033 user_project_wrapper_0.IOVSS1 a_209480_329719# a_210109_330241# w_207883_330166# sg13_lv_pmos ad=0.68p pd=4.68u as=0.38p ps=2.38u w=2u l=0.13u
X4034 IOVDD3 a_355624_278644# analog_io[26] IOVDD3 sg13_hv_pmos ad=2.1312p pd=7.3u as=3.9294p ps=7.84u w=6.66u l=0.6u
X4035 user_project_wrapper_0.uo_PAD[8] user_project_wrapper_0.IOVDD1 dpantenna l=27.78u w=1.26u
X4036 user_project_wrapper_0.IOVSS1 user_project_wrapper_0.analog_io[0] dantenna l=27.78u w=1.26u
X4037 a_315347_192648# a_314793_201808# a_314697_196700# user_project_wrapper_0.IOVSS1 sg13_lv_nmos ad=1.14p pd=6.38u as=1.14p ps=6.38u w=6u l=6.4u
X4038 user_project_wrapper_0.IOVSS1 a_190389_101343# user_project_wrapper_0.analog_io[15] user_project_wrapper_0.IOVSS1 sg13_lv_nmos ad=0.1406p pd=1.12u as=0.1406p ps=1.12u w=0.74u l=0.13u
X4039 user_project_wrapper_0.IOVSS1 a_194687_324142# user_project_wrapper_0.analog_io[30] user_project_wrapper_0.IOVSS1 sg13_lv_nmos ad=0.912p pd=5.18u as=0.912p ps=5.18u w=4.8u l=0.13u
X4040 a_304196_200821# a_304090_197941# a_296625_208423# user_project_wrapper_0.IOVSS1 sg13_lv_nmos ad=0.361p pd=2.28u as=0.361p ps=2.28u w=1.9u l=0.16u
X4041 user_project_wrapper_0.IOVSS1 user_project_wrapper_0.sg13g2_IOPadIOVdd_2.sg13g2_RCClampResistor_0.p2 user_project_wrapper_0.IOVSS1 user_project_wrapper_0.IOVSS1 sg13_hv_nmos ad=1.71p pd=9.38u as=0 ps=0 w=9u l=9.5u
X4042 user_project_wrapper_0.IOVSS1 user_project_wrapper_0.sg13g2_IOPadVdd_2.sg13g2_RCClampInverter_noptap_0.out user_project_wrapper_0.VDD1 user_project_wrapper_0.IOVSS1 sg13_hv_nmos ad=1.408p pd=5.04u as=2.596p ps=5.58u w=4.4u l=0.6u
X4043 analog_io[23] a_311108_215937# VDD3 user_project_wrapper_0.IOVSS1 sg13_lv_nmos ad=3.4p pd=20.68u as=3.4p ps=20.68u w=10u l=0.15u
X4044 a_304196_200821# a_304889_199957# a_304995_198817# user_project_wrapper_0.IOVSS1 sg13_lv_nmos ad=0.209p pd=1.48u as=0.374p ps=2.88u w=1.1u l=0.15u
X4045 a_304196_197873# a_304889_198885# a_304995_198817# user_project_wrapper_0.IOVSS1 sg13_lv_nmos ad=0.209p pd=1.48u as=0.209p ps=1.48u w=1.1u l=0.15u
X4046 user_project_wrapper_0.IOVSS1 a_206201_328627# a_205385_326221# user_project_wrapper_0.IOVSS1 sg13_lv_nmos ad=1.632p pd=10.28u as=0.912p ps=5.18u w=4.8u l=0.13u
X4047 user_project_wrapper_0.analog_io[35] a_278644_355624# user_project_wrapper_0.IOVDD4 user_project_wrapper_0.IOVDD4 sg13_hv_pmos ad=3.9294p pd=7.84u as=2.1312p ps=7.3u w=6.66u l=0.6u
X4048 user_project_wrapper_0.analog_io[14] a_217444_41476# user_project_wrapper_0.IOVDD2 user_project_wrapper_0.IOVDD2 sg13_hv_pmos ad=3.9294p pd=7.84u as=2.1312p ps=7.3u w=6.66u l=0.6u
X4049 user_project_wrapper_0.VDD2 user_project_wrapper_0.sg13g2_IOPadVdd_1.sg13g2_RCClampInverter_noptap_0.out user_project_wrapper_0.IOVSS1 user_project_wrapper_0.IOVSS1 sg13_hv_nmos ad=2.596p pd=5.58u as=1.408p ps=5.04u w=4.4u l=0.6u
X4050 user_project_wrapper_0.IOVDD1 a_41476_115444# user_project_wrapper_0.analog_io[0] user_project_wrapper_0.IOVDD1 sg13_hv_pmos ad=2.1312p pd=7.3u as=3.9294p ps=7.84u w=6.66u l=0.6u
X4051 user_project_wrapper_0.sg13g2_IOPadIOVdd_3.sg13g2_Clamp_N43N43D4R_0.gate user_project_wrapper_0.sg13g2_IOPadIOVdd_3.sg13g2_RCClampResistor_0.p2 user_project_wrapper_0.IOVSS1 user_project_wrapper_0.IOVSS1 sg13_hv_nmos ad=1.71p pd=9.38u as=1.71p ps=9.38u w=9u l=0.5u
X4052 a_296731_208493# a_296625_208423# VDD3 VDD3 sg13_lv_pmos ad=0.2603p pd=1.75u as=0.2603p ps=1.75u w=1.37u l=0.35u
X4053 user_project_wrapper_0.IOVSS1 user_project_wrapper_0.sg13g2_IOPadVdd_0.sg13g2_RCClampInverter_noptap_0.out VDD3 user_project_wrapper_0.IOVSS1 sg13_hv_nmos ad=1.408p pd=5.04u as=2.596p ps=5.58u w=4.4u l=0.6u
X4054 IOVDD3 user_project_wrapper_0.sg13g2_IOPadIOVdd_3.sg13g2_Clamp_N43N43D4R_0.gate user_project_wrapper_0.IOVSS1 user_project_wrapper_0.IOVSS1 sg13_hv_nmos ad=2.596p pd=5.58u as=1.408p ps=5.04u w=4.4u l=0.6u
X4055 user_project_wrapper_0.analog_io[11] a_156244_41476# user_project_wrapper_0.IOVDD2 user_project_wrapper_0.IOVDD2 sg13_hv_pmos ad=3.9294p pd=7.84u as=2.1312p ps=7.3u w=6.66u l=0.6u
X4056 user_project_wrapper_0.IOVSS1 user_project_wrapper_0.sg13g2_IOPadVdd_3.sg13g2_RCClampInverter_noptap_0.out user_project_wrapper_0.IOVSS1 user_project_wrapper_0.IOVSS1 sg13_hv_nmos ad=1.408p pd=5.04u as=0 ps=0 w=4.4u l=0.6u
X4057 user_project_wrapper_0.IOVSS1 a_194279_327536# a_194687_324142# user_project_wrapper_0.IOVSS1 sg13_lv_pmos ad=1.824p pd=9.98u as=1.824p ps=9.98u w=9.6u l=0.13u
X4058 a_309516_194555# a_309516_194555# VDD3 VDD3 sg13_lv_pmos ad=0.19p pd=1.38u as=0.19p ps=1.38u w=1u l=0.7u
X4059 user_project_wrapper_0.IOVSS1 user_project_wrapper_0.sg13g2_IOPadIOVdd_1.sg13g2_Clamp_N43N43D4R_0.gate user_project_wrapper_0.IOVDD1 user_project_wrapper_0.IOVSS1 sg13_hv_nmos ad=1.408p pd=5.04u as=2.596p ps=5.58u w=4.4u l=0.6u
X4060 user_project_wrapper_0.VDD2 user_project_wrapper_0.sg13g2_IOPadVdd_1.sg13g2_RCClampInverter_noptap_0.out user_project_wrapper_0.IOVSS1 user_project_wrapper_0.IOVSS1 sg13_hv_nmos ad=2.596p pd=5.58u as=1.408p ps=5.04u w=4.4u l=0.6u
X4061 user_project_wrapper_0.IOVDD4 user_project_wrapper_0.sg13g2_IOPadIOVdd_2.sg13g2_Clamp_N43N43D4R_0.gate user_project_wrapper_0.IOVSS1 user_project_wrapper_0.IOVSS1 sg13_hv_nmos ad=3.256p pd=10.28u as=1.408p ps=5.04u w=4.4u l=0.6u
X4062 user_project_wrapper_0.IOVSS1 user_project_wrapper_0.sg13g2_IOPadVdd_0.sg13g2_RCClampInverter_noptap_0.out VDD3 user_project_wrapper_0.IOVSS1 sg13_hv_nmos ad=1.408p pd=5.04u as=2.596p ps=5.58u w=4.4u l=0.6u
X4063 user_project_wrapper_0.IOVSS1 user_project_wrapper_0.sg13g2_IOPadVdd_2.sg13g2_RCClampInverter_noptap_0.out user_project_wrapper_0.VDD1 user_project_wrapper_0.IOVSS1 sg13_hv_nmos ad=1.408p pd=5.04u as=2.596p ps=5.58u w=4.4u l=0.6u
X4064 a_35456_76015# a_39542_76345# user_project_wrapper_0.IOVSS1 rppd l=20u w=1u
X4065 analog_io[19] a_355624_135844# IOVDD3 IOVDD3 sg13_hv_pmos ad=3.9294p pd=7.84u as=2.1312p ps=7.3u w=6.66u l=0.6u
X4066 user_project_wrapper_0.IOVDD1 user_project_wrapper_0.sg13g2_IOPadIOVdd_1.sg13g2_Clamp_N43N43D4R_0.gate user_project_wrapper_0.IOVSS1 user_project_wrapper_0.IOVSS1 sg13_hv_nmos ad=2.596p pd=5.58u as=1.408p ps=5.04u w=4.4u l=0.6u
X4067 user_project_wrapper_0.IOVDD1 user_project_wrapper_0.sg13g2_IOPadIOVdd_1.sg13g2_RCClampResistor_0.p2 user_project_wrapper_0.sg13g2_IOPadIOVdd_1.sg13g2_Clamp_N43N43D4R_0.gate user_project_wrapper_0.IOVDD1 sg13_hv_pmos ad=1.33p pd=7.38u as=1.33p ps=7.38u w=7u l=0.5u
X4068 user_project_wrapper_0.IOVDD2 user_project_wrapper_0.sg13g2_IOPadIOVdd_0.sg13g2_Clamp_N43N43D4R_0.gate user_project_wrapper_0.IOVSS1 user_project_wrapper_0.IOVSS1 sg13_hv_nmos ad=2.596p pd=5.58u as=1.408p ps=5.04u w=4.4u l=0.6u
X4069 user_project_wrapper_0.VDD2 user_project_wrapper_0.sg13g2_IOPadVdd_1.sg13g2_RCClampInverter_noptap_0.out user_project_wrapper_0.IOVSS1 user_project_wrapper_0.IOVSS1 sg13_hv_nmos ad=2.596p pd=5.58u as=1.408p ps=5.04u w=4.4u l=0.6u
X4070 user_project_wrapper_0.IOVSS1 user_project_wrapper_0.sg13g2_IOPadVdd_3.sg13g2_RCClampInverter_noptap_0.out user_project_wrapper_0.IOVSS1 user_project_wrapper_0.IOVSS1 sg13_hv_nmos ad=2.596p pd=5.58u as=0 ps=0 w=4.4u l=0.6u
X4071 user_project_wrapper_0.IOVSS1 a_176644_369296# user_project_wrapper_0.analog_io[30] user_project_wrapper_0.IOVSS1 sg13_hv_nmos ad=1.408p pd=5.04u as=2.596p ps=5.58u w=4.4u l=0.6u
X4072 user_project_wrapper_0.analog_io[29] a_156244_355624# user_project_wrapper_0.IOVDD4 user_project_wrapper_0.IOVDD4 sg13_hv_pmos ad=3.9294p pd=7.84u as=2.1312p ps=7.3u w=6.66u l=0.6u
X4073 user_project_wrapper_0.IOVSS1 a_202114_326125# user_project_wrapper_0.analog_io[32] user_project_wrapper_0.IOVSS1 sg13_lv_pmos ad=1.824p pd=9.98u as=1.824p ps=9.98u w=9.6u l=0.13u
X4074 user_project_wrapper_0.VDD1 user_project_wrapper_0.sg13g2_IOPadVdd_2.sg13g2_RCClampInverter_noptap_0.out user_project_wrapper_0.IOVSS1 user_project_wrapper_0.IOVSS1 sg13_hv_nmos ad=2.596p pd=5.58u as=1.408p ps=5.04u w=4.4u l=0.6u
X4075 user_project_wrapper_0.analog_io[14] a_190389_99046# QDLL_TOP_0.VDD QDLL_TOP_0.VDD sg13_lv_pmos ad=0.2128p pd=1.5u as=0.2128p ps=1.5u w=1.12u l=0.13u
X4076 a_304995_198817# a_307232_196607# user_project_wrapper_0.IOVSS1 user_project_wrapper_0.IOVSS1 sg13_lv_nmos ad=0.6327p pd=3.71u as=0.6327p ps=3.71u w=3.33u l=0.2u
X4077 a_190389_99046# a_189729_99046# QDLL_TOP_0.VDD QDLL_TOP_0.VDD sg13_lv_pmos ad=0.2184p pd=1.51u as=0.2128p ps=1.5u w=1.12u l=0.13u
X4078 user_project_wrapper_0.IOVSS1 a_194687_324142# user_project_wrapper_0.analog_io[30] user_project_wrapper_0.IOVSS1 sg13_lv_pmos ad=1.824p pd=9.98u as=1.824p ps=9.98u w=9.6u l=0.13u
X4079 user_project_wrapper_0.analog_io[32] a_217444_355624# user_project_wrapper_0.IOVDD4 user_project_wrapper_0.IOVDD4 sg13_hv_pmos ad=3.9294p pd=7.84u as=2.1312p ps=7.3u w=6.66u l=0.6u
X4080 user_project_wrapper_0.IOVDD4 a_135844_355624# user_project_wrapper_0.analog_io[28] user_project_wrapper_0.IOVDD4 sg13_hv_pmos ad=2.1312p pd=7.3u as=3.9294p ps=7.84u w=6.66u l=0.6u
X4081 user_project_wrapper_0.IOVSS1 user_project_wrapper_0.sg13g2_IOPadVdd_0.sg13g2_RCClampResistor_0.p2 user_project_wrapper_0.IOVSS1 user_project_wrapper_0.IOVSS1 sg13_hv_nmos ad=1.71p pd=9.38u as=0 ps=0 w=9u l=9.5u
X4082 IOVDD3 a_355624_197044# analog_io[22] IOVDD3 sg13_hv_pmos ad=2.1312p pd=7.3u as=3.9294p ps=7.84u w=6.66u l=0.6u
X4083 analog_io[25] a_355624_258244# IOVDD3 IOVDD3 sg13_hv_pmos ad=3.9294p pd=7.84u as=2.1312p ps=7.3u w=6.66u l=0.6u
X4084 user_project_wrapper_0.IOVSS1 a_205385_326221# a_202114_326125# user_project_wrapper_0.IOVSS1 sg13_lv_pmos ad=1.824p pd=9.98u as=1.824p ps=9.98u w=9.6u l=0.13u
X4085 user_project_wrapper_0.sg13g2_IOPadVdd_0.sg13g2_RCClampInverter_noptap_0.out user_project_wrapper_0.sg13g2_IOPadVdd_0.sg13g2_RCClampResistor_0.p2 VDD3 VDD3 sg13_hv_pmos ad=1.33p pd=7.38u as=1.33p ps=7.38u w=7u l=0.5u
X4086 a_296731_208493# a_296625_208423# VDD3 VDD3 sg13_lv_pmos ad=0.2603p pd=1.75u as=0.2603p ps=1.75u w=1.37u l=0.35u
X4087 user_project_wrapper_0.IOVDD2 user_project_wrapper_0.sg13g2_IOPadIOVdd_0.sg13g2_Clamp_N43N43D4R_0.gate user_project_wrapper_0.IOVSS1 user_project_wrapper_0.IOVSS1 sg13_hv_nmos ad=2.596p pd=5.58u as=1.408p ps=5.04u w=4.4u l=0.6u
X4088 user_project_wrapper_0.analog_io[30] a_194687_324142# user_project_wrapper_0.IOVSS1 user_project_wrapper_0.IOVSS1 sg13_lv_nmos ad=0.912p pd=5.18u as=0.912p ps=5.18u w=4.8u l=0.13u
X4089 user_project_wrapper_0.IOVDD1 user_project_wrapper_0.sg13g2_IOPadIOVdd_1.sg13g2_Clamp_N43N43D4R_0.gate user_project_wrapper_0.IOVSS1 user_project_wrapper_0.IOVSS1 sg13_hv_nmos ad=2.596p pd=5.58u as=1.408p ps=5.04u w=4.4u l=0.6u
X4090 user_project_wrapper_0.sg13g2_IOPadVdd_0.sg13g2_RCClampInverter_noptap_0.out user_project_wrapper_0.sg13g2_IOPadVdd_0.sg13g2_RCClampResistor_0.p2 VDD3 VDD3 sg13_hv_pmos ad=1.33p pd=7.38u as=1.33p ps=7.38u w=7u l=0.5u
X4091 analog_io[18] a_355624_115444# IOVDD3 IOVDD3 sg13_hv_pmos ad=3.9294p pd=7.84u as=2.1312p ps=7.3u w=6.66u l=0.6u
X4092 a_85875_125209# a_84332_125209# a_85435_125173# user_project_wrapper_0.IOVSS1 sg13_lv_nmos ad=0.1406p pd=1.12u as=0.1406p ps=1.12u w=0.74u l=0.13u
X4093 user_project_wrapper_0.IOVSS1 user_project_wrapper_0.sg13g2_IOPadVdd_3.sg13g2_RCClampInverter_noptap_0.out user_project_wrapper_0.IOVSS1 user_project_wrapper_0.IOVSS1 sg13_hv_nmos ad=2.596p pd=5.58u as=0 ps=0 w=4.4u l=0.6u
X4094 user_project_wrapper_0.IOVSS1 a_307232_196607# a_304995_198817# user_project_wrapper_0.IOVSS1 sg13_lv_nmos ad=0.6327p pd=3.71u as=0.6327p ps=3.71u w=3.33u l=0.2u
X4095 user_project_wrapper_0.IOVSS1 user_project_wrapper_0.sg13g2_IOPadVdd_1.sg13g2_RCClampResistor_0.p2 user_project_wrapper_0.IOVSS1 user_project_wrapper_0.IOVSS1 sg13_hv_nmos ad=1.71p pd=9.38u as=0 ps=0 w=9u l=9.5u
X4096 user_project_wrapper_0.IOVSS1 user_project_wrapper_0.sg13g2_IOPadVdd_3.sg13g2_RCClampInverter_noptap_0.out user_project_wrapper_0.IOVSS1 user_project_wrapper_0.IOVSS1 sg13_hv_nmos ad=2.596p pd=5.58u as=0 ps=0 w=4.4u l=0.6u
X4097 a_309917_194695# a_309516_194555# VDD3 VDD3 sg13_lv_pmos ad=0.19p pd=1.38u as=0.19p ps=1.38u w=1u l=0.7u
X4098 user_project_wrapper_0.IOVSS1 a_176644_29676# user_project_wrapper_0.analog_io[12] user_project_wrapper_0.IOVSS1 sg13_hv_nmos ad=1.408p pd=5.04u as=2.596p ps=5.58u w=4.4u l=0.6u
X4099 user_project_wrapper_0.IOVSS1 user_project_wrapper_0.sg13g2_IOPadVdd_3.sg13g2_RCClampInverter_noptap_0.out user_project_wrapper_0.IOVSS1 user_project_wrapper_0.IOVSS1 sg13_hv_nmos ad=2.596p pd=5.58u as=0 ps=0 w=4.4u l=0.6u
X4100 user_project_wrapper_0.IOVSS1 user_project_wrapper_0.sg13g2_IOPadVdd_0.sg13g2_RCClampInverter_noptap_0.out VDD3 user_project_wrapper_0.IOVSS1 sg13_hv_nmos ad=1.408p pd=5.04u as=2.596p ps=5.58u w=4.4u l=0.6u
X4101 user_project_wrapper_0.analog_io[14] a_217444_41476# user_project_wrapper_0.IOVDD2 user_project_wrapper_0.IOVDD2 sg13_hv_pmos ad=3.9294p pd=7.84u as=2.1312p ps=7.3u w=6.66u l=0.6u
X4102 user_project_wrapper_0.IOVSS1 a_194687_324142# user_project_wrapper_0.analog_io[30] user_project_wrapper_0.IOVSS1 sg13_lv_pmos ad=1.824p pd=9.98u as=1.824p ps=9.98u w=9.6u l=0.13u
X4103 a_84332_125209# a_82667_125418# user_project_wrapper_0.IOVSS1 user_project_wrapper_0.IOVSS1 sg13_lv_nmos ad=0.2516p pd=2.16u as=0.2516p ps=2.16u w=0.74u l=0.13u
X4104 a_296731_208493# a_301186_192011# user_project_wrapper_0.IOVSS1 user_project_wrapper_0.IOVSS1 sg13_lv_nmos ad=0.912p pd=5.18u as=0.912p ps=5.18u w=4.8u l=1.06u
X4105 user_project_wrapper_0.analog_io[10] user_project_wrapper_0.IOVDD2 dpantenna l=1.26u w=27.78u
X4106 a_311846_195517# user_project_wrapper_0.sg13g2_IOPadAnalog_29.padres a_309917_194695# VDD3 sg13_lv_pmos ad=0.24415p pd=1.665u as=0.24415p ps=1.665u w=1.285u l=0.35u
X4107 a_304196_197873# a_304090_197941# a_296625_189595# user_project_wrapper_0.IOVSS1 sg13_lv_nmos ad=0.646p pd=4.48u as=0.361p ps=2.28u w=1.9u l=0.16u
X4108 user_project_wrapper_0.IOVSS1 user_project_wrapper_0.sg13g2_IOPadIOVdd_1.sg13g2_Clamp_N43N43D4R_0.gate user_project_wrapper_0.IOVDD1 user_project_wrapper_0.IOVSS1 sg13_hv_nmos ad=1.408p pd=5.04u as=2.596p ps=5.58u w=4.4u l=0.6u
X4109 a_82433_130212# a_79025_138251# user_project_wrapper_0.IOVSS1 user_project_wrapper_0.IOVSS1 sg13_lv_nmos ad=0.2516p pd=2.16u as=0.2516p ps=2.16u w=0.74u l=0.13u
X4110 a_296731_189665# a_296625_189595# VDD3 VDD3 sg13_lv_pmos ad=0.2603p pd=1.75u as=0.2603p ps=1.75u w=1.37u l=0.35u
X4111 a_91911_129060# a_91090_129425# user_project_wrapper_0.IOVSS1 user_project_wrapper_0.IOVSS1 sg13_lv_nmos ad=0.2516p pd=2.16u as=0.2516p ps=2.16u w=0.74u l=0.13u
X4112 user_project_wrapper_0.IOVSS1 user_project_wrapper_0.sg13g2_IOPadVdd_3.sg13g2_RCClampResistor_0.p2 user_project_wrapper_0.sg13g2_IOPadVdd_3.sg13g2_RCClampInverter_noptap_0.out user_project_wrapper_0.IOVSS1 sg13_hv_pmos ad=1.33p pd=7.38u as=1.33p ps=7.38u w=7u l=0.5u
X4113 user_project_wrapper_0.IOVSS1 a_205385_326221# a_202114_326125# user_project_wrapper_0.IOVSS1 sg13_lv_pmos ad=1.824p pd=9.98u as=1.824p ps=9.98u w=9.6u l=0.13u
X4114 a_307232_196607# a_296731_208493# a_309917_199879# VDD3 sg13_lv_pmos ad=0.4369p pd=3.25u as=0.24415p ps=1.665u w=1.285u l=0.35u
X4115 user_project_wrapper_0.analog_io[35] a_213870_324142# user_project_wrapper_0.IOVSS1 user_project_wrapper_0.IOVSS1 sg13_lv_nmos ad=0.912p pd=5.18u as=0.912p ps=5.18u w=4.8u l=0.13u
X4116 IOVDD3 a_355624_135844# analog_io[19] IOVDD3 sg13_hv_pmos ad=2.1312p pd=7.3u as=3.9294p ps=7.84u w=6.66u l=0.6u
X4117 user_project_wrapper_0.IOVDD4 a_278644_355624# user_project_wrapper_0.analog_io[35] user_project_wrapper_0.IOVDD4 sg13_hv_pmos ad=2.1312p pd=7.3u as=3.9294p ps=7.84u w=6.66u l=0.6u
X4118 user_project_wrapper_0.VDD1 user_project_wrapper_0.sg13g2_IOPadVdd_2.sg13g2_RCClampInverter_noptap_0.out user_project_wrapper_0.IOVSS1 user_project_wrapper_0.IOVSS1 sg13_hv_nmos ad=2.596p pd=5.58u as=1.408p ps=5.04u w=4.4u l=0.6u
X4119 user_project_wrapper_0.VDD2 user_project_wrapper_0.sg13g2_IOPadVdd_1.sg13g2_RCClampInverter_noptap_0.out user_project_wrapper_0.IOVSS1 user_project_wrapper_0.IOVSS1 sg13_hv_nmos ad=2.596p pd=5.58u as=1.408p ps=5.04u w=4.4u l=0.6u
X4120 user_project_wrapper_0.IOVSS1 a_189396_324119# a_188988_324119# user_project_wrapper_0.IOVSS1 sg13_lv_nmos ad=0.34p pd=2.68u as=0.34p ps=2.68u w=1u l=0.13u
X4121 a_309917_194695# a_309516_194555# VDD3 VDD3 sg13_lv_pmos ad=0.19p pd=1.38u as=0.19p ps=1.38u w=1u l=0.7u
X4122 user_project_wrapper_0.IOVSS1 a_202114_326125# user_project_wrapper_0.analog_io[32] user_project_wrapper_0.IOVSS1 sg13_lv_nmos ad=0.912p pd=5.18u as=0.912p ps=5.18u w=4.8u l=0.13u
X4123 user_project_wrapper_0.IOVSS1 user_project_wrapper_0.analog_io[33] dantenna l=1.26u w=27.78u
X4124 a_208469_325785# a_208367_326377# a_208367_325263# w_207887_326203# sg13_lv_pmos ad=0.38p pd=2.38u as=0.38p ps=2.38u w=2u l=0.13u
X4125 IOVDD3 a_355624_237844# analog_io[23] IOVDD3 sg13_hv_pmos ad=2.1312p pd=7.3u as=3.9294p ps=7.84u w=6.66u l=0.6u
X4126 a_309917_199879# a_309516_194555# VDD3 VDD3 sg13_lv_pmos ad=0.19p pd=1.38u as=0.19p ps=1.38u w=1u l=0.7u
X4127 VDD3 a_296626_197740# a_296732_197880# VDD3 sg13_lv_pmos ad=1.33p pd=7.38u as=1.33p ps=7.38u w=7u l=0.7u
X4128 a_309917_194695# user_project_wrapper_0.sg13g2_IOPadAnalog_29.padres a_311846_195517# VDD3 sg13_lv_pmos ad=0.24415p pd=1.665u as=0.24415p ps=1.665u w=1.285u l=0.35u
X4129 user_project_wrapper_0.IOVDD4 user_project_wrapper_0.sg13g2_IOPadIOVdd_2.sg13g2_Clamp_N43N43D4R_0.gate user_project_wrapper_0.IOVSS1 user_project_wrapper_0.IOVSS1 sg13_hv_nmos ad=2.596p pd=5.58u as=1.408p ps=5.04u w=4.4u l=0.6u
X4130 VDD3 user_project_wrapper_0.sg13g2_IOPadVdd_0.sg13g2_RCClampInverter_noptap_0.out user_project_wrapper_0.IOVSS1 user_project_wrapper_0.IOVSS1 sg13_hv_nmos ad=2.596p pd=5.58u as=1.408p ps=5.04u w=4.4u l=0.6u
X4131 a_296731_208493# a_296625_208423# VDD3 VDD3 sg13_lv_pmos ad=0.2603p pd=1.75u as=0.2603p ps=1.75u w=1.37u l=0.35u
X4132 analog_io[20] a_355624_156244# IOVDD3 IOVDD3 sg13_hv_pmos ad=3.9294p pd=7.84u as=3.1302p ps=14.26u w=6.66u l=0.6u
X4133 user_project_wrapper_0.IOVSS1 a_189729_101343# a_190389_101343# user_project_wrapper_0.IOVSS1 sg13_lv_nmos ad=0.1406p pd=1.12u as=0.1406p ps=1.12u w=0.74u l=0.13u
X4134 VDD3 a_296625_189595# a_296731_189665# VDD3 sg13_lv_pmos ad=0.2603p pd=1.75u as=0.2603p ps=1.75u w=1.37u l=0.35u
X4135 user_project_wrapper_0.IOVSS1 a_194279_327536# a_194687_324142# user_project_wrapper_0.IOVSS1 sg13_lv_nmos ad=0.912p pd=5.18u as=0.912p ps=5.18u w=4.8u l=0.13u
X4136 user_project_wrapper_0.IOVSS1 user_project_wrapper_0.sg13g2_IOPadIOVdd_2.sg13g2_RCClampResistor_0.p2 user_project_wrapper_0.IOVSS1 user_project_wrapper_0.IOVSS1 sg13_hv_nmos ad=1.71p pd=9.38u as=0 ps=0 w=9u l=9.5u
X4137 VDD3 a_309516_194555# a_309917_194695# VDD3 sg13_lv_pmos ad=0.19p pd=1.38u as=0.19p ps=1.38u w=1u l=0.7u
X4138 VDD3 a_309516_194555# a_309516_194555# VDD3 sg13_lv_pmos ad=0.19p pd=1.38u as=0.19p ps=1.38u w=1u l=0.7u
X4139 user_project_wrapper_0.analog_io[14] a_190389_99046# QDLL_TOP_0.VDD QDLL_TOP_0.VDD sg13_lv_pmos ad=0.2128p pd=1.5u as=0.2128p ps=1.5u w=1.12u l=0.13u
X4140 a_190389_99046# a_189729_99046# QDLL_TOP_0.VDD QDLL_TOP_0.VDD sg13_lv_pmos ad=0.2128p pd=1.5u as=0.2128p ps=1.5u w=1.12u l=0.13u
X4141 analog_io[26] a_355624_278644# IOVDD3 IOVDD3 sg13_hv_pmos ad=3.9294p pd=7.84u as=2.1312p ps=7.3u w=6.66u l=0.6u
X4142 a_190501_325263# a_189184_325263# user_project_wrapper_0.IOVSS1 user_project_wrapper_0.IOVSS1 sg13_lv_nmos ad=0.34p pd=2.68u as=0.34p ps=2.68u w=1u l=0.13u
X4143 user_project_wrapper_0.IOVDD1 a_41476_217444# user_project_wrapper_0.analog_io[5] user_project_wrapper_0.IOVDD1 sg13_hv_pmos ad=2.1312p pd=7.3u as=3.9294p ps=7.84u w=6.66u l=0.6u
X4144 user_project_wrapper_0.IOVDD2 user_project_wrapper_0.sg13g2_IOPadIOVdd_0.sg13g2_RCClampResistor_0.p2 user_project_wrapper_0.sg13g2_IOPadIOVdd_0.sg13g2_Clamp_N43N43D4R_0.gate user_project_wrapper_0.IOVDD2 sg13_hv_pmos ad=1.33p pd=7.38u as=1.33p ps=7.38u w=7u l=0.5u
X4145 IOVDD3 a_355624_237844# analog_io[23] IOVDD3 sg13_hv_pmos ad=2.1312p pd=7.3u as=3.9294p ps=7.84u w=6.66u l=0.6u
X4146 user_project_wrapper_0.IOVSS1 a_176644_29676# user_project_wrapper_0.analog_io[12] user_project_wrapper_0.IOVSS1 sg13_hv_nmos ad=1.408p pd=5.04u as=2.596p ps=5.58u w=4.4u l=0.6u
X4147 user_project_wrapper_0.IOVSS1 user_project_wrapper_0.sg13g2_IOPadVdd_1.sg13g2_RCClampInverter_noptap_0.out user_project_wrapper_0.VDD2 user_project_wrapper_0.IOVSS1 sg13_hv_nmos ad=1.408p pd=5.04u as=2.596p ps=5.58u w=4.4u l=0.6u
X4148 a_271172_100118# a_270512_100118# QDLL_TOP_0.VDD QDLL_TOP_0.VDD sg13_lv_pmos ad=0.2184p pd=1.51u as=0.2128p ps=1.5u w=1.12u l=0.13u
X4149 user_project_wrapper_0.analog_io[1] a_41476_135844# user_project_wrapper_0.IOVDD1 user_project_wrapper_0.IOVDD1 sg13_hv_pmos ad=3.9294p pd=7.84u as=3.1302p ps=14.26u w=6.66u l=0.6u
X4150 user_project_wrapper_0.IOVDD1 user_project_wrapper_0.sg13g2_IOPadIOVdd_1.sg13g2_Clamp_N43N43D4R_0.gate user_project_wrapper_0.IOVSS1 user_project_wrapper_0.IOVSS1 sg13_hv_nmos ad=2.596p pd=5.58u as=1.408p ps=5.04u w=4.4u l=0.6u
X4151 user_project_wrapper_0.analog_io[30] a_176644_369296# user_project_wrapper_0.IOVSS1 user_project_wrapper_0.IOVSS1 sg13_hv_nmos ad=2.596p pd=5.58u as=1.408p ps=5.04u w=4.4u l=0.6u
X4152 a_309917_199879# a_309516_194555# VDD3 VDD3 sg13_lv_pmos ad=0.19p pd=1.38u as=0.19p ps=1.38u w=1u l=0.7u
X4153 a_313884_211353# a_296731_208493# a_311189_211724# user_project_wrapper_0.IOVSS1 sg13_lv_nmos ad=1.9p pd=10.38u as=1.9p ps=10.38u w=10u l=0.5u
X4154 user_project_wrapper_0.IOVSS1 user_project_wrapper_0.sg13g2_IOPadVdd_2.sg13g2_RCClampInverter_noptap_0.out user_project_wrapper_0.VDD1 user_project_wrapper_0.IOVSS1 sg13_hv_nmos ad=1.408p pd=5.04u as=2.596p ps=5.58u w=4.4u l=0.6u
X4155 a_82658_128838# a_82348_128838# user_project_wrapper_0.IOVSS1 user_project_wrapper_0.IOVSS1 sg13_lv_nmos ad=0.1406p pd=1.12u as=0.2516p ps=2.16u w=0.74u l=0.13u
X4156 VDD3 a_296625_189595# a_296731_189665# VDD3 sg13_lv_pmos ad=0.2603p pd=1.75u as=0.2603p ps=1.75u w=1.37u l=0.35u
X4157 user_project_wrapper_0.IOVSS1 analog_io[18] dantenna l=27.78u w=1.26u
X4158 user_project_wrapper_0.IOVSS1 a_135844_29676# user_project_wrapper_0.analog_io[10] user_project_wrapper_0.IOVSS1 sg13_hv_nmos ad=1.408p pd=5.04u as=2.596p ps=5.58u w=4.4u l=0.6u
X4159 user_project_wrapper_0.IOVDD1 a_41476_115444# user_project_wrapper_0.analog_io[0] user_project_wrapper_0.IOVDD1 sg13_hv_pmos ad=2.1312p pd=7.3u as=3.9294p ps=7.84u w=6.66u l=0.6u
X4160 user_project_wrapper_0.IOVDD2 a_135844_41476# user_project_wrapper_0.analog_io[10] user_project_wrapper_0.IOVDD2 sg13_hv_pmos ad=2.1312p pd=7.3u as=3.9294p ps=7.84u w=6.66u l=0.6u
X4161 VDD3 a_296625_189595# a_296731_189665# VDD3 sg13_lv_pmos ad=0.2603p pd=1.75u as=0.2603p ps=1.75u w=1.37u l=0.35u
X4162 a_304995_198817# a_304889_199957# a_304196_200821# user_project_wrapper_0.IOVSS1 sg13_lv_nmos ad=0.209p pd=1.48u as=0.209p ps=1.48u w=1.1u l=0.15u
X4163 user_project_wrapper_0.analog_io[28] a_135844_355624# user_project_wrapper_0.IOVDD4 user_project_wrapper_0.IOVDD4 sg13_hv_pmos ad=3.9294p pd=7.84u as=2.1312p ps=7.3u w=6.66u l=0.6u
X4164 VDD3 a_296625_208423# a_296731_208493# VDD3 sg13_lv_pmos ad=0.2603p pd=1.75u as=0.2603p ps=1.75u w=1.37u l=0.35u
X4165 user_project_wrapper_0.IOVDD2 user_project_wrapper_0.sg13g2_IOPadIOVdd_0.sg13g2_Clamp_N43N43D4R_0.gate user_project_wrapper_0.IOVSS1 user_project_wrapper_0.IOVSS1 sg13_hv_nmos ad=2.596p pd=5.58u as=1.408p ps=5.04u w=4.4u l=0.6u
X4166 a_186202_326221# a_187018_328627# user_project_wrapper_0.IOVSS1 user_project_wrapper_0.IOVSS1 sg13_lv_pmos ad=1.824p pd=9.98u as=1.824p ps=9.98u w=9.6u l=0.13u
X4167 user_project_wrapper_0.IOVDD2 a_197044_41476# user_project_wrapper_0.analog_io[13] user_project_wrapper_0.IOVDD2 sg13_hv_pmos ad=2.1312p pd=7.3u as=3.9294p ps=7.84u w=6.66u l=0.6u
X4168 user_project_wrapper_0.IOVSS1 user_project_wrapper_0.sg13g2_IOPadIOVdd_0.sg13g2_Clamp_N43N43D4R_0.gate user_project_wrapper_0.IOVDD2 user_project_wrapper_0.IOVSS1 sg13_hv_nmos ad=1.408p pd=5.04u as=2.596p ps=5.58u w=4.4u l=0.6u
X4169 user_project_wrapper_0.IOVSS1 a_194687_324142# user_project_wrapper_0.analog_io[30] user_project_wrapper_0.IOVSS1 sg13_lv_nmos ad=0.912p pd=5.18u as=0.912p ps=5.18u w=4.8u l=0.13u
X4170 user_project_wrapper_0.IOVSS1 user_project_wrapper_0.analog_io[12] dantenna l=1.26u w=27.78u
X4171 user_project_wrapper_0.IOVSS1 user_project_wrapper_0.sg13g2_IOPadVdd_2.sg13g2_RCClampInverter_noptap_0.out user_project_wrapper_0.VDD1 user_project_wrapper_0.IOVSS1 sg13_hv_nmos ad=1.408p pd=5.04u as=2.596p ps=5.58u w=4.4u l=0.6u
X4172 user_project_wrapper_0.IOVSS1 a_190389_101343# user_project_wrapper_0.analog_io[15] user_project_wrapper_0.IOVSS1 sg13_lv_nmos ad=0.1406p pd=1.12u as=0.1406p ps=1.12u w=0.74u l=0.13u
X4173 VDD3 a_296625_208423# a_296731_208493# VDD3 sg13_lv_pmos ad=0.2603p pd=1.75u as=0.2603p ps=1.75u w=1.37u l=0.35u
X4174 a_296625_189595# a_301940_196388# a_296732_197880# VDD3 sg13_lv_pmos ad=0.7695p pd=4.43u as=0.7695p ps=4.43u w=4.05u l=0.5u
X4175 user_project_wrapper_0.analog_io[33] a_237844_355624# user_project_wrapper_0.IOVDD4 user_project_wrapper_0.IOVDD4 sg13_hv_pmos ad=3.9294p pd=7.84u as=2.1312p ps=7.3u w=6.66u l=0.6u
X4176 user_project_wrapper_0.IOVSS1 user_project_wrapper_0.sg13g2_IOPadIOVdd_2.sg13g2_Clamp_N43N43D4R_0.gate user_project_wrapper_0.IOVDD4 user_project_wrapper_0.IOVSS1 sg13_hv_nmos ad=1.408p pd=5.04u as=2.596p ps=5.58u w=4.4u l=0.6u
X4177 IOVDD3 a_355624_156244# analog_io[20] IOVDD3 sg13_hv_pmos ad=2.1312p pd=7.3u as=3.9294p ps=7.84u w=6.66u l=0.6u
X4178 user_project_wrapper_0.IOVDD1 user_project_wrapper_0.sg13g2_IOPadIOVdd_1.sg13g2_RCClampResistor_0.p2 user_project_wrapper_0.sg13g2_IOPadIOVdd_1.sg13g2_Clamp_N43N43D4R_0.gate user_project_wrapper_0.IOVDD1 sg13_hv_pmos ad=1.33p pd=7.38u as=1.33p ps=7.38u w=7u l=0.5u
X4179 user_project_wrapper_0.IOVSS1 user_project_wrapper_0.sg13g2_IOPadIOVdd_1.sg13g2_Clamp_N43N43D4R_0.gate user_project_wrapper_0.IOVDD1 user_project_wrapper_0.IOVSS1 sg13_hv_nmos ad=1.408p pd=5.04u as=2.596p ps=5.58u w=4.4u l=0.6u
X4180 user_project_wrapper_0.IOVSS1 a_206201_328627# a_205385_326221# user_project_wrapper_0.IOVSS1 sg13_lv_nmos ad=0.912p pd=5.18u as=0.912p ps=5.18u w=4.8u l=0.13u
X4181 user_project_wrapper_0.IOVSS1 user_project_wrapper_0.sg13g2_IOPadVdd_0.sg13g2_RCClampResistor_0.p2 user_project_wrapper_0.sg13g2_IOPadVdd_0.sg13g2_RCClampInverter_noptap_0.out user_project_wrapper_0.IOVSS1 sg13_hv_nmos ad=1.71p pd=9.38u as=1.71p ps=9.38u w=9u l=0.5u
X4182 a_309917_199879# user_project_wrapper_0.sg13g2_IOPadAnalog_29.padres a_311846_195517# VDD3 sg13_lv_pmos ad=0.24415p pd=1.665u as=0.24415p ps=1.665u w=1.285u l=0.35u
X4183 user_project_wrapper_0.IOVDD4 a_217444_355624# user_project_wrapper_0.analog_io[32] user_project_wrapper_0.IOVDD4 sg13_hv_pmos ad=2.1312p pd=7.3u as=3.9294p ps=7.84u w=6.66u l=0.6u
X4184 user_project_wrapper_0.analog_io[6] a_29676_237844# user_project_wrapper_0.IOVSS1 user_project_wrapper_0.IOVSS1 sg13_hv_nmos ad=2.596p pd=5.58u as=1.408p ps=5.04u w=4.4u l=0.6u
X4185 user_project_wrapper_0.IOVSS1 user_project_wrapper_0.sg13g2_IOPadVdd_1.sg13g2_RCClampResistor_0.p2 user_project_wrapper_0.IOVSS1 user_project_wrapper_0.IOVSS1 sg13_hv_nmos ad=1.71p pd=9.38u as=0 ps=0 w=9u l=9.5u
X4186 a_311108_179669# analog_io[20] a_313884_185173# user_project_wrapper_0.IOVSS1 sg13_lv_nmos ad=1.9p pd=10.38u as=1.9p ps=10.38u w=10u l=0.5u
X4187 a_296732_200582# a_301940_196388# a_296625_208423# VDD3 sg13_lv_pmos ad=0.7695p pd=4.43u as=0.7695p ps=4.43u w=4.05u l=0.5u
X4188 QDLL_TOP_0.VOUT a_271172_100118# QDLL_TOP_0.VDD QDLL_TOP_0.VDD sg13_lv_pmos ad=0.2128p pd=1.5u as=0.2128p ps=1.5u w=1.12u l=0.13u
X4189 user_project_wrapper_0.IOVSS1 user_project_wrapper_0.sg13g2_IOPadVdd_0.sg13g2_RCClampInverter_noptap_0.out VDD3 user_project_wrapper_0.IOVSS1 sg13_hv_nmos ad=1.408p pd=5.04u as=2.596p ps=5.58u w=4.4u l=0.6u
X4190 a_79025_131334# a_78220_128592# a_79038_130026# user_project_wrapper_0.VDD1 sg13_lv_pmos ad=1.7p pd=10.68u as=0.95p ps=5.38u w=5u l=0.3u
X4191 a_296625_189595# a_301940_196388# a_296732_197880# VDD3 sg13_lv_pmos ad=0.7695p pd=4.43u as=0.7695p ps=4.43u w=4.05u l=0.5u
X4192 user_project_wrapper_0.IOVSS1 user_project_wrapper_0.sg13g2_IOPadIOVdd_3.sg13g2_Clamp_N43N43D4R_0.gate IOVDD3 user_project_wrapper_0.IOVSS1 sg13_hv_nmos ad=1.408p pd=5.04u as=2.596p ps=5.58u w=4.4u l=0.6u
X4193 user_project_wrapper_0.IOVSS1 user_project_wrapper_0.IOVSS1 user_project_wrapper_0.IOVSS1 rppd l=0.5u w=0.5u
X4194 user_project_wrapper_0.IOVSS1 a_369296_115444# analog_io[18] user_project_wrapper_0.IOVSS1 sg13_hv_nmos ad=1.408p pd=5.04u as=2.596p ps=5.58u w=4.4u l=0.6u
X4195 user_project_wrapper_0.sg13g2_IOPadVdd_0.sg13g2_RCClampInverter_noptap_0.out user_project_wrapper_0.sg13g2_IOPadVdd_0.sg13g2_RCClampResistor_0.p2 VDD3 VDD3 sg13_hv_pmos ad=1.33p pd=7.38u as=1.33p ps=7.38u w=7u l=0.5u
X4196 user_project_wrapper_0.analog_io[35] a_278644_355624# user_project_wrapper_0.IOVDD4 user_project_wrapper_0.IOVDD4 sg13_hv_pmos ad=3.9294p pd=7.84u as=2.1312p ps=7.3u w=6.66u l=0.6u
X4197 user_project_wrapper_0.analog_io[12] a_176644_41476# user_project_wrapper_0.IOVDD2 user_project_wrapper_0.IOVDD2 sg13_hv_pmos ad=3.9294p pd=7.84u as=3.1302p ps=14.26u w=6.66u l=0.6u
X4198 user_project_wrapper_0.VDD2 user_project_wrapper_0.sg13g2_IOPadVdd_1.sg13g2_RCClampInverter_noptap_0.out user_project_wrapper_0.IOVSS1 user_project_wrapper_0.IOVSS1 sg13_hv_nmos ad=2.596p pd=5.58u as=1.408p ps=5.04u w=4.4u l=0.6u
X4199 user_project_wrapper_0.sg13g2_IOPadVdd_1.sg13g2_RCClampInverter_noptap_0.out user_project_wrapper_0.sg13g2_IOPadVdd_1.sg13g2_RCClampResistor_0.p2 user_project_wrapper_0.VDD2 user_project_wrapper_0.VDD2 sg13_hv_pmos ad=1.33p pd=7.38u as=1.33p ps=7.38u w=7u l=0.5u
X4200 a_191438_328605# TOP_ROILIFNEURON_0.MEM user_project_wrapper_0.IOVSS1 rppd l=0.5u w=0.5u
X4201 user_project_wrapper_0.VDD1 user_project_wrapper_0.sg13g2_IOPadVdd_2.sg13g2_RCClampInverter_noptap_0.out user_project_wrapper_0.IOVSS1 user_project_wrapper_0.IOVSS1 sg13_hv_nmos ad=2.596p pd=5.58u as=1.408p ps=5.04u w=4.4u l=0.6u
X4202 user_project_wrapper_0.sg13g2_IOPadVdd_3.sg13g2_RCClampInverter_noptap_0.out user_project_wrapper_0.sg13g2_IOPadVdd_3.sg13g2_RCClampResistor_0.p2 user_project_wrapper_0.IOVSS1 user_project_wrapper_0.IOVSS1 sg13_hv_pmos ad=1.33p pd=7.38u as=1.33p ps=7.38u w=7u l=0.5u
X4203 a_91090_127895# a_90579_127530# user_project_wrapper_0.VDD1 user_project_wrapper_0.VDD1 sg13_lv_pmos ad=0.2128p pd=1.5u as=0.3808p ps=2.92u w=1.12u l=0.13u
X4204 user_project_wrapper_0.analog_io[14] a_190389_99046# QDLL_TOP_0.VDD QDLL_TOP_0.VDD sg13_lv_pmos ad=0.2128p pd=1.5u as=0.2128p ps=1.5u w=1.12u l=0.13u
X4205 user_project_wrapper_0.IOVDD4 user_project_wrapper_0.sg13g2_IOPadIOVdd_2.sg13g2_Clamp_N43N43D4R_0.gate user_project_wrapper_0.IOVSS1 user_project_wrapper_0.IOVSS1 sg13_hv_nmos ad=2.596p pd=5.58u as=1.408p ps=5.04u w=4.4u l=0.6u
X4206 user_project_wrapper_0.analog_io[11] a_156244_29676# user_project_wrapper_0.IOVSS1 user_project_wrapper_0.IOVSS1 sg13_hv_nmos ad=2.596p pd=5.58u as=1.408p ps=5.04u w=4.4u l=0.6u
X4207 a_296625_189595# a_304090_197941# a_304196_197873# user_project_wrapper_0.IOVSS1 sg13_lv_nmos ad=0.361p pd=2.28u as=0.361p ps=2.28u w=1.9u l=0.16u
X4208 user_project_wrapper_0.sg13g2_IOPadIOVdd_2.sg13g2_Clamp_N43N43D4R_0.gate user_project_wrapper_0.sg13g2_IOPadIOVdd_2.sg13g2_RCClampResistor_0.p2 user_project_wrapper_0.IOVDD4 user_project_wrapper_0.IOVDD4 sg13_hv_pmos ad=1.33p pd=7.38u as=1.33p ps=7.38u w=7u l=0.5u
X4209 user_project_wrapper_0.IOVDD1 user_project_wrapper_0.sg13g2_IOPadIOVdd_1.sg13g2_RCClampResistor_0.p2 user_project_wrapper_0.sg13g2_IOPadIOVdd_1.sg13g2_Clamp_N43N43D4R_0.gate user_project_wrapper_0.IOVDD1 sg13_hv_pmos ad=1.33p pd=7.38u as=1.33p ps=7.38u w=7u l=0.5u
X4210 a_311846_195517# a_311846_195517# user_project_wrapper_0.IOVSS1 user_project_wrapper_0.IOVSS1 sg13_lv_nmos ad=0.6327p pd=3.71u as=0.6327p ps=3.71u w=3.33u l=0.2u
X4211 VDD3 user_project_wrapper_0.sg13g2_IOPadVdd_0.sg13g2_RCClampInverter_noptap_0.out user_project_wrapper_0.IOVSS1 user_project_wrapper_0.IOVSS1 sg13_hv_nmos ad=2.596p pd=5.58u as=1.408p ps=5.04u w=4.4u l=0.6u
X4212 a_304995_198817# a_304889_199957# a_304196_200821# user_project_wrapper_0.IOVSS1 sg13_lv_nmos ad=0.209p pd=1.48u as=0.209p ps=1.48u w=1.1u l=0.15u
X4213 a_360372_302065# a_364458_302395# user_project_wrapper_0.IOVSS1 rppd l=20u w=1u
X4214 user_project_wrapper_0.IOVDD4 user_project_wrapper_0.sg13g2_IOPadIOVdd_2.sg13g2_RCClampResistor_0.p2 user_project_wrapper_0.sg13g2_IOPadIOVdd_2.sg13g2_Clamp_N43N43D4R_0.gate user_project_wrapper_0.IOVDD4 sg13_hv_pmos ad=1.33p pd=7.38u as=1.33p ps=7.38u w=7u l=0.5u
X4215 a_189737_324155# a_189672_324776# user_project_wrapper_0.IOVSS1 w_188806_323975# sg13_lv_pmos ad=0.38p pd=2.38u as=0.38p ps=2.38u w=2u l=0.13u
X4216 a_299425_39542# a_299755_35456# user_project_wrapper_0.IOVSS1 rppd l=20u w=1u
X4217 a_296731_189665# a_296625_189595# VDD3 VDD3 sg13_lv_pmos ad=0.2603p pd=1.75u as=0.2603p ps=1.75u w=1.37u l=0.35u
X4218 user_project_wrapper_0.analog_io[35] user_project_wrapper_0.IOVDD4 dpantenna l=1.26u w=27.78u
X4219 a_296731_208493# a_301186_192011# user_project_wrapper_0.IOVSS1 user_project_wrapper_0.IOVSS1 sg13_lv_nmos ad=0.912p pd=5.18u as=0.912p ps=5.18u w=4.8u l=1.06u
X4220 user_project_wrapper_0.analog_io[29] a_156244_355624# user_project_wrapper_0.IOVDD4 user_project_wrapper_0.IOVDD4 sg13_hv_pmos ad=3.9294p pd=7.84u as=2.1312p ps=7.3u w=6.66u l=0.6u
X4221 IOVDD3 a_355624_115444# analog_io[18] IOVDD3 sg13_hv_pmos ad=2.1312p pd=7.3u as=3.9294p ps=7.84u w=6.66u l=0.6u
X4222 user_project_wrapper_0.IOVSS1 user_project_wrapper_0.ui_PAD[31] dantenna l=27.78u w=1.26u
X4223 a_309917_194695# a_309516_194555# VDD3 VDD3 sg13_lv_pmos ad=0.19p pd=1.38u as=0.19p ps=1.38u w=1u l=0.7u
X4224 user_project_wrapper_0.IOVDD4 a_135844_355624# user_project_wrapper_0.analog_io[28] user_project_wrapper_0.IOVDD4 sg13_hv_pmos ad=2.1312p pd=7.3u as=3.9294p ps=7.84u w=6.66u l=0.6u
X4225 user_project_wrapper_0.IOVSS1 a_208017_327918# a_208469_328013# w_207887_327938# sg13_lv_pmos ad=0.68p pd=4.68u as=0.38p ps=2.38u w=2u l=0.13u
X4226 user_project_wrapper_0.IOVSS1 a_182931_326125# user_project_wrapper_0.analog_io[27] user_project_wrapper_0.IOVSS1 sg13_lv_nmos ad=0.912p pd=5.18u as=0.912p ps=5.18u w=4.8u l=0.13u
X4227 user_project_wrapper_0.IOVSS1 user_project_wrapper_0.sg13g2_IOPadIOVdd_1.sg13g2_Clamp_N43N43D4R_0.gate user_project_wrapper_0.IOVDD1 user_project_wrapper_0.IOVSS1 sg13_hv_nmos ad=1.408p pd=5.04u as=2.596p ps=5.58u w=4.4u l=0.6u
X4228 a_299425_39542# a_299095_35456# user_project_wrapper_0.IOVSS1 rppd l=20u w=1u
X4229 IOVDD3 a_355624_217444# analog_io[23] IOVDD3 sg13_hv_pmos ad=2.1312p pd=7.3u as=3.9294p ps=7.84u w=6.66u l=0.6u
X4230 user_project_wrapper_0.IOVSS1 user_project_wrapper_0.sg13g2_IOPadVdd_3.sg13g2_RCClampInverter_noptap_0.out user_project_wrapper_0.IOVSS1 user_project_wrapper_0.IOVSS1 sg13_hv_nmos ad=2.596p pd=5.58u as=0 ps=0 w=4.4u l=0.6u
X4231 a_35456_305035# a_39542_305365# user_project_wrapper_0.IOVSS1 rppd l=20u w=1u
X4232 user_project_wrapper_0.IOVSS1 a_194687_324142# user_project_wrapper_0.analog_io[30] user_project_wrapper_0.IOVSS1 sg13_lv_pmos ad=1.824p pd=9.98u as=1.824p ps=9.98u w=9.6u l=0.13u
X4233 user_project_wrapper_0.analog_io[13] user_project_wrapper_0.IOVDD2 dpantenna l=1.26u w=27.78u
X4234 user_project_wrapper_0.analog_io[1] a_29676_135844# user_project_wrapper_0.IOVSS1 user_project_wrapper_0.IOVSS1 sg13_hv_nmos ad=2.596p pd=5.58u as=1.408p ps=5.04u w=4.4u l=0.6u
X4235 a_191438_325263# a_191234_325263# user_project_wrapper_0.IOVSS1 w_188704_326203# sg13_lv_pmos ad=0.68p pd=4.68u as=0.38p ps=2.38u w=2u l=0.13u
X4236 a_209684_327491# a_208367_327491# user_project_wrapper_0.IOVSS1 user_project_wrapper_0.IOVSS1 sg13_lv_nmos ad=0.34p pd=2.68u as=0.34p ps=2.68u w=1u l=0.13u
X4237 a_296731_189665# a_296625_189595# VDD3 VDD3 sg13_lv_pmos ad=0.2603p pd=1.75u as=0.2603p ps=1.75u w=1.37u l=0.35u
X4238 a_85591_241748# a_85287_241383# user_project_wrapper_0.VDD1 user_project_wrapper_0.VDD1 sg13_lv_pmos ad=0.2128p pd=1.5u as=0.3808p ps=2.92u w=1.12u l=0.13u
X4239 a_304995_198817# a_304889_198885# a_304196_197873# user_project_wrapper_0.IOVSS1 sg13_lv_nmos ad=0.209p pd=1.48u as=0.209p ps=1.48u w=1.1u l=0.15u
X4240 user_project_wrapper_0.IOVDD2 a_135844_41476# user_project_wrapper_0.analog_io[10] user_project_wrapper_0.IOVDD2 sg13_hv_pmos ad=2.1312p pd=7.3u as=3.9294p ps=7.84u w=6.66u l=0.6u
X4241 analog_io[18] a_369296_115444# user_project_wrapper_0.IOVSS1 user_project_wrapper_0.IOVSS1 sg13_hv_nmos ad=2.596p pd=5.58u as=1.408p ps=5.04u w=4.4u l=0.6u
X4242 VDD3 a_296626_197740# a_296732_200582# VDD3 sg13_lv_pmos ad=2.38p pd=14.68u as=1.33p ps=7.38u w=7u l=0.7u
X4243 VDD3 a_309516_194555# a_309917_199879# VDD3 sg13_lv_pmos ad=0.19p pd=1.38u as=0.19p ps=1.38u w=1u l=0.7u
X4244 user_project_wrapper_0.IOVSS1 a_205385_326221# a_202114_326125# user_project_wrapper_0.IOVSS1 sg13_lv_pmos ad=1.824p pd=9.98u as=1.824p ps=9.98u w=9.6u l=0.13u
X4245 IOVDD3 a_355624_197044# analog_io[22] IOVDD3 sg13_hv_pmos ad=2.1312p pd=7.3u as=3.9294p ps=7.84u w=6.66u l=0.6u
X4246 a_270512_100118# a_270178_100118# user_project_wrapper_0.IOVSS1 user_project_wrapper_0.IOVSS1 sg13_lv_nmos ad=0.1406p pd=1.12u as=0.2516p ps=2.16u w=0.74u l=0.13u
X4247 a_307232_196607# a_296731_189665# a_309917_194695# VDD3 sg13_lv_pmos ad=0.24415p pd=1.665u as=0.24415p ps=1.665u w=1.285u l=0.35u
X4248 analog_io[18] a_355624_115444# IOVDD3 IOVDD3 sg13_hv_pmos ad=3.9294p pd=7.84u as=2.1312p ps=7.3u w=6.66u l=0.6u
X4249 a_296731_189665# a_296625_189595# VDD3 VDD3 sg13_lv_pmos ad=0.2603p pd=1.75u as=0.4658p ps=3.42u w=1.37u l=0.35u
X4250 user_project_wrapper_0.IOVSS1 user_project_wrapper_0.IOVSS1 user_project_wrapper_0.IOVSS1 rhigh l=0.96u w=0.5u
X4251 user_project_wrapper_0.IOVSS1 a_188988_324119# a_188920_324155# user_project_wrapper_0.IOVSS1 sg13_lv_nmos ad=0.34p pd=2.68u as=0.19p ps=1.38u w=1u l=0.13u
X4252 user_project_wrapper_0.IOVSS1 user_project_wrapper_0.IOVSS1 user_project_wrapper_0.IOVSS1 rppd l=0.5u w=0.5u
X4253 user_project_wrapper_0.IOVSS1 a_237844_369296# user_project_wrapper_0.IOVSS1 rppd l=3.54u w=0.5u
X4254 user_project_wrapper_0.sg13g2_IOPadVdd_0.sg13g2_RCClampInverter_noptap_0.out user_project_wrapper_0.sg13g2_IOPadVdd_0.sg13g2_RCClampResistor_0.p2 VDD3 VDD3 sg13_hv_pmos ad=1.33p pd=7.38u as=1.33p ps=7.38u w=7u l=0.5u
X4255 a_296731_208493# a_301186_192011# user_project_wrapper_0.IOVSS1 user_project_wrapper_0.IOVSS1 sg13_lv_nmos ad=0.912p pd=5.18u as=0.912p ps=5.18u w=4.8u l=1.06u
X4256 a_87434_129061# a_86594_129426# user_project_wrapper_0.IOVSS1 user_project_wrapper_0.IOVSS1 sg13_lv_nmos ad=0.1406p pd=1.12u as=0.2516p ps=2.16u w=0.74u l=0.13u
X4257 user_project_wrapper_0.IOVSS1 a_188834_326341# a_189858_330241# w_188700_330166# sg13_lv_pmos ad=0.68p pd=4.68u as=0.38p ps=2.38u w=2u l=0.13u
X4258 user_project_wrapper_0.IOVSS1 a_202114_326125# user_project_wrapper_0.analog_io[32] user_project_wrapper_0.IOVSS1 sg13_lv_nmos ad=0.912p pd=5.18u as=0.912p ps=5.18u w=4.8u l=0.13u
X4259 user_project_wrapper_0.analog_io[0] a_29676_115444# user_project_wrapper_0.IOVSS1 user_project_wrapper_0.IOVSS1 sg13_hv_nmos ad=2.596p pd=5.58u as=1.408p ps=5.04u w=4.4u l=0.6u
X4260 a_296731_189665# a_296625_189595# VDD3 VDD3 sg13_lv_pmos ad=0.2603p pd=1.75u as=0.2603p ps=1.75u w=1.37u l=0.35u
X4261 a_296731_208493# a_296625_208423# VDD3 VDD3 sg13_lv_pmos ad=0.2603p pd=1.75u as=0.2603p ps=1.75u w=1.37u l=0.35u
X4262 user_project_wrapper_0.IOVSS1 a_176644_369296# user_project_wrapper_0.analog_io[30] user_project_wrapper_0.IOVSS1 sg13_hv_nmos ad=1.408p pd=5.04u as=2.596p ps=5.58u w=4.4u l=0.6u
X4263 user_project_wrapper_0.analog_io[29] a_156244_355624# user_project_wrapper_0.IOVDD4 user_project_wrapper_0.IOVDD4 sg13_hv_pmos ad=3.9294p pd=7.84u as=2.1312p ps=7.3u w=6.66u l=0.6u
X4264 user_project_wrapper_0.sg13g2_IOPadVdd_2.sg13g2_RCClampInverter_noptap_0.out user_project_wrapper_0.sg13g2_IOPadVdd_2.sg13g2_RCClampResistor_0.p2 user_project_wrapper_0.VDD1 user_project_wrapper_0.VDD1 sg13_hv_pmos ad=1.33p pd=7.38u as=1.33p ps=7.38u w=7u l=0.5u
X4265 user_project_wrapper_0.IOVSS1 user_project_wrapper_0.sg13g2_IOPadVdd_3.sg13g2_RCClampInverter_noptap_0.out user_project_wrapper_0.IOVSS1 user_project_wrapper_0.IOVSS1 sg13_hv_nmos ad=1.408p pd=5.04u as=0 ps=0 w=4.4u l=0.6u
X4266 user_project_wrapper_0.IOVDD4 user_project_wrapper_0.sg13g2_IOPadIOVdd_2.sg13g2_Clamp_N43N43D4R_0.gate user_project_wrapper_0.IOVSS1 user_project_wrapper_0.IOVSS1 sg13_hv_nmos ad=2.596p pd=5.58u as=1.408p ps=5.04u w=4.4u l=0.6u
X4267 user_project_wrapper_0.IOVSS1 user_project_wrapper_0.sg13g2_IOPadVdd_0.sg13g2_RCClampInverter_noptap_0.out VDD3 user_project_wrapper_0.IOVSS1 sg13_hv_nmos ad=1.408p pd=5.04u as=2.596p ps=5.58u w=4.4u l=0.6u
X4268 VDD3 a_296625_189595# a_296731_189665# VDD3 sg13_lv_pmos ad=0.2603p pd=1.75u as=0.2603p ps=1.75u w=1.37u l=0.35u
X4269 user_project_wrapper_0.IOVDD1 user_project_wrapper_0.sg13g2_IOPadIOVdd_1.sg13g2_RCClampResistor_0.p2 user_project_wrapper_0.sg13g2_IOPadIOVdd_1.sg13g2_Clamp_N43N43D4R_0.gate user_project_wrapper_0.IOVDD1 sg13_hv_pmos ad=1.33p pd=7.38u as=1.33p ps=7.38u w=7u l=0.5u
X4270 user_project_wrapper_0.IOVDD4 a_135844_355624# user_project_wrapper_0.analog_io[28] user_project_wrapper_0.IOVDD4 sg13_hv_pmos ad=2.1312p pd=7.3u as=3.9294p ps=7.84u w=6.66u l=0.6u
X4271 analog_io[22] a_355624_197044# IOVDD3 IOVDD3 sg13_hv_pmos ad=3.9294p pd=7.84u as=2.1312p ps=7.3u w=6.66u l=0.6u
X4272 a_296732_197880# a_296626_197740# VDD3 VDD3 sg13_lv_pmos ad=1.33p pd=7.38u as=1.33p ps=7.38u w=7u l=0.7u
X4273 a_304995_198817# a_307232_196607# user_project_wrapper_0.IOVSS1 user_project_wrapper_0.IOVSS1 sg13_lv_nmos ad=0.6327p pd=3.71u as=0.6327p ps=3.71u w=3.33u l=0.2u
X4274 user_project_wrapper_0.IOVDD4 user_project_wrapper_0.sg13g2_IOPadIOVdd_2.sg13g2_Clamp_N43N43D4R_0.gate user_project_wrapper_0.IOVSS1 user_project_wrapper_0.IOVSS1 sg13_hv_nmos ad=2.596p pd=5.58u as=1.408p ps=5.04u w=4.4u l=0.6u
X4275 a_190297_325263# a_189756_325263# user_project_wrapper_0.IOVSS1 user_project_wrapper_0.IOVSS1 sg13_lv_nmos ad=0.34p pd=2.68u as=0.34p ps=2.68u w=1u l=0.13u
X4276 a_305365_39542# a_305695_35456# user_project_wrapper_0.IOVSS1 rppd l=20u w=1u
X4277 a_296625_189595# a_304090_197941# a_304196_197873# user_project_wrapper_0.IOVSS1 sg13_lv_nmos ad=0.361p pd=2.28u as=0.361p ps=2.28u w=1.9u l=0.16u
X4278 user_project_wrapper_0.analog_io[6] a_41476_237844# user_project_wrapper_0.IOVDD1 user_project_wrapper_0.IOVDD1 sg13_hv_pmos ad=3.9294p pd=7.84u as=2.1312p ps=7.3u w=6.66u l=0.6u
X4279 user_project_wrapper_0.IOVSS1 user_project_wrapper_0.sg13g2_IOPadIOVdd_3.sg13g2_Clamp_N43N43D4R_0.gate IOVDD3 user_project_wrapper_0.IOVSS1 sg13_hv_nmos ad=1.408p pd=5.04u as=2.596p ps=5.58u w=4.4u l=0.6u
X4280 VDD3 user_project_wrapper_0.sg13g2_IOPadVdd_0.sg13g2_RCClampInverter_noptap_0.out user_project_wrapper_0.IOVSS1 user_project_wrapper_0.IOVSS1 sg13_hv_nmos ad=2.596p pd=5.58u as=1.408p ps=5.04u w=4.4u l=0.6u
X4281 user_project_wrapper_0.IOVSS1 a_29676_135844# user_project_wrapper_0.analog_io[1] user_project_wrapper_0.IOVSS1 sg13_hv_nmos ad=1.408p pd=5.04u as=2.596p ps=5.58u w=4.4u l=0.6u
X4282 a_208920_324155# a_208855_324776# user_project_wrapper_0.IOVSS1 w_207989_323975# sg13_lv_pmos ad=0.38p pd=2.38u as=0.38p ps=2.38u w=2u l=0.13u
X4283 a_296731_208493# a_296625_208423# VDD3 VDD3 sg13_lv_pmos ad=0.2603p pd=1.75u as=0.2603p ps=1.75u w=1.37u l=0.35u
X4284 a_271172_100118# a_270512_100118# QDLL_TOP_0.VDD QDLL_TOP_0.VDD sg13_lv_pmos ad=0.2128p pd=1.5u as=0.2128p ps=1.5u w=1.12u l=0.13u
X4285 IOVDD3 a_355624_135844# analog_io[19] IOVDD3 sg13_hv_pmos ad=2.1312p pd=7.3u as=3.9294p ps=7.84u w=6.66u l=0.6u
X4286 user_project_wrapper_0.IOVDD4 user_project_wrapper_0.sg13g2_IOPadIOVdd_2.sg13g2_Clamp_N43N43D4R_0.gate user_project_wrapper_0.IOVSS1 user_project_wrapper_0.IOVSS1 sg13_hv_nmos ad=2.596p pd=5.58u as=1.408p ps=5.04u w=4.4u l=0.6u
X4287 a_309917_199879# a_309516_194555# VDD3 VDD3 sg13_lv_pmos ad=0.19p pd=1.38u as=0.19p ps=1.38u w=1u l=0.7u
X4288 user_project_wrapper_0.IOVSS1 user_project_wrapper_0.sg13g2_IOPadIOVdd_1.sg13g2_Clamp_N43N43D4R_0.gate user_project_wrapper_0.IOVDD1 user_project_wrapper_0.IOVSS1 sg13_hv_nmos ad=1.408p pd=5.04u as=2.596p ps=5.58u w=4.4u l=0.6u
X4289 VDD3 a_309516_194555# a_309917_194695# VDD3 sg13_lv_pmos ad=0.19p pd=1.38u as=0.19p ps=1.38u w=1u l=0.7u
X4290 VDD3 a_296625_208423# a_296731_208493# VDD3 sg13_lv_pmos ad=0.4658p pd=3.42u as=0.2603p ps=1.75u w=1.37u l=0.35u
X4291 user_project_wrapper_0.IOVSS1 a_202114_326125# user_project_wrapper_0.analog_io[32] user_project_wrapper_0.IOVSS1 sg13_lv_nmos ad=0.912p pd=5.18u as=0.912p ps=5.18u w=4.8u l=0.13u
X4292 user_project_wrapper_0.IOVSS1 user_project_wrapper_0.sg13g2_IOPadAnalog_21.padres a_209041_325263# user_project_wrapper_0.IOVSS1 sg13_lv_nmos ad=0.34p pd=2.68u as=0.19p ps=1.38u w=1u l=0.13u
X4293 user_project_wrapper_0.IOVSS1 user_project_wrapper_0.sg13g2_IOPadIOVdd_2.sg13g2_Clamp_N43N43D4R_0.gate user_project_wrapper_0.IOVDD4 user_project_wrapper_0.IOVSS1 sg13_hv_nmos ad=1.408p pd=5.04u as=2.596p ps=5.58u w=4.4u l=0.6u
X4294 user_project_wrapper_0.sg13g2_IOPadVdd_3.sg13g2_RCClampInverter_noptap_0.out user_project_wrapper_0.sg13g2_IOPadVdd_3.sg13g2_RCClampResistor_0.p2 user_project_wrapper_0.IOVSS1 user_project_wrapper_0.IOVSS1 sg13_hv_pmos ad=1.33p pd=7.38u as=1.33p ps=7.38u w=7u l=0.5u
X4295 a_305365_39542# a_305035_35456# user_project_wrapper_0.IOVSS1 rppd l=20u w=1u
X4296 IOVDD3 a_355624_115444# analog_io[18] IOVDD3 sg13_hv_pmos ad=2.1312p pd=7.3u as=3.9294p ps=7.84u w=6.66u l=0.6u
X4297 analog_io[26] a_369296_278644# user_project_wrapper_0.IOVSS1 user_project_wrapper_0.IOVSS1 sg13_hv_nmos ad=2.596p pd=5.58u as=1.408p ps=5.04u w=4.4u l=0.6u
X4298 user_project_wrapper_0.IOVSS1 user_project_wrapper_0.sg13g2_IOPadIOVdd_2.sg13g2_Clamp_N43N43D4R_0.gate user_project_wrapper_0.IOVDD4 user_project_wrapper_0.IOVSS1 sg13_hv_nmos ad=1.408p pd=5.04u as=2.596p ps=5.58u w=4.4u l=0.6u
X4299 user_project_wrapper_0.IOVSS1 a_189609_324119# a_189396_324119# user_project_wrapper_0.IOVSS1 sg13_lv_nmos ad=0.19p pd=1.38u as=0.34p ps=2.68u w=1u l=0.13u
X4300 user_project_wrapper_0.IOVSS1 a_93461_128591# a_93400_129062# user_project_wrapper_0.IOVSS1 sg13_lv_nmos ad=0.2516p pd=2.16u as=0.1406p ps=1.12u w=0.74u l=0.13u
X4301 user_project_wrapper_0.analog_io[5] a_41476_217444# user_project_wrapper_0.IOVDD1 user_project_wrapper_0.IOVDD1 sg13_hv_pmos ad=3.9294p pd=7.84u as=2.1312p ps=7.3u w=6.66u l=0.6u
X4302 VDD3 a_296626_197740# a_296732_197880# VDD3 sg13_lv_pmos ad=2.38p pd=14.68u as=1.33p ps=7.38u w=7u l=0.7u
X4303 a_210621_325263# a_210417_325263# user_project_wrapper_0.IOVSS1 w_207887_326203# sg13_lv_pmos ad=0.68p pd=4.68u as=0.38p ps=2.38u w=2u l=0.13u
X4304 a_360372_73705# a_364458_73375# user_project_wrapper_0.IOVSS1 rppd l=20u w=1u
X4305 user_project_wrapper_0.IOVSS1 a_182931_326125# user_project_wrapper_0.analog_io[27] user_project_wrapper_0.IOVSS1 sg13_lv_pmos ad=1.824p pd=9.98u as=1.824p ps=9.98u w=9.6u l=0.13u
X4306 user_project_wrapper_0.IOVDD4 a_278644_355624# user_project_wrapper_0.analog_io[35] user_project_wrapper_0.IOVDD4 sg13_hv_pmos ad=2.1312p pd=7.3u as=3.9294p ps=7.84u w=6.66u l=0.6u
X4307 user_project_wrapper_0.IOVDD4 a_115444_355624# user_project_wrapper_0.analog_io[27] user_project_wrapper_0.IOVDD4 sg13_hv_pmos ad=2.1312p pd=7.3u as=3.9294p ps=7.84u w=6.66u l=0.6u
X4308 user_project_wrapper_0.IOVSS1 a_194687_324142# user_project_wrapper_0.analog_io[30] user_project_wrapper_0.IOVSS1 sg13_lv_nmos ad=0.912p pd=5.18u as=0.912p ps=5.18u w=4.8u l=0.13u
X4309 IOVDD3 a_355624_217444# analog_io[23] IOVDD3 sg13_hv_pmos ad=2.1312p pd=7.3u as=3.9294p ps=7.84u w=6.66u l=0.6u
X4310 analog_io[23] a_311108_215937# VDD3 user_project_wrapper_0.IOVSS1 sg13_lv_nmos ad=3.4p pd=20.68u as=3.4p ps=20.68u w=10u l=0.15u
X4311 a_304705_39542# a_305035_35456# user_project_wrapper_0.IOVSS1 rppd l=20u w=1u
X4312 user_project_wrapper_0.IOVSS1 a_135844_29676# user_project_wrapper_0.analog_io[10] user_project_wrapper_0.IOVSS1 sg13_hv_nmos ad=1.408p pd=5.04u as=2.596p ps=5.58u w=4.4u l=0.6u
X4313 user_project_wrapper_0.IOVSS1 a_269355_100412# a_269543_100118# user_project_wrapper_0.IOVSS1 sg13_lv_nmos ad=0.1323p pd=1.05u as=0.1428p ps=1.52u w=0.42u l=0.13u
X4314 user_project_wrapper_0.IOVSS1 user_project_wrapper_0.sg13g2_IOPadVdd_3.sg13g2_RCClampResistor_0.p2 user_project_wrapper_0.sg13g2_IOPadVdd_3.sg13g2_RCClampInverter_noptap_0.out user_project_wrapper_0.IOVSS1 sg13_hv_nmos ad=1.71p pd=9.38u as=1.71p ps=9.38u w=9u l=0.5u
X4315 user_project_wrapper_0.sg13g2_IOPadIOVdd_2.sg13g2_Clamp_N43N43D4R_0.gate user_project_wrapper_0.sg13g2_IOPadIOVdd_2.sg13g2_RCClampResistor_0.p2 user_project_wrapper_0.IOVDD4 user_project_wrapper_0.IOVDD4 sg13_hv_pmos ad=1.33p pd=7.38u as=1.33p ps=7.38u w=7u l=0.5u
X4316 user_project_wrapper_0.IOVDD2 a_135844_41476# user_project_wrapper_0.analog_io[10] user_project_wrapper_0.IOVDD2 sg13_hv_pmos ad=2.1312p pd=7.3u as=3.9294p ps=7.84u w=6.66u l=0.6u
X4317 user_project_wrapper_0.VDD1 a_87434_127896# a_89114_127896# user_project_wrapper_0.VDD1 sg13_lv_pmos ad=0.3808p pd=2.92u as=0.2128p ps=1.5u w=1.12u l=0.13u
X4318 user_project_wrapper_0.IOVSS1 a_369296_197044# analog_io[22] user_project_wrapper_0.IOVSS1 sg13_hv_nmos ad=1.408p pd=5.04u as=2.596p ps=5.58u w=4.4u l=0.6u
X4319 user_project_wrapper_0.IOVDD1 a_41476_197044# user_project_wrapper_0.analog_io[4] user_project_wrapper_0.IOVDD1 sg13_hv_pmos ad=2.1312p pd=7.3u as=3.9294p ps=7.84u w=6.66u l=0.6u
X4320 user_project_wrapper_0.analog_io[7] a_41476_258244# user_project_wrapper_0.IOVDD1 user_project_wrapper_0.IOVDD1 sg13_hv_pmos ad=3.9294p pd=7.84u as=2.1312p ps=7.3u w=6.66u l=0.6u
X4321 VDD3 a_309516_194555# a_309917_194695# VDD3 sg13_lv_pmos ad=0.19p pd=1.38u as=0.19p ps=1.38u w=1u l=0.7u
X4322 a_190824_325263# a_189184_325263# a_190722_325263# user_project_wrapper_0.IOVSS1 sg13_lv_nmos ad=0.19p pd=1.38u as=0.19p ps=1.38u w=1u l=0.13u
X4323 user_project_wrapper_0.IOVSS1 a_29676_237844# user_project_wrapper_0.analog_io[6] user_project_wrapper_0.IOVSS1 sg13_hv_nmos ad=1.408p pd=5.04u as=2.596p ps=5.58u w=4.4u l=0.6u
X4324 user_project_wrapper_0.analog_io[27] a_115444_355624# user_project_wrapper_0.IOVDD4 user_project_wrapper_0.IOVDD4 sg13_hv_pmos ad=3.9294p pd=7.84u as=2.1312p ps=7.3u w=6.66u l=0.6u
X4325 a_119785_39542# a_119455_35456# user_project_wrapper_0.IOVSS1 rppd l=20u w=1u
X4326 user_project_wrapper_0.IOVSS1 user_project_wrapper_0.sg13g2_IOPadIOVdd_3.sg13g2_Clamp_N43N43D4R_0.gate IOVDD3 user_project_wrapper_0.IOVSS1 sg13_hv_nmos ad=1.408p pd=5.04u as=2.596p ps=5.58u w=4.4u l=0.6u
X4327 user_project_wrapper_0.IOVSS1 user_project_wrapper_0.sg13g2_IOPadVdd_3.sg13g2_RCClampResistor_0.p2 user_project_wrapper_0.sg13g2_IOPadVdd_3.sg13g2_RCClampInverter_noptap_0.out user_project_wrapper_0.IOVSS1 sg13_hv_pmos ad=1.33p pd=7.38u as=1.33p ps=7.38u w=7u l=0.5u
X4328 QDLL_TOP_0.VOUT a_271172_100118# QDLL_TOP_0.VDD QDLL_TOP_0.VDD sg13_lv_pmos ad=0.2128p pd=1.5u as=0.2128p ps=1.5u w=1.12u l=0.13u
X4329 user_project_wrapper_0.IOVDD1 a_41476_237844# user_project_wrapper_0.analog_io[6] user_project_wrapper_0.IOVDD1 sg13_hv_pmos ad=2.1312p pd=7.3u as=3.9294p ps=7.84u w=6.66u l=0.6u
X4330 user_project_wrapper_0.IOVSS1 a_189672_324776# a_192138_324119# user_project_wrapper_0.IOVSS1 sg13_lv_nmos ad=0.34p pd=2.68u as=0.34p ps=2.68u w=1u l=0.65u
X4331 a_75355_364458# a_75025_360372# user_project_wrapper_0.IOVSS1 rppd l=20u w=1u
X4332 user_project_wrapper_0.IOVDD2 user_project_wrapper_0.sg13g2_IOPadIOVdd_0.sg13g2_RCClampResistor_0.p2 user_project_wrapper_0.sg13g2_IOPadIOVdd_0.sg13g2_Clamp_N43N43D4R_0.gate user_project_wrapper_0.IOVDD2 sg13_hv_pmos ad=1.33p pd=7.38u as=1.33p ps=7.38u w=7u l=0.5u
X4333 user_project_wrapper_0.IOVSS1 a_202114_326125# user_project_wrapper_0.analog_io[32] user_project_wrapper_0.IOVSS1 sg13_lv_pmos ad=1.824p pd=9.98u as=1.824p ps=9.98u w=9.6u l=0.13u
X4334 user_project_wrapper_0.IOVDD1 user_project_wrapper_0.sg13g2_IOPadIOVdd_1.sg13g2_RCClampResistor_0.p2 user_project_wrapper_0.sg13g2_IOPadIOVdd_1.sg13g2_Clamp_N43N43D4R_0.gate user_project_wrapper_0.IOVDD1 sg13_hv_pmos ad=1.33p pd=7.38u as=1.33p ps=7.38u w=7u l=0.5u
X4335 a_119125_39542# a_119455_35456# user_project_wrapper_0.IOVSS1 rppd l=20u w=1u
X4336 a_194687_324142# a_194279_327536# user_project_wrapper_0.IOVSS1 user_project_wrapper_0.IOVSS1 sg13_lv_nmos ad=0.912p pd=5.18u as=0.912p ps=5.18u w=4.8u l=0.13u
X4337 user_project_wrapper_0.IOVSS1 a_369296_278644# analog_io[26] user_project_wrapper_0.IOVSS1 sg13_hv_nmos ad=1.408p pd=5.04u as=2.596p ps=5.58u w=4.4u l=0.6u
X4338 a_309917_194695# a_309516_194555# VDD3 VDD3 sg13_lv_pmos ad=0.19p pd=1.38u as=0.19p ps=1.38u w=1u l=0.7u
X4339 user_project_wrapper_0.analog_io[32] a_202114_326125# user_project_wrapper_0.IOVSS1 user_project_wrapper_0.IOVSS1 sg13_lv_nmos ad=0.912p pd=5.18u as=0.912p ps=5.18u w=4.8u l=0.13u
X4340 user_project_wrapper_0.IOVDD2 user_project_wrapper_0.sg13g2_IOPadIOVdd_0.sg13g2_RCClampResistor_0.p2 user_project_wrapper_0.sg13g2_IOPadIOVdd_0.sg13g2_Clamp_N43N43D4R_0.gate user_project_wrapper_0.IOVDD2 sg13_hv_pmos ad=1.33p pd=7.38u as=1.33p ps=7.38u w=7u l=0.5u
X4341 a_190082_92557# a_189524_90472# user_project_wrapper_0.IOVSS1 rppd l=10u w=1u
X4342 VDD3 a_296626_197740# a_296626_197740# VDD3 sg13_lv_pmos ad=0.476p pd=3.48u as=0.266p ps=1.78u w=1.4u l=0.35u
X4343 a_309917_194695# user_project_wrapper_0.sg13g2_IOPadAnalog_29.padres a_311846_195517# VDD3 sg13_lv_pmos ad=0.24415p pd=1.665u as=0.24415p ps=1.665u w=1.285u l=0.35u
X4344 a_119125_39542# a_118795_35456# user_project_wrapper_0.IOVSS1 rppd l=20u w=1u
X4345 user_project_wrapper_0.analog_io[12] a_176644_29676# user_project_wrapper_0.IOVSS1 user_project_wrapper_0.IOVSS1 sg13_hv_nmos ad=2.596p pd=5.58u as=2.068p ps=9.74u w=4.4u l=0.6u
X4346 VDD3 user_project_wrapper_0.sg13g2_IOPadVdd_0.sg13g2_RCClampInverter_noptap_0.out user_project_wrapper_0.IOVSS1 user_project_wrapper_0.IOVSS1 sg13_hv_nmos ad=2.596p pd=5.58u as=1.408p ps=5.04u w=4.4u l=0.6u
X4347 a_189016_101343# a_188760_101343# QDLL_TOP_0.VDD QDLL_TOP_0.VDD sg13_lv_pmos ad=0.34p pd=2.68u as=0.2481p ps=1.56u w=1u l=0.25u
X4348 user_project_wrapper_0.analog_io[12] a_176644_41476# user_project_wrapper_0.IOVDD2 user_project_wrapper_0.IOVDD2 sg13_hv_pmos ad=3.9294p pd=7.84u as=2.1312p ps=7.3u w=6.66u l=0.6u
X4349 a_90579_127530# a_84598_130577# user_project_wrapper_0.VDD1 user_project_wrapper_0.VDD1 sg13_lv_pmos ad=0.3808p pd=2.92u as=0.3808p ps=2.92u w=1.12u l=0.13u
X4350 user_project_wrapper_0.VDD1 user_project_wrapper_0.sg13g2_IOPadVdd_2.sg13g2_RCClampInverter_noptap_0.out user_project_wrapper_0.IOVSS1 user_project_wrapper_0.IOVSS1 sg13_hv_nmos ad=2.596p pd=5.58u as=1.408p ps=5.04u w=4.4u l=0.6u
X4351 user_project_wrapper_0.VDD2 user_project_wrapper_0.sg13g2_IOPadVdd_1.sg13g2_RCClampInverter_noptap_0.out user_project_wrapper_0.IOVSS1 user_project_wrapper_0.IOVSS1 sg13_hv_nmos ad=2.596p pd=5.58u as=1.408p ps=5.04u w=4.4u l=0.6u
X4352 user_project_wrapper_0.analog_io[7] a_87832_241383# user_project_wrapper_0.IOVSS1 user_project_wrapper_0.IOVSS1 sg13_lv_nmos ad=2.516p pd=15.48u as=2.516p ps=15.48u w=7.4u l=0.13u
X4353 IOVDD3 user_project_wrapper_0.sg13g2_IOPadIOVdd_3.sg13g2_Clamp_N43N43D4R_0.gate user_project_wrapper_0.IOVSS1 user_project_wrapper_0.IOVSS1 sg13_hv_nmos ad=2.596p pd=5.58u as=1.408p ps=5.04u w=4.4u l=0.6u
X4354 user_project_wrapper_0.IOVDD4 user_project_wrapper_0.sg13g2_IOPadIOVdd_2.sg13g2_Clamp_N43N43D4R_0.gate user_project_wrapper_0.IOVSS1 user_project_wrapper_0.IOVSS1 sg13_hv_nmos ad=2.596p pd=5.58u as=1.408p ps=5.04u w=4.4u l=0.6u
X4355 user_project_wrapper_0.IOVSS1 user_project_wrapper_0.IOVSS1 user_project_wrapper_0.IOVSS1 rhigh l=4u w=0.5u
X4356 IOVDD3 user_project_wrapper_0.sg13g2_IOPadIOVdd_3.sg13g2_Clamp_N43N43D4R_0.gate user_project_wrapper_0.IOVSS1 user_project_wrapper_0.IOVSS1 sg13_hv_nmos ad=2.596p pd=5.58u as=1.408p ps=5.04u w=4.4u l=0.6u
X4357 user_project_wrapper_0.IOVSS1 a_59490_159238# user_project_wrapper_0.sg13g2_IOPadIn$1_0.p2c user_project_wrapper_0.IOVSS1 sg13_lv_nmos ad=0.935p pd=6.18u as=0.935p ps=6.18u w=2.75u l=0.13u
X4358 user_project_wrapper_0.IOVSS1 user_project_wrapper_0.analog_io[29] dantenna l=1.26u w=27.78u
X4359 a_208367_327491# user_project_wrapper_0.IOVSS1 user_project_wrapper_0.IOVSS1 w_207887_327938# sg13_lv_pmos ad=0.38p pd=2.38u as=0.68p ps=4.68u w=2u l=0.13u
X4360 user_project_wrapper_0.IOVSS1 a_182931_326125# user_project_wrapper_0.analog_io[27] user_project_wrapper_0.IOVSS1 sg13_lv_nmos ad=0.912p pd=5.18u as=0.912p ps=5.18u w=4.8u l=0.13u
X4361 analog_io[20] a_369296_156244# user_project_wrapper_0.IOVSS1 user_project_wrapper_0.IOVSS1 sg13_hv_nmos ad=2.596p pd=5.58u as=1.408p ps=5.04u w=4.4u l=0.6u
X4362 user_project_wrapper_0.IOVDD1 user_project_wrapper_0.sg13g2_IOPadIOVdd_1.sg13g2_Clamp_N43N43D4R_0.gate user_project_wrapper_0.IOVSS1 user_project_wrapper_0.IOVSS1 sg13_hv_nmos ad=2.596p pd=5.58u as=1.408p ps=5.04u w=4.4u l=0.6u
X4363 user_project_wrapper_0.IOVSS1 a_314793_197200# a_313884_185173# user_project_wrapper_0.IOVSS1 sg13_lv_nmos ad=1.02p pd=6.68u as=0.57p ps=3.38u w=3u l=1u
X4364 a_190389_99046# a_189729_99046# user_project_wrapper_0.IOVSS1 user_project_wrapper_0.IOVSS1 sg13_lv_nmos ad=0.1406p pd=1.12u as=0.1406p ps=1.12u w=0.74u l=0.13u
X4365 a_191438_325263# a_191234_325263# user_project_wrapper_0.IOVSS1 w_188704_326203# sg13_lv_pmos ad=0.38p pd=2.38u as=0.68p ps=4.68u w=2u l=0.13u
X4366 VDD3 a_296625_208423# a_296731_208493# VDD3 sg13_lv_pmos ad=0.2603p pd=1.75u as=0.2603p ps=1.75u w=1.37u l=0.35u
X4367 a_303715_364458# a_304045_360372# user_project_wrapper_0.IOVSS1 rppd l=20u w=1u
X4368 a_209480_327491# a_208939_327491# user_project_wrapper_0.IOVSS1 user_project_wrapper_0.IOVSS1 sg13_lv_nmos ad=0.34p pd=2.68u as=0.34p ps=2.68u w=1u l=0.13u
X4369 VDD3 a_309516_194555# a_309917_199879# VDD3 sg13_lv_pmos ad=0.19p pd=1.38u as=0.19p ps=1.38u w=1u l=0.7u
X4370 a_304196_200821# a_304889_199957# a_304995_198817# user_project_wrapper_0.IOVSS1 sg13_lv_nmos ad=0.209p pd=1.48u as=0.209p ps=1.48u w=1.1u l=0.15u
X4371 user_project_wrapper_0.IOVSS1 user_project_wrapper_0.sg13g2_IOPadVdd_3.sg13g2_RCClampInverter_noptap_0.out user_project_wrapper_0.IOVSS1 user_project_wrapper_0.IOVSS1 sg13_hv_nmos ad=2.596p pd=5.58u as=0 ps=0 w=4.4u l=0.6u
X4372 user_project_wrapper_0.IOVDD4 a_278644_355624# user_project_wrapper_0.analog_io[35] user_project_wrapper_0.IOVDD4 sg13_hv_pmos ad=2.1312p pd=7.3u as=3.9294p ps=7.84u w=6.66u l=0.6u
X4373 user_project_wrapper_0.sg13g2_IOPadIOVdd_2.sg13g2_Clamp_N43N43D4R_0.gate user_project_wrapper_0.sg13g2_IOPadIOVdd_2.sg13g2_RCClampResistor_0.p2 user_project_wrapper_0.IOVDD4 user_project_wrapper_0.IOVDD4 sg13_hv_pmos ad=1.33p pd=7.38u as=1.33p ps=7.38u w=7u l=0.5u
X4374 user_project_wrapper_0.sg13g2_IOPadIOVdd_1.sg13g2_Clamp_N43N43D4R_0.gate user_project_wrapper_0.sg13g2_IOPadIOVdd_1.sg13g2_RCClampResistor_0.p2 user_project_wrapper_0.IOVSS1 user_project_wrapper_0.IOVSS1 sg13_hv_nmos ad=1.71p pd=9.38u as=1.71p ps=9.38u w=9u l=0.5u
X4375 user_project_wrapper_0.sg13g2_IOPadVdd_0.sg13g2_RCClampInverter_noptap_0.out user_project_wrapper_0.sg13g2_IOPadVdd_0.sg13g2_RCClampResistor_0.p2 VDD3 VDD3 sg13_hv_pmos ad=1.33p pd=7.38u as=1.33p ps=7.38u w=7u l=0.5u
X4376 user_project_wrapper_0.IOVSS1 a_301186_192011# a_296731_208493# user_project_wrapper_0.IOVSS1 sg13_lv_nmos ad=0.912p pd=5.18u as=0.912p ps=5.18u w=4.8u l=1.06u
X4377 user_project_wrapper_0.uo_PAD[8] user_project_wrapper_0.sg13g2_IOPadOut4mA$1_1.sg13g2_GateLevelUpInv_noptap$1$1_0.pgate user_project_wrapper_0.IOVDD1 user_project_wrapper_0.IOVDD1 sg13_hv_pmos ad=3.9294p pd=7.84u as=3.1302p ps=14.26u w=6.66u l=0.6u
X4378 user_project_wrapper_0.IOVSS1 user_project_wrapper_0.sg13g2_IOPadIOVdd_2.sg13g2_Clamp_N43N43D4R_0.gate user_project_wrapper_0.IOVDD4 user_project_wrapper_0.IOVSS1 sg13_hv_nmos ad=1.408p pd=5.04u as=2.596p ps=5.58u w=4.4u l=0.6u
X4379 user_project_wrapper_0.IOVDD2 a_156244_41476# user_project_wrapper_0.analog_io[11] user_project_wrapper_0.IOVDD2 sg13_hv_pmos ad=2.1312p pd=7.3u as=3.9294p ps=7.84u w=6.66u l=0.6u
X4380 a_78219_135283# a_78219_134797# user_project_wrapper_0.IOVSS1 rppd l=2u w=0.5u
X4381 user_project_wrapper_0.sg13g2_IOPadVdd_1.sg13g2_RCClampInverter_noptap_0.out user_project_wrapper_0.sg13g2_IOPadVdd_1.sg13g2_RCClampResistor_0.p2 user_project_wrapper_0.VDD2 user_project_wrapper_0.VDD2 sg13_hv_pmos ad=1.33p pd=7.38u as=1.33p ps=7.38u w=7u l=0.5u
X4382 a_296625_208423# a_304090_197941# a_304196_200821# user_project_wrapper_0.IOVSS1 sg13_lv_nmos ad=0.361p pd=2.28u as=0.646p ps=4.48u w=1.9u l=0.16u
X4383 user_project_wrapper_0.IOVSS1 user_project_wrapper_0.sg13g2_IOPadIOVdd_2.sg13g2_Clamp_N43N43D4R_0.gate user_project_wrapper_0.IOVDD4 user_project_wrapper_0.IOVSS1 sg13_hv_nmos ad=1.408p pd=5.04u as=2.596p ps=5.58u w=4.4u l=0.6u
X4384 user_project_wrapper_0.IOVDD1 user_project_wrapper_0.sg13g2_IOPadIOVdd_1.sg13g2_Clamp_N43N43D4R_0.gate user_project_wrapper_0.IOVSS1 user_project_wrapper_0.IOVSS1 sg13_hv_nmos ad=2.596p pd=5.58u as=1.408p ps=5.04u w=4.4u l=0.6u
X4385 user_project_wrapper_0.VDD1 user_project_wrapper_0.sg13g2_IOPadVdd_2.sg13g2_RCClampInverter_noptap_0.out user_project_wrapper_0.IOVSS1 user_project_wrapper_0.IOVSS1 sg13_hv_nmos ad=2.596p pd=5.58u as=1.408p ps=5.04u w=4.4u l=0.6u
X4386 user_project_wrapper_0.IOVSS1 analog_io[20] dantenna l=0.64u w=3.1u
X4387 user_project_wrapper_0.IOVSS1 user_project_wrapper_0.IOVSS1 user_project_wrapper_0.IOVSS1 rppd l=0.5u w=0.5u
X4388 user_project_wrapper_0.IOVSS1 user_project_wrapper_0.sg13g2_IOPadVdd_3.sg13g2_RCClampResistor_0.p2 user_project_wrapper_0.sg13g2_IOPadVdd_3.sg13g2_RCClampInverter_noptap_0.out user_project_wrapper_0.IOVSS1 sg13_hv_pmos ad=1.33p pd=7.38u as=1.33p ps=7.38u w=7u l=0.5u
X4389 user_project_wrapper_0.IOVDD2 user_project_wrapper_0.sg13g2_IOPadIOVdd_0.sg13g2_Clamp_N43N43D4R_0.gate user_project_wrapper_0.IOVSS1 user_project_wrapper_0.IOVSS1 sg13_hv_nmos ad=2.596p pd=5.58u as=1.408p ps=5.04u w=4.4u l=0.6u
X4390 user_project_wrapper_0.IOVSS1 a_29676_115444# user_project_wrapper_0.analog_io[0] user_project_wrapper_0.IOVSS1 sg13_hv_nmos ad=1.408p pd=5.04u as=2.596p ps=5.58u w=4.4u l=0.6u
X4391 a_189756_329719# user_project_wrapper_0.IOVSS1 user_project_wrapper_0.IOVSS1 w_188700_330166# sg13_lv_pmos ad=0.38p pd=2.38u as=0.68p ps=4.68u w=2u l=0.13u
X4392 user_project_wrapper_0.IOVSS1 a_202114_326125# user_project_wrapper_0.analog_io[32] user_project_wrapper_0.IOVSS1 sg13_lv_nmos ad=0.912p pd=5.18u as=0.912p ps=5.18u w=4.8u l=0.13u
X4393 analog_io[20] a_355624_156244# IOVDD3 IOVDD3 sg13_hv_pmos ad=3.9294p pd=7.84u as=2.1312p ps=7.3u w=6.66u l=0.6u
X4394 user_project_wrapper_0.analog_io[15] a_237844_41476# user_project_wrapper_0.IOVDD2 user_project_wrapper_0.IOVDD2 sg13_hv_pmos ad=3.9294p pd=7.84u as=2.1312p ps=7.3u w=6.66u l=0.6u
X4395 user_project_wrapper_0.IOVDD2 user_project_wrapper_0.sg13g2_IOPadIOVdd_0.sg13g2_RCClampResistor_0.p2 user_project_wrapper_0.sg13g2_IOPadIOVdd_0.sg13g2_Clamp_N43N43D4R_0.gate user_project_wrapper_0.IOVDD2 sg13_hv_pmos ad=1.33p pd=7.38u as=1.33p ps=7.38u w=7u l=0.5u
X4396 analog_io[23] a_311108_215937# VDD3 user_project_wrapper_0.IOVSS1 sg13_lv_nmos ad=3.4p pd=20.68u as=3.4p ps=20.68u w=10u l=0.15u
X4397 user_project_wrapper_0.IOVSS1 a_278644_369296# user_project_wrapper_0.analog_io[35] user_project_wrapper_0.IOVSS1 sg13_hv_nmos ad=2.068p pd=9.74u as=2.596p ps=5.58u w=4.4u l=0.6u
X4398 user_project_wrapper_0.IOVSS1 user_project_wrapper_0.IOVSS1 user_project_wrapper_0.IOVSS1 rppd l=0.5u w=0.5u
X4399 user_project_wrapper_0.sg13g2_IOPadIOVdd_1.sg13g2_Clamp_N43N43D4R_0.gate user_project_wrapper_0.sg13g2_IOPadIOVdd_1.sg13g2_RCClampResistor_0.p2 user_project_wrapper_0.IOVSS1 user_project_wrapper_0.IOVSS1 sg13_hv_nmos ad=1.71p pd=9.38u as=1.71p ps=9.38u w=9u l=0.5u
X4400 user_project_wrapper_0.analog_io[35] a_213870_324142# user_project_wrapper_0.IOVSS1 user_project_wrapper_0.IOVSS1 sg13_lv_nmos ad=0.912p pd=5.18u as=0.912p ps=5.18u w=4.8u l=0.13u
X4401 user_project_wrapper_0.IOVSS1 user_project_wrapper_0.sg13g2_IOPadVdd_3.sg13g2_RCClampResistor_0.p2 user_project_wrapper_0.sg13g2_IOPadVdd_3.sg13g2_RCClampInverter_noptap_0.out user_project_wrapper_0.IOVSS1 sg13_hv_nmos ad=1.71p pd=9.38u as=1.71p ps=9.38u w=9u l=0.5u
X4402 user_project_wrapper_0.IOVSS1 a_182931_326125# user_project_wrapper_0.analog_io[27] user_project_wrapper_0.IOVSS1 sg13_lv_nmos ad=0.912p pd=5.18u as=0.912p ps=5.18u w=4.8u l=0.13u
X4403 user_project_wrapper_0.analog_io[12] a_176644_41476# user_project_wrapper_0.IOVDD2 user_project_wrapper_0.IOVDD2 sg13_hv_pmos ad=3.9294p pd=7.84u as=2.1312p ps=7.3u w=6.66u l=0.6u
X4404 VDD3 a_309516_194555# a_309917_199879# VDD3 sg13_lv_pmos ad=0.19p pd=1.38u as=0.19p ps=1.38u w=1u l=0.7u
X4405 user_project_wrapper_0.IOVSS1 user_project_wrapper_0.sg13g2_IOPadIOVdd_1.sg13g2_Clamp_N43N43D4R_0.gate user_project_wrapper_0.IOVDD1 user_project_wrapper_0.IOVSS1 sg13_hv_nmos ad=1.408p pd=5.04u as=2.596p ps=5.58u w=4.4u l=0.6u
X4406 user_project_wrapper_0.IOVSS1 user_project_wrapper_0.sg13g2_IOPadIOVdd_0.sg13g2_Clamp_N43N43D4R_0.gate user_project_wrapper_0.IOVDD2 user_project_wrapper_0.IOVSS1 sg13_hv_nmos ad=1.408p pd=5.04u as=2.596p ps=5.58u w=4.4u l=0.6u
X4407 analog_io[25] a_355624_258244# IOVDD3 IOVDD3 sg13_hv_pmos ad=3.9294p pd=7.84u as=2.1312p ps=7.3u w=6.66u l=0.6u
X4408 a_309917_194695# a_309516_194555# VDD3 VDD3 sg13_lv_pmos ad=0.19p pd=1.38u as=0.19p ps=1.38u w=1u l=0.7u
X4409 user_project_wrapper_0.IOVSS1 user_project_wrapper_0.IOVSS1 user_project_wrapper_0.IOVSS1 rppd l=0.5u w=0.5u
X4410 IOVDD3 user_project_wrapper_0.sg13g2_IOPadIOVdd_3.sg13g2_Clamp_N43N43D4R_0.gate user_project_wrapper_0.IOVSS1 user_project_wrapper_0.IOVSS1 sg13_hv_nmos ad=2.596p pd=5.58u as=1.408p ps=5.04u w=4.4u l=0.6u
X4411 user_project_wrapper_0.analog_io[10] a_135844_41476# user_project_wrapper_0.IOVDD2 user_project_wrapper_0.IOVDD2 sg13_hv_pmos ad=3.9294p pd=7.84u as=3.1302p ps=14.26u w=6.66u l=0.6u
X4412 user_project_wrapper_0.IOVSS1 a_369296_156244# analog_io[20] user_project_wrapper_0.IOVSS1 sg13_hv_nmos ad=1.408p pd=5.04u as=2.596p ps=5.58u w=4.4u l=0.6u
X4413 VDD3 a_309516_194555# a_309917_199879# VDD3 sg13_lv_pmos ad=0.19p pd=1.38u as=0.19p ps=1.38u w=1u l=0.7u
X4414 user_project_wrapper_0.IOVSS1 a_29676_197044# user_project_wrapper_0.analog_io[4] user_project_wrapper_0.IOVSS1 sg13_hv_nmos ad=1.408p pd=5.04u as=2.596p ps=5.58u w=4.4u l=0.6u
X4415 user_project_wrapper_0.sg13g2_IOPadVdd_3.sg13g2_RCClampInverter_noptap_0.out user_project_wrapper_0.sg13g2_IOPadVdd_3.sg13g2_RCClampResistor_0.p2 user_project_wrapper_0.IOVSS1 user_project_wrapper_0.IOVSS1 sg13_hv_pmos ad=1.33p pd=7.38u as=1.33p ps=7.38u w=7u l=0.5u
X4416 a_296731_208493# a_296625_208423# VDD3 VDD3 sg13_lv_pmos ad=0.2603p pd=1.75u as=0.2603p ps=1.75u w=1.37u l=0.35u
X4417 a_271172_100118# a_270512_100118# QDLL_TOP_0.VDD QDLL_TOP_0.VDD sg13_lv_pmos ad=0.2128p pd=1.5u as=0.2128p ps=1.5u w=1.12u l=0.13u
X4418 user_project_wrapper_0.analog_io[0] a_29676_115444# user_project_wrapper_0.IOVSS1 user_project_wrapper_0.IOVSS1 sg13_hv_nmos ad=2.596p pd=5.58u as=1.408p ps=5.04u w=4.4u l=0.6u
X4419 user_project_wrapper_0.IOVDD2 a_237844_41476# user_project_wrapper_0.analog_io[15] user_project_wrapper_0.IOVDD2 sg13_hv_pmos ad=2.1312p pd=7.3u as=3.9294p ps=7.84u w=6.66u l=0.6u
X4420 a_311846_195517# user_project_wrapper_0.sg13g2_IOPadAnalog_29.padres a_309917_199879# VDD3 sg13_lv_pmos ad=0.24415p pd=1.665u as=0.24415p ps=1.665u w=1.285u l=0.35u
X4421 a_296731_208493# a_296625_208423# VDD3 VDD3 sg13_lv_pmos ad=0.2603p pd=1.75u as=0.2603p ps=1.75u w=1.37u l=0.35u
X4422 a_209684_326377# a_208367_326377# user_project_wrapper_0.IOVSS1 w_207887_326203# sg13_lv_pmos ad=0.68p pd=4.68u as=0.68p ps=4.68u w=2u l=0.13u
X4423 user_project_wrapper_0.IOVDD4 user_project_wrapper_0.sg13g2_IOPadIOVdd_2.sg13g2_Clamp_N43N43D4R_0.gate user_project_wrapper_0.IOVSS1 user_project_wrapper_0.IOVSS1 sg13_hv_nmos ad=2.596p pd=5.58u as=1.408p ps=5.04u w=4.4u l=0.6u
X4424 a_35456_81295# user_project_wrapper_0.sg13g2_IOPadVdd_2.sg13g2_RCClampResistor_0.p2 user_project_wrapper_0.IOVSS1 rppd l=20u w=1u
X4425 user_project_wrapper_0.IOVDD1 a_41476_197044# user_project_wrapper_0.analog_io[4] user_project_wrapper_0.IOVDD1 sg13_hv_pmos ad=2.1312p pd=7.3u as=3.9294p ps=7.84u w=6.66u l=0.6u
X4426 user_project_wrapper_0.analog_io[7] a_41476_258244# user_project_wrapper_0.IOVDD1 user_project_wrapper_0.IOVDD1 sg13_hv_pmos ad=3.9294p pd=7.84u as=2.1312p ps=7.3u w=6.66u l=0.6u
X4427 a_360372_298105# a_364458_297775# user_project_wrapper_0.IOVSS1 rppd l=20u w=1u
X4428 user_project_wrapper_0.analog_io[35] a_278644_369296# user_project_wrapper_0.IOVSS1 user_project_wrapper_0.IOVSS1 sg13_hv_nmos ad=2.596p pd=5.58u as=1.408p ps=5.04u w=4.4u l=0.6u
X4429 user_project_wrapper_0.analog_io[27] a_115444_369296# user_project_wrapper_0.IOVSS1 user_project_wrapper_0.IOVSS1 sg13_hv_nmos ad=2.596p pd=5.58u as=1.408p ps=5.04u w=4.4u l=0.6u
X4430 a_315347_192648# a_314793_201808# a_314697_196700# user_project_wrapper_0.IOVSS1 sg13_lv_nmos ad=1.14p pd=6.38u as=1.14p ps=6.38u w=6u l=6.4u
X4431 a_93208_127531# a_92512_127896# user_project_wrapper_0.VDD1 user_project_wrapper_0.VDD1 sg13_lv_pmos ad=0.3808p pd=2.92u as=0.3808p ps=2.92u w=1.12u l=0.13u
X4432 user_project_wrapper_0.IOVSS1 a_202114_326125# user_project_wrapper_0.analog_io[32] user_project_wrapper_0.IOVSS1 sg13_lv_nmos ad=0.912p pd=5.18u as=0.912p ps=5.18u w=4.8u l=0.13u
X4433 user_project_wrapper_0.IOVSS1 user_project_wrapper_0.sg13g2_IOPadIOVdd_2.sg13g2_Clamp_N43N43D4R_0.gate user_project_wrapper_0.IOVDD4 user_project_wrapper_0.IOVSS1 sg13_hv_nmos ad=1.408p pd=5.04u as=2.596p ps=5.58u w=4.4u l=0.6u
X4434 VDD3 a_296625_189595# a_296731_189665# VDD3 sg13_lv_pmos ad=0.2603p pd=1.75u as=0.2603p ps=1.75u w=1.37u l=0.35u
X4435 user_project_wrapper_0.IOVDD1 a_41476_217444# user_project_wrapper_0.analog_io[5] user_project_wrapper_0.IOVDD1 sg13_hv_pmos ad=2.1312p pd=7.3u as=3.9294p ps=7.84u w=6.66u l=0.6u
X4436 user_project_wrapper_0.IOVSS1 a_189395_99046# a_189729_99046# user_project_wrapper_0.IOVSS1 sg13_lv_nmos ad=0.1406p pd=1.12u as=0.1406p ps=1.12u w=0.74u l=0.13u
X4437 a_93298_129062# a_87105_130835# a_93204_129062# user_project_wrapper_0.IOVSS1 sg13_lv_nmos ad=0.1406p pd=1.12u as=0.2516p ps=2.16u w=0.74u l=0.13u
X4438 a_304196_197873# a_304889_198885# a_304995_198817# user_project_wrapper_0.IOVSS1 sg13_lv_nmos ad=0.209p pd=1.48u as=0.209p ps=1.48u w=1.1u l=0.15u
X4439 user_project_wrapper_0.IOVSS1 user_project_wrapper_0.sg13g2_IOPadIOVdd_2.sg13g2_Clamp_N43N43D4R_0.gate user_project_wrapper_0.IOVDD4 user_project_wrapper_0.IOVSS1 sg13_hv_nmos ad=1.408p pd=5.04u as=2.596p ps=5.58u w=4.4u l=0.6u
X4440 a_210621_325263# a_210417_325263# user_project_wrapper_0.IOVSS1 w_207887_326203# sg13_lv_pmos ad=0.38p pd=2.38u as=0.68p ps=4.68u w=2u l=0.13u
X4441 user_project_wrapper_0.IOVDD2 user_project_wrapper_0.sg13g2_IOPadIOVdd_0.sg13g2_Clamp_N43N43D4R_0.gate user_project_wrapper_0.IOVSS1 user_project_wrapper_0.IOVSS1 sg13_hv_nmos ad=2.596p pd=5.58u as=1.408p ps=5.04u w=4.4u l=0.6u
X4442 a_209905_328605# a_208939_328605# user_project_wrapper_0.IOVSS1 w_207887_327938# sg13_lv_pmos ad=0.38p pd=2.38u as=0.68p ps=4.68u w=2u l=0.13u
X4443 a_190389_99046# a_189729_99046# user_project_wrapper_0.IOVSS1 user_project_wrapper_0.IOVSS1 sg13_lv_nmos ad=0.1406p pd=1.12u as=0.2516p ps=2.16u w=0.74u l=0.13u
X4444 user_project_wrapper_0.IOVSS1 a_182931_326125# user_project_wrapper_0.analog_io[27] user_project_wrapper_0.IOVSS1 sg13_lv_pmos ad=1.824p pd=9.98u as=1.824p ps=9.98u w=9.6u l=0.13u
X4445 user_project_wrapper_0.IOVDD1 user_project_wrapper_0.sg13g2_IOPadIOVdd_1.sg13g2_RCClampResistor_0.p2 user_project_wrapper_0.sg13g2_IOPadIOVdd_1.sg13g2_Clamp_N43N43D4R_0.gate user_project_wrapper_0.IOVDD1 sg13_hv_pmos ad=1.33p pd=7.38u as=1.33p ps=7.38u w=7u l=0.5u
X4446 user_project_wrapper_0.IOVSS1 a_307232_196607# a_304995_198817# user_project_wrapper_0.IOVSS1 sg13_lv_nmos ad=0.6327p pd=3.71u as=0.6327p ps=3.71u w=3.33u l=0.2u
X4447 a_360372_77005# a_364458_76675# user_project_wrapper_0.IOVSS1 rppd l=20u w=1u
X4448 a_190304_110495# a_190862_108410# user_project_wrapper_0.IOVSS1 rppd l=10u w=1u
X4449 a_314793_201808# a_314793_201808# user_project_wrapper_0.IOVSS1 user_project_wrapper_0.IOVSS1 sg13_lv_nmos ad=2.04p pd=12.68u as=1.14p ps=6.38u w=6u l=6.4u
X4450 QDLL_TOP_0.VDD a_190389_101343# user_project_wrapper_0.analog_io[15] QDLL_TOP_0.VDD sg13_lv_pmos ad=0.2128p pd=1.5u as=0.2128p ps=1.5u w=1.12u l=0.13u
X4451 user_project_wrapper_0.IOVDD1 user_project_wrapper_0.sg13g2_IOPadIOVdd_1.sg13g2_RCClampResistor_0.p2 user_project_wrapper_0.sg13g2_IOPadIOVdd_1.sg13g2_Clamp_N43N43D4R_0.gate user_project_wrapper_0.IOVDD1 sg13_hv_pmos ad=1.33p pd=7.38u as=1.33p ps=7.38u w=7u l=0.5u
X4452 user_project_wrapper_0.IOVSS1 user_project_wrapper_0.sg13g2_IOPadIOVdd_2.sg13g2_Clamp_N43N43D4R_0.gate user_project_wrapper_0.IOVDD4 user_project_wrapper_0.IOVSS1 sg13_hv_nmos ad=1.408p pd=5.04u as=2.596p ps=5.58u w=4.4u l=0.6u
X4453 a_296731_189665# a_296625_189595# VDD3 VDD3 sg13_lv_pmos ad=0.2603p pd=1.75u as=0.2603p ps=1.75u w=1.37u l=0.35u
X4454 user_project_wrapper_0.IOVDD2 a_197044_41476# user_project_wrapper_0.analog_io[13] user_project_wrapper_0.IOVDD2 sg13_hv_pmos ad=2.1312p pd=7.3u as=3.9294p ps=7.84u w=6.66u l=0.6u
X4455 user_project_wrapper_0.IOVSS1 a_369296_258244# analog_io[25] user_project_wrapper_0.IOVSS1 sg13_hv_nmos ad=1.408p pd=5.04u as=2.596p ps=5.58u w=4.4u l=0.6u
X4456 user_project_wrapper_0.analog_io[11] user_project_wrapper_0.IOVDD2 dpantenna l=1.26u w=27.78u
X4457 user_project_wrapper_0.IOVDD1 a_41476_258244# user_project_wrapper_0.analog_io[7] user_project_wrapper_0.IOVDD1 sg13_hv_pmos ad=2.1312p pd=7.3u as=3.9294p ps=7.84u w=6.66u l=0.6u
X4458 user_project_wrapper_0.IOVSS1 user_project_wrapper_0.sg13g2_IOPadIOVdd_2.sg13g2_Clamp_N43N43D4R_0.gate user_project_wrapper_0.IOVDD4 user_project_wrapper_0.IOVSS1 sg13_hv_nmos ad=1.408p pd=5.04u as=2.596p ps=5.58u w=4.4u l=0.6u
X4459 user_project_wrapper_0.VDD2 user_project_wrapper_0.sg13g2_IOPadVdd_1.sg13g2_RCClampInverter_noptap_0.out user_project_wrapper_0.IOVSS1 user_project_wrapper_0.IOVSS1 sg13_hv_nmos ad=2.596p pd=5.58u as=1.408p ps=5.04u w=4.4u l=0.6u
X4460 user_project_wrapper_0.analog_io[1] user_project_wrapper_0.sg13g2_IOPadAnalog_9.padres user_project_wrapper_0.IOVSS1 rppd l=2u w=1u
X4461 IOVDD3 a_355624_258244# analog_io[25] IOVDD3 sg13_hv_pmos ad=2.1312p pd=7.3u as=3.9294p ps=7.84u w=6.66u l=0.6u
X4462 VDD3 a_296625_189595# a_296731_189665# VDD3 sg13_lv_pmos ad=0.4658p pd=3.42u as=0.2603p ps=1.75u w=1.37u l=0.35u
X4463 user_project_wrapper_0.IOVDD1 user_project_wrapper_0.sg13g2_IOPadIOVdd_1.sg13g2_Clamp_N43N43D4R_0.gate user_project_wrapper_0.IOVSS1 user_project_wrapper_0.IOVSS1 sg13_hv_nmos ad=2.596p pd=5.58u as=1.408p ps=5.04u w=4.4u l=0.6u
X4464 user_project_wrapper_0.IOVSS1 a_271172_100118# QDLL_TOP_0.VOUT user_project_wrapper_0.IOVSS1 sg13_lv_nmos ad=0.1406p pd=1.12u as=0.1406p ps=1.12u w=0.74u l=0.13u
X4465 a_309516_194555# a_309516_194555# VDD3 VDD3 sg13_lv_pmos ad=0.19p pd=1.38u as=0.19p ps=1.38u w=1u l=0.7u
X4466 a_296625_208423# a_301940_196388# a_296732_200582# VDD3 sg13_lv_pmos ad=0.7695p pd=4.43u as=0.7695p ps=4.43u w=4.05u l=0.5u
X4467 user_project_wrapper_0.IOVSS1 user_project_wrapper_0.sg13g2_IOPadVdd_3.sg13g2_RCClampResistor_0.p2 user_project_wrapper_0.sg13g2_IOPadVdd_3.sg13g2_RCClampInverter_noptap_0.out user_project_wrapper_0.IOVSS1 sg13_hv_pmos ad=1.33p pd=7.38u as=1.33p ps=7.38u w=7u l=0.5u
X4468 user_project_wrapper_0.VDD1 user_project_wrapper_0.sg13g2_IOPadVdd_2.sg13g2_RCClampInverter_noptap_0.out user_project_wrapper_0.IOVSS1 user_project_wrapper_0.IOVSS1 sg13_hv_nmos ad=2.596p pd=5.58u as=1.408p ps=5.04u w=4.4u l=0.6u
X4469 VDD3 a_309516_194555# a_309516_194555# VDD3 sg13_lv_pmos ad=0.19p pd=1.38u as=0.19p ps=1.38u w=1u l=0.7u
X4470 a_296625_208423# a_304090_197941# a_304196_200821# user_project_wrapper_0.IOVSS1 sg13_lv_nmos ad=0.361p pd=2.28u as=0.646p ps=4.48u w=1.9u l=0.16u
X4471 user_project_wrapper_0.IOVSS1 user_project_wrapper_0.sg13g2_IOPadVdd_1.sg13g2_RCClampResistor_0.p2 user_project_wrapper_0.IOVSS1 user_project_wrapper_0.IOVSS1 sg13_hv_nmos ad=1.71p pd=9.38u as=0 ps=0 w=9u l=9.5u
X4472 analog_io[20] a_355624_176644# IOVDD3 IOVDD3 sg13_hv_pmos ad=3.9294p pd=7.84u as=2.1312p ps=7.3u w=6.66u l=0.6u
X4473 a_189184_329719# user_project_wrapper_0.IOVSS1 user_project_wrapper_0.IOVSS1 w_188700_330166# sg13_lv_pmos ad=0.38p pd=2.38u as=0.68p ps=4.68u w=2u l=0.13u
X4474 a_304995_198817# a_307232_196607# user_project_wrapper_0.IOVSS1 user_project_wrapper_0.IOVSS1 sg13_lv_nmos ad=0.6327p pd=3.71u as=0.6327p ps=3.71u w=3.33u l=0.2u
X4475 user_project_wrapper_0.IOVSS1 a_135844_29676# user_project_wrapper_0.analog_io[10] user_project_wrapper_0.IOVSS1 sg13_hv_nmos ad=1.408p pd=5.04u as=2.596p ps=5.58u w=4.4u l=0.6u
X4476 user_project_wrapper_0.analog_io[5] a_41476_217444# user_project_wrapper_0.IOVDD1 user_project_wrapper_0.IOVDD1 sg13_hv_pmos ad=3.9294p pd=7.84u as=2.1312p ps=7.3u w=6.66u l=0.6u
X4477 user_project_wrapper_0.IOVSS1 a_29676_115444# user_project_wrapper_0.analog_io[0] user_project_wrapper_0.IOVSS1 sg13_hv_nmos ad=1.408p pd=5.04u as=2.596p ps=5.58u w=4.4u l=0.6u
X4478 user_project_wrapper_0.IOVSS1 a_202114_326125# user_project_wrapper_0.analog_io[32] user_project_wrapper_0.IOVSS1 sg13_lv_pmos ad=1.824p pd=9.98u as=1.824p ps=9.98u w=9.6u l=0.13u
X4479 user_project_wrapper_0.IOVSS1 user_project_wrapper_0.sg13g2_IOPadVdd_0.sg13g2_RCClampResistor_0.p2 user_project_wrapper_0.IOVSS1 user_project_wrapper_0.IOVSS1 sg13_hv_nmos ad=1.71p pd=9.38u as=0 ps=0 w=9u l=9.5u
X4480 analog_io[20] a_311108_179669# VDD3 user_project_wrapper_0.IOVSS1 sg13_lv_nmos ad=3.4p pd=20.68u as=3.4p ps=20.68u w=10u l=0.15u
X4481 a_296731_208493# a_296625_208423# VDD3 VDD3 sg13_lv_pmos ad=0.2603p pd=1.75u as=0.2603p ps=1.75u w=1.37u l=0.35u
X4482 user_project_wrapper_0.IOVSS1 a_182931_326125# user_project_wrapper_0.analog_io[27] user_project_wrapper_0.IOVSS1 sg13_lv_pmos ad=1.824p pd=9.98u as=1.824p ps=9.98u w=9.6u l=0.13u
X4483 user_project_wrapper_0.IOVSS1 user_project_wrapper_0.IOVSS1 user_project_wrapper_0.IOVSS1 rppd l=0.5u w=0.5u
X4484 a_194687_324142# a_194279_327536# user_project_wrapper_0.IOVSS1 user_project_wrapper_0.IOVSS1 sg13_lv_nmos ad=0.912p pd=5.18u as=1.632p ps=10.28u w=4.8u l=0.13u
X4485 a_296731_189665# a_296625_189595# VDD3 VDD3 sg13_lv_pmos ad=0.2603p pd=1.75u as=0.2603p ps=1.75u w=1.37u l=0.35u
X4486 user_project_wrapper_0.IOVDD2 user_project_wrapper_0.sg13g2_IOPadIOVdd_0.sg13g2_Clamp_N43N43D4R_0.gate user_project_wrapper_0.IOVSS1 user_project_wrapper_0.IOVSS1 sg13_hv_nmos ad=2.596p pd=5.58u as=1.408p ps=5.04u w=4.4u l=0.6u
X4487 user_project_wrapper_0.analog_io[32] a_217444_355624# user_project_wrapper_0.IOVDD4 user_project_wrapper_0.IOVDD4 sg13_hv_pmos ad=3.9294p pd=7.84u as=2.1312p ps=7.3u w=6.66u l=0.6u
X4488 QDLL_TOP_0.VDD QDLL_TOP_0.VOUT a_187914_101343# QDLL_TOP_0.VDD sg13_lv_pmos ad=0.1523p pd=1.38u as=0.1428p ps=1.52u w=0.42u l=0.13u
X4489 a_360372_79645# a_364458_79975# user_project_wrapper_0.IOVSS1 rppd l=20u w=1u
X4490 user_project_wrapper_0.analog_io[35] a_213870_324142# user_project_wrapper_0.IOVSS1 user_project_wrapper_0.IOVSS1 sg13_lv_pmos ad=1.824p pd=9.98u as=1.824p ps=9.98u w=9.6u l=0.13u
X4491 user_project_wrapper_0.IOVSS1 a_182931_326125# user_project_wrapper_0.analog_io[27] user_project_wrapper_0.IOVSS1 sg13_lv_pmos ad=1.824p pd=9.98u as=1.824p ps=9.98u w=9.6u l=0.13u
X4492 user_project_wrapper_0.sg13g2_IOPadAnalog_25.padres IOVDD3 dpantenna l=4.98u w=0.64u
X4493 user_project_wrapper_0.IOVSS1 a_191234_327491# a_191438_327491# w_188704_327938# sg13_lv_pmos ad=0.38p pd=2.38u as=0.38p ps=2.38u w=2u l=0.13u
X4494 VDD3 a_309516_194555# a_309917_194695# VDD3 sg13_lv_pmos ad=0.19p pd=1.38u as=0.19p ps=1.38u w=1u l=0.7u
X4495 a_296625_189595# a_301940_196388# a_296732_197880# VDD3 sg13_lv_pmos ad=0.7695p pd=4.43u as=0.7695p ps=4.43u w=4.05u l=0.5u
X4496 a_191234_329719# a_190824_329719# user_project_wrapper_0.IOVSS1 user_project_wrapper_0.IOVSS1 sg13_lv_nmos ad=0.34p pd=2.68u as=0.34p ps=2.68u w=1u l=0.13u
X4497 user_project_wrapper_0.IOVDD4 user_project_wrapper_0.sg13g2_IOPadIOVdd_2.sg13g2_Clamp_N43N43D4R_0.gate user_project_wrapper_0.IOVSS1 user_project_wrapper_0.IOVSS1 sg13_hv_nmos ad=2.596p pd=5.58u as=2.068p ps=9.74u w=4.4u l=0.6u
X4498 user_project_wrapper_0.analog_io[29] a_156244_355624# user_project_wrapper_0.IOVDD4 user_project_wrapper_0.IOVDD4 sg13_hv_pmos ad=3.9294p pd=7.84u as=3.1302p ps=14.26u w=6.66u l=0.6u
X4499 user_project_wrapper_0.IOVDD1 a_41476_135844# user_project_wrapper_0.analog_io[1] user_project_wrapper_0.IOVDD1 sg13_hv_pmos ad=2.1312p pd=7.3u as=3.9294p ps=7.84u w=6.66u l=0.6u
X4500 a_296731_189665# a_301186_192011# user_project_wrapper_0.IOVSS1 user_project_wrapper_0.IOVSS1 sg13_lv_nmos ad=0.912p pd=5.18u as=0.912p ps=5.18u w=4.8u l=1.06u
X4501 user_project_wrapper_0.analog_io[4] a_41476_197044# user_project_wrapper_0.IOVDD1 user_project_wrapper_0.IOVDD1 sg13_hv_pmos ad=3.9294p pd=7.84u as=2.1312p ps=7.3u w=6.66u l=0.6u
X4502 analog_io[25] IOVDD3 dpantenna l=27.78u w=1.26u
X4503 user_project_wrapper_0.IOVDD2 user_project_wrapper_0.sg13g2_IOPadIOVdd_0.sg13g2_Clamp_N43N43D4R_0.gate user_project_wrapper_0.IOVSS1 user_project_wrapper_0.IOVSS1 sg13_hv_nmos ad=2.596p pd=5.58u as=1.408p ps=5.04u w=4.4u l=0.6u
X4504 user_project_wrapper_0.IOVSS1 a_156244_369296# user_project_wrapper_0.IOVSS1 rppd l=3.54u w=0.5u
X4505 a_296731_208493# a_296625_208423# VDD3 VDD3 sg13_lv_pmos ad=0.2603p pd=1.75u as=0.2603p ps=1.75u w=1.37u l=0.35u
X4506 user_project_wrapper_0.IOVSS1 user_project_wrapper_0.sg13g2_IOPadAnalog_17.padres a_189286_325263# user_project_wrapper_0.IOVSS1 sg13_lv_nmos ad=0.34p pd=2.68u as=0.19p ps=1.38u w=1u l=0.13u
X4507 VDD3 a_309516_194555# a_309917_199879# VDD3 sg13_lv_pmos ad=0.19p pd=1.38u as=0.19p ps=1.38u w=1u l=0.7u
X4508 user_project_wrapper_0.IOVSS1 user_project_wrapper_0.sg13g2_IOPadIOVdd_3.sg13g2_Clamp_N43N43D4R_0.gate IOVDD3 user_project_wrapper_0.IOVSS1 sg13_hv_nmos ad=1.408p pd=5.04u as=2.596p ps=5.58u w=4.4u l=0.6u
X4509 user_project_wrapper_0.IOVSS1 user_project_wrapper_0.sg13g2_IOPadIOVdd_3.sg13g2_Clamp_N43N43D4R_0.gate IOVDD3 user_project_wrapper_0.IOVSS1 sg13_hv_nmos ad=1.408p pd=5.04u as=2.596p ps=5.58u w=4.4u l=0.6u
X4510 a_35456_301735# a_39542_302065# user_project_wrapper_0.IOVSS1 rppd l=20u w=1u
X4511 user_project_wrapper_0.IOVSS1 user_project_wrapper_0.IOVSS1 user_project_wrapper_0.IOVSS1 rppd l=0.5u w=0.5u
X4512 user_project_wrapper_0.IOVSS1 a_202114_326125# user_project_wrapper_0.analog_io[32] user_project_wrapper_0.IOVSS1 sg13_lv_pmos ad=1.824p pd=9.98u as=1.824p ps=9.98u w=9.6u l=0.13u
X4513 analog_io[23] a_369296_217444# user_project_wrapper_0.IOVSS1 user_project_wrapper_0.IOVSS1 sg13_hv_nmos ad=2.596p pd=5.58u as=2.068p ps=9.74u w=4.4u l=0.6u
X4514 user_project_wrapper_0.analog_io[6] a_41476_237844# user_project_wrapper_0.IOVDD1 user_project_wrapper_0.IOVDD1 sg13_hv_pmos ad=3.9294p pd=7.84u as=2.1312p ps=7.3u w=6.66u l=0.6u
X4515 user_project_wrapper_0.IOVSS1 a_182931_326125# user_project_wrapper_0.analog_io[27] user_project_wrapper_0.IOVSS1 sg13_lv_nmos ad=0.912p pd=5.18u as=0.912p ps=5.18u w=4.8u l=0.13u
X4516 user_project_wrapper_0.analog_io[12] a_176644_29676# user_project_wrapper_0.IOVSS1 user_project_wrapper_0.IOVSS1 sg13_hv_nmos ad=2.596p pd=5.58u as=1.408p ps=5.04u w=4.4u l=0.6u
X4517 IOVDD3 a_355624_176644# analog_io[20] IOVDD3 sg13_hv_pmos ad=3.1302p pd=14.26u as=3.9294p ps=7.84u w=6.66u l=0.6u
X4518 VDD3 a_296625_208423# a_296731_208493# VDD3 sg13_lv_pmos ad=0.2603p pd=1.75u as=0.2603p ps=1.75u w=1.37u l=0.35u
X4519 user_project_wrapper_0.IOVSS1 a_202114_326125# user_project_wrapper_0.analog_io[32] user_project_wrapper_0.IOVSS1 sg13_lv_pmos ad=1.824p pd=9.98u as=1.824p ps=9.98u w=9.6u l=0.13u
X4520 user_project_wrapper_0.IOVDD2 a_156244_41476# user_project_wrapper_0.analog_io[11] user_project_wrapper_0.IOVDD2 sg13_hv_pmos ad=2.1312p pd=7.3u as=3.9294p ps=7.84u w=6.66u l=0.6u
X4521 user_project_wrapper_0.IOVDD1 user_project_wrapper_0.sg13g2_IOPadIOVdd_1.sg13g2_Clamp_N43N43D4R_0.gate user_project_wrapper_0.IOVSS1 user_project_wrapper_0.IOVSS1 sg13_hv_nmos ad=2.596p pd=5.58u as=1.408p ps=5.04u w=4.4u l=0.6u
X4522 a_81295_364458# user_project_wrapper_0.sg13g2_IOPadVdd_3.sg13g2_RCClampResistor_0.p2 user_project_wrapper_0.IOVSS1 rppd l=20u w=1u
X4523 user_project_wrapper_0.IOVSS1 user_project_wrapper_0.sg13g2_IOPadVdd_0.sg13g2_RCClampInverter_noptap_0.out VDD3 user_project_wrapper_0.IOVSS1 sg13_hv_nmos ad=1.408p pd=5.04u as=2.596p ps=5.58u w=4.4u l=0.6u
X4524 user_project_wrapper_0.analog_io[30] a_194687_324142# user_project_wrapper_0.IOVSS1 user_project_wrapper_0.IOVSS1 sg13_lv_nmos ad=0.912p pd=5.18u as=0.912p ps=5.18u w=4.8u l=0.13u
X4525 analog_io[20] analog_io[20] user_project_wrapper_0.IOVSS1 rppd l=2u w=1u
X4526 user_project_wrapper_0.IOVDD1 a_41476_217444# user_project_wrapper_0.analog_io[5] user_project_wrapper_0.IOVDD1 sg13_hv_pmos ad=2.1312p pd=7.3u as=3.9294p ps=7.84u w=6.66u l=0.6u
X4527 VDD3 a_309516_194555# a_309917_199879# VDD3 sg13_lv_pmos ad=0.19p pd=1.38u as=0.19p ps=1.38u w=1u l=0.7u
X4528 IOVDD3 a_355624_278644# analog_io[26] IOVDD3 sg13_hv_pmos ad=2.1312p pd=7.3u as=3.9294p ps=7.84u w=6.66u l=0.6u
X4529 user_project_wrapper_0.IOVSS1 user_project_wrapper_0.sg13g2_IOPadVdd_3.sg13g2_RCClampInverter_noptap_0.out user_project_wrapper_0.IOVSS1 user_project_wrapper_0.IOVSS1 sg13_hv_nmos ad=1.408p pd=5.04u as=0 ps=0 w=4.4u l=0.6u
X4530 user_project_wrapper_0.IOVSS1 a_192745_324776# a_189672_324776# w_188806_323975# sg13_lv_pmos ad=0.38p pd=2.38u as=0.38p ps=2.38u w=2u l=0.13u
X4531 a_202114_326125# a_205385_326221# user_project_wrapper_0.IOVSS1 user_project_wrapper_0.IOVSS1 sg13_lv_nmos ad=0.912p pd=5.18u as=0.912p ps=5.18u w=4.8u l=0.13u
X4532 user_project_wrapper_0.VDD1 user_project_wrapper_0.sg13g2_IOPadVdd_2.sg13g2_RCClampInverter_noptap_0.out user_project_wrapper_0.IOVSS1 user_project_wrapper_0.IOVSS1 sg13_hv_nmos ad=2.596p pd=5.58u as=1.408p ps=5.04u w=4.4u l=0.6u
X4533 analog_io[22] a_355624_197044# IOVDD3 IOVDD3 sg13_hv_pmos ad=3.9294p pd=7.84u as=3.1302p ps=14.26u w=6.66u l=0.6u
X4534 a_79025_136081# a_78824_135221# user_project_wrapper_0.VDD1 user_project_wrapper_0.VDD1 sg13_lv_pmos ad=1.7p pd=10.68u as=1.7p ps=10.68u w=5u l=0.15u
X4535 VDD3 a_296625_189595# a_296731_189665# VDD3 sg13_lv_pmos ad=0.2603p pd=1.75u as=0.2603p ps=1.75u w=1.37u l=0.35u
X4536 user_project_wrapper_0.IOVDD2 user_project_wrapper_0.sg13g2_IOPadIOVdd_0.sg13g2_Clamp_N43N43D4R_0.gate user_project_wrapper_0.IOVSS1 user_project_wrapper_0.IOVSS1 sg13_hv_nmos ad=2.596p pd=5.58u as=1.408p ps=5.04u w=4.4u l=0.6u
X4537 a_355624_197044# IOVDD3 IOVDD3 rppd l=12.9u w=0.5u
X4538 analog_io[23] a_355624_217444# IOVDD3 IOVDD3 sg13_hv_pmos ad=3.9294p pd=7.84u as=2.1312p ps=7.3u w=6.66u l=0.6u
X4539 VDD3 a_296625_208423# a_296731_208493# VDD3 sg13_lv_pmos ad=0.2603p pd=1.75u as=0.2603p ps=1.75u w=1.37u l=0.35u
X4540 VDD3 a_309516_194555# a_309917_199879# VDD3 sg13_lv_pmos ad=0.34p pd=2.68u as=0.19p ps=1.38u w=1u l=0.7u
X4541 analog_io[26] a_369296_278644# user_project_wrapper_0.IOVSS1 user_project_wrapper_0.IOVSS1 sg13_hv_nmos ad=2.596p pd=5.58u as=1.408p ps=5.04u w=4.4u l=0.6u
X4542 user_project_wrapper_0.IOVSS1 user_project_wrapper_0.sg13g2_IOPadIOVdd_1.sg13g2_Clamp_N43N43D4R_0.gate user_project_wrapper_0.IOVDD1 user_project_wrapper_0.IOVSS1 sg13_hv_nmos ad=1.408p pd=5.04u as=2.596p ps=5.58u w=4.4u l=0.6u
X4543 VDD3 a_296625_208423# a_296731_208493# VDD3 sg13_lv_pmos ad=0.2603p pd=1.75u as=0.2603p ps=1.75u w=1.37u l=0.35u
X4544 a_304196_200821# a_304889_199957# a_304995_198817# user_project_wrapper_0.IOVSS1 sg13_lv_nmos ad=0.209p pd=1.48u as=0.209p ps=1.48u w=1.1u l=0.15u
X4545 a_91090_127530# a_90579_127530# user_project_wrapper_0.IOVSS1 user_project_wrapper_0.IOVSS1 sg13_lv_nmos ad=0.1406p pd=1.12u as=0.2516p ps=2.16u w=0.74u l=0.13u
X4546 a_57810_180219# a_58798_179951# user_project_wrapper_0.IOVSS1 user_project_wrapper_0.IOVSS1 sg13_hv_nmos ad=0.646p pd=4.48u as=0.361p ps=2.28u w=1.9u l=0.45u
X4547 user_project_wrapper_0.IOVSS1 a_278644_369296# user_project_wrapper_0.analog_io[35] user_project_wrapper_0.IOVSS1 sg13_hv_nmos ad=1.408p pd=5.04u as=2.596p ps=5.58u w=4.4u l=0.6u
X4548 user_project_wrapper_0.IOVSS1 a_115444_369296# user_project_wrapper_0.analog_io[27] user_project_wrapper_0.IOVSS1 sg13_hv_nmos ad=1.408p pd=5.04u as=2.596p ps=5.58u w=4.4u l=0.6u
X4549 user_project_wrapper_0.IOVSS1 a_182931_326125# user_project_wrapper_0.analog_io[27] user_project_wrapper_0.IOVSS1 sg13_lv_nmos ad=0.912p pd=5.18u as=0.912p ps=5.18u w=4.8u l=0.13u
X4550 analog_io[20] a_355624_176644# IOVDD3 IOVDD3 sg13_hv_pmos ad=3.9294p pd=7.84u as=2.1312p ps=7.3u w=6.66u l=0.6u
X4551 user_project_wrapper_0.IOVSS1 a_369296_217444# analog_io[23] user_project_wrapper_0.IOVSS1 sg13_hv_nmos ad=1.408p pd=5.04u as=2.596p ps=5.58u w=4.4u l=0.6u
X4552 user_project_wrapper_0.sg13g2_IOPadIOVdd_1.sg13g2_Clamp_N43N43D4R_0.gate user_project_wrapper_0.sg13g2_IOPadIOVdd_1.sg13g2_RCClampResistor_0.p2 user_project_wrapper_0.IOVSS1 user_project_wrapper_0.IOVSS1 sg13_hv_nmos ad=1.71p pd=9.38u as=3.06p ps=18.68u w=9u l=0.5u
X4553 user_project_wrapper_0.IOVSS1 a_210417_327491# a_210621_327491# w_207887_327938# sg13_lv_pmos ad=0.38p pd=2.38u as=0.38p ps=2.38u w=2u l=0.13u
X4554 IOVDD3 a_355624_135844# analog_io[19] IOVDD3 sg13_hv_pmos ad=2.1312p pd=7.3u as=3.9294p ps=7.84u w=6.66u l=0.6u
X4555 a_86407_241748# a_85989_241383# user_project_wrapper_0.VDD1 user_project_wrapper_0.VDD1 sg13_lv_pmos ad=0.2128p pd=1.5u as=0.3808p ps=2.92u w=1.12u l=0.13u
X4556 a_210621_325263# TOP_ROILIFNEURON_0.MEM user_project_wrapper_0.IOVSS1 rppd l=0.5u w=0.5u
X4557 user_project_wrapper_0.IOVSS1 user_project_wrapper_0.IOVSS1 user_project_wrapper_0.IOVSS1 rppd l=0.5u w=0.5u
X4558 analog_io[19] a_369296_135844# user_project_wrapper_0.IOVSS1 user_project_wrapper_0.IOVSS1 sg13_hv_nmos ad=2.596p pd=5.58u as=1.408p ps=5.04u w=4.4u l=0.6u
X4559 a_360372_80965# a_364458_81295# user_project_wrapper_0.IOVSS1 rppd l=20u w=1u
X4560 user_project_wrapper_0.IOVSS1 user_project_wrapper_0.sg13g2_IOPadVdd_1.sg13g2_RCClampResistor_0.p2 user_project_wrapper_0.IOVSS1 user_project_wrapper_0.IOVSS1 sg13_hv_nmos ad=1.71p pd=9.38u as=0 ps=0 w=9u l=9.5u
X4561 user_project_wrapper_0.analog_io[12] a_176644_29676# user_project_wrapper_0.IOVSS1 user_project_wrapper_0.IOVSS1 sg13_hv_nmos ad=2.596p pd=5.58u as=1.408p ps=5.04u w=4.4u l=0.6u
X4562 analog_io[19] a_355624_135844# IOVDD3 IOVDD3 sg13_hv_pmos ad=3.9294p pd=7.84u as=2.1312p ps=7.3u w=6.66u l=0.6u
X4563 user_project_wrapper_0.IOVDD1 user_project_wrapper_0.sg13g2_IOPadIOVdd_1.sg13g2_Clamp_N43N43D4R_0.gate user_project_wrapper_0.IOVSS1 user_project_wrapper_0.IOVSS1 sg13_hv_nmos ad=2.596p pd=5.58u as=1.408p ps=5.04u w=4.4u l=0.6u
X4564 user_project_wrapper_0.IOVDD4 user_project_wrapper_0.sg13g2_IOPadIOVdd_2.sg13g2_Clamp_N43N43D4R_0.gate user_project_wrapper_0.IOVSS1 user_project_wrapper_0.IOVSS1 sg13_hv_nmos ad=2.596p pd=5.58u as=1.408p ps=5.04u w=4.4u l=0.6u
X4565 user_project_wrapper_0.IOVDD4 a_237844_355624# user_project_wrapper_0.analog_io[33] user_project_wrapper_0.IOVDD4 sg13_hv_pmos ad=3.1302p pd=14.26u as=3.9294p ps=7.84u w=6.66u l=0.6u
X4566 VDD3 user_project_wrapper_0.sg13g2_IOPadVdd_0.sg13g2_RCClampInverter_noptap_0.out user_project_wrapper_0.IOVSS1 user_project_wrapper_0.IOVSS1 sg13_hv_nmos ad=2.596p pd=5.58u as=1.408p ps=5.04u w=4.4u l=0.6u
X4567 user_project_wrapper_0.IOVSS1 user_project_wrapper_0.sg13g2_IOPadVdd_1.sg13g2_RCClampInverter_noptap_0.out user_project_wrapper_0.VDD2 user_project_wrapper_0.IOVSS1 sg13_hv_nmos ad=1.408p pd=5.04u as=2.596p ps=5.58u w=4.4u l=0.6u
X4568 a_85287_241383# a_82846_243261# user_project_wrapper_0.VDD1 user_project_wrapper_0.VDD1 sg13_lv_pmos ad=0.3808p pd=2.92u as=0.3808p ps=2.92u w=1.12u l=0.13u
X4569 user_project_wrapper_0.VDD2 user_project_wrapper_0.sg13g2_IOPadVdd_1.sg13g2_RCClampInverter_noptap_0.out user_project_wrapper_0.IOVSS1 user_project_wrapper_0.IOVSS1 sg13_hv_nmos ad=2.596p pd=5.58u as=1.408p ps=5.04u w=4.4u l=0.6u
X4570 a_209480_326377# a_208939_326377# user_project_wrapper_0.IOVSS1 w_207887_326203# sg13_lv_pmos ad=0.68p pd=4.68u as=0.68p ps=4.68u w=2u l=0.13u
X4571 user_project_wrapper_0.VDD1 user_project_wrapper_0.sg13g2_IOPadVdd_2.sg13g2_RCClampInverter_noptap_0.out user_project_wrapper_0.IOVSS1 user_project_wrapper_0.IOVSS1 sg13_hv_nmos ad=2.596p pd=5.58u as=1.408p ps=5.04u w=4.4u l=0.6u
X4572 user_project_wrapper_0.IOVSS1 a_208579_324119# a_208171_324119# w_207989_323975# sg13_lv_pmos ad=0.68p pd=4.68u as=0.68p ps=4.68u w=2u l=0.13u
X4573 user_project_wrapper_0.IOVSS1 user_project_wrapper_0.IOVSS1 user_project_wrapper_0.IOVSS1 rhigh l=0.96u w=0.5u
X4574 user_project_wrapper_0.analog_io[10] a_135844_29676# user_project_wrapper_0.IOVSS1 user_project_wrapper_0.IOVSS1 sg13_hv_nmos ad=2.596p pd=5.58u as=2.068p ps=9.74u w=4.4u l=0.6u
X4575 VDD3 a_309516_194555# a_309917_199879# VDD3 sg13_lv_pmos ad=0.19p pd=1.38u as=0.19p ps=1.38u w=1u l=0.7u
X4576 user_project_wrapper_0.analog_io[28] a_135844_355624# user_project_wrapper_0.IOVDD4 user_project_wrapper_0.IOVDD4 sg13_hv_pmos ad=3.9294p pd=7.84u as=2.1312p ps=7.3u w=6.66u l=0.6u
X4577 a_304196_197873# a_304889_198885# a_304995_198817# user_project_wrapper_0.IOVSS1 sg13_lv_nmos ad=0.209p pd=1.48u as=0.209p ps=1.48u w=1.1u l=0.15u
X4578 user_project_wrapper_0.IOVDD4 user_project_wrapper_0.sg13g2_IOPadIOVdd_2.sg13g2_Clamp_N43N43D4R_0.gate user_project_wrapper_0.IOVSS1 user_project_wrapper_0.IOVSS1 sg13_hv_nmos ad=2.596p pd=5.58u as=1.408p ps=5.04u w=4.4u l=0.6u
X4579 user_project_wrapper_0.IOVSS1 a_202114_326125# user_project_wrapper_0.analog_io[32] user_project_wrapper_0.IOVSS1 sg13_lv_nmos ad=0.912p pd=5.18u as=0.912p ps=5.18u w=4.8u l=0.13u
X4580 a_309917_194695# a_309516_194555# VDD3 VDD3 sg13_lv_pmos ad=0.19p pd=1.38u as=0.19p ps=1.38u w=1u l=0.7u
X4581 user_project_wrapper_0.sg13g2_IOPadIOVdd_1.sg13g2_Clamp_N43N43D4R_0.gate user_project_wrapper_0.sg13g2_IOPadIOVdd_1.sg13g2_RCClampResistor_0.p2 user_project_wrapper_0.IOVSS1 user_project_wrapper_0.IOVSS1 sg13_hv_nmos ad=1.71p pd=9.38u as=3.06p ps=18.68u w=9u l=0.5u
X4582 user_project_wrapper_0.IOVDD4 a_278644_355624# user_project_wrapper_0.analog_io[35] user_project_wrapper_0.IOVDD4 sg13_hv_pmos ad=2.1312p pd=7.3u as=3.9294p ps=7.84u w=6.66u l=0.6u
X4583 user_project_wrapper_0.IOVSS1 user_project_wrapper_0.sg13g2_IOPadVdd_1.sg13g2_RCClampInverter_noptap_0.out user_project_wrapper_0.VDD2 user_project_wrapper_0.IOVSS1 sg13_hv_nmos ad=1.408p pd=5.04u as=2.596p ps=5.58u w=4.4u l=0.6u
X4584 user_project_wrapper_0.IOVSS1 a_237844_29676# user_project_wrapper_0.analog_io[15] user_project_wrapper_0.IOVSS1 sg13_hv_nmos ad=1.408p pd=5.04u as=2.596p ps=5.58u w=4.4u l=0.6u
X4585 IOVDD3 a_355624_217444# analog_io[23] IOVDD3 sg13_hv_pmos ad=3.1302p pd=14.26u as=3.9294p ps=7.84u w=6.66u l=0.6u
X4586 a_309516_194555# a_309516_194555# VDD3 VDD3 sg13_lv_pmos ad=0.19p pd=1.38u as=0.19p ps=1.38u w=1u l=0.7u
X4587 a_210417_325263# a_210007_325263# user_project_wrapper_0.IOVSS1 w_207887_326203# sg13_lv_pmos ad=0.68p pd=4.68u as=0.68p ps=4.68u w=2u l=0.13u
X4588 user_project_wrapper_0.ui_PAD[9] user_project_wrapper_0.IOVDD1 dpantenna l=27.78u w=1.26u
X4589 user_project_wrapper_0.analog_io[13] a_197044_41476# user_project_wrapper_0.IOVDD2 user_project_wrapper_0.IOVDD2 sg13_hv_pmos ad=3.9294p pd=7.84u as=3.1302p ps=14.26u w=6.66u l=0.6u
X4590 user_project_wrapper_0.IOVSS1 user_project_wrapper_0.sg13g2_IOPadVdd_0.sg13g2_RCClampInverter_noptap_0.out VDD3 user_project_wrapper_0.IOVSS1 sg13_hv_nmos ad=1.408p pd=5.04u as=2.596p ps=5.58u w=4.4u l=0.6u
X4591 user_project_wrapper_0.IOVSS1 a_186202_326221# a_182931_326125# user_project_wrapper_0.IOVSS1 sg13_lv_nmos ad=0.912p pd=5.18u as=0.912p ps=5.18u w=4.8u l=0.13u
X4592 user_project_wrapper_0.sg13g2_IOPadIOVdd_0.sg13g2_Clamp_N43N43D4R_0.gate user_project_wrapper_0.sg13g2_IOPadIOVdd_0.sg13g2_RCClampResistor_0.p2 user_project_wrapper_0.IOVSS1 user_project_wrapper_0.IOVSS1 sg13_hv_nmos ad=1.71p pd=9.38u as=1.71p ps=9.38u w=9u l=0.5u
X4593 user_project_wrapper_0.IOVSS1 user_project_wrapper_0.sg13g2_IOPadIOVdd_2.sg13g2_Clamp_N43N43D4R_0.gate user_project_wrapper_0.IOVDD4 user_project_wrapper_0.IOVSS1 sg13_hv_nmos ad=1.408p pd=5.04u as=2.596p ps=5.58u w=4.4u l=0.6u
X4594 user_project_wrapper_0.IOVDD4 a_217444_355624# user_project_wrapper_0.analog_io[32] user_project_wrapper_0.IOVDD4 sg13_hv_pmos ad=2.1312p pd=7.3u as=3.9294p ps=7.84u w=6.66u l=0.6u
X4595 user_project_wrapper_0.IOVSS1 user_project_wrapper_0.sg13g2_IOPadIOVdd_3.sg13g2_Clamp_N43N43D4R_0.gate IOVDD3 user_project_wrapper_0.IOVSS1 sg13_hv_nmos ad=1.408p pd=5.04u as=2.596p ps=5.58u w=4.4u l=0.6u
X4596 user_project_wrapper_0.IOVSS1 user_project_wrapper_0.sg13g2_IOPadIOVdd_3.sg13g2_Clamp_N43N43D4R_0.gate IOVDD3 user_project_wrapper_0.IOVSS1 sg13_hv_nmos ad=1.408p pd=5.04u as=2.596p ps=5.58u w=4.4u l=0.6u
X4597 user_project_wrapper_0.IOVSS1 user_project_wrapper_0.sg13g2_IOPadIOVdd_0.sg13g2_Clamp_N43N43D4R_0.gate user_project_wrapper_0.IOVDD2 user_project_wrapper_0.IOVSS1 sg13_hv_nmos ad=1.408p pd=5.04u as=2.596p ps=5.58u w=4.4u l=0.6u
X4598 a_311846_195517# user_project_wrapper_0.sg13g2_IOPadAnalog_29.padres a_309917_194695# VDD3 sg13_lv_pmos ad=0.24415p pd=1.665u as=0.24415p ps=1.665u w=1.285u l=0.35u
X4599 user_project_wrapper_0.IOVDD2 a_156244_41476# user_project_wrapper_0.analog_io[11] user_project_wrapper_0.IOVDD2 sg13_hv_pmos ad=2.1312p pd=7.3u as=3.9294p ps=7.84u w=6.66u l=0.6u
X4600 analog_io[23] a_355624_237844# IOVDD3 IOVDD3 sg13_hv_pmos ad=3.9294p pd=7.84u as=2.1312p ps=7.3u w=6.66u l=0.6u
X4601 user_project_wrapper_0.IOVSS1 user_project_wrapper_0.sg13g2_IOPadIOVdd_0.sg13g2_Clamp_N43N43D4R_0.gate user_project_wrapper_0.IOVDD2 user_project_wrapper_0.IOVSS1 sg13_hv_nmos ad=1.408p pd=5.04u as=2.596p ps=5.58u w=4.4u l=0.6u
X4602 a_296731_189665# a_296625_189595# VDD3 VDD3 sg13_lv_pmos ad=0.2603p pd=1.75u as=0.4658p ps=3.42u w=1.37u l=0.35u
X4603 a_311846_195517# user_project_wrapper_0.sg13g2_IOPadAnalog_29.padres a_309917_194695# VDD3 sg13_lv_pmos ad=0.24415p pd=1.665u as=0.24415p ps=1.665u w=1.285u l=0.35u
X4604 user_project_wrapper_0.IOVDD2 user_project_wrapper_0.sg13g2_IOPadIOVdd_0.sg13g2_RCClampResistor_0.p2 user_project_wrapper_0.sg13g2_IOPadIOVdd_0.sg13g2_Clamp_N43N43D4R_0.gate user_project_wrapper_0.IOVDD2 sg13_hv_pmos ad=1.33p pd=7.38u as=1.33p ps=7.38u w=7u l=0.5u
X4605 IOVDD3 user_project_wrapper_0.sg13g2_IOPadIOVdd_3.sg13g2_Clamp_N43N43D4R_0.gate user_project_wrapper_0.IOVSS1 user_project_wrapper_0.IOVSS1 sg13_hv_nmos ad=2.596p pd=5.58u as=1.408p ps=5.04u w=4.4u l=0.6u
X4606 user_project_wrapper_0.IOVSS1 a_369296_135844# analog_io[19] user_project_wrapper_0.IOVSS1 sg13_hv_nmos ad=1.408p pd=5.04u as=2.596p ps=5.58u w=4.4u l=0.6u
X4607 user_project_wrapper_0.IOVSS1 a_197044_29676# user_project_wrapper_0.analog_io[13] user_project_wrapper_0.IOVSS1 sg13_hv_nmos ad=1.408p pd=5.04u as=2.596p ps=5.58u w=4.4u l=0.6u
X4608 user_project_wrapper_0.IOVSS1 user_project_wrapper_0.IOVDD2 dpantenna l=27.78u w=1.26u
X4609 user_project_wrapper_0.IOVSS1 a_182931_326125# user_project_wrapper_0.analog_io[27] user_project_wrapper_0.IOVSS1 sg13_lv_pmos ad=1.824p pd=9.98u as=1.824p ps=9.98u w=9.6u l=0.13u
X4610 a_57810_180219# a_58170_179951# user_project_wrapper_0.IOVDD1 user_project_wrapper_0.IOVDD1 sg13_hv_pmos ad=0.102p pd=1.28u as=57f ps=0.68u w=0.3u l=0.45u
X4611 a_269799_100118# a_269543_100118# user_project_wrapper_0.IOVSS1 user_project_wrapper_0.IOVSS1 sg13_lv_nmos ad=0.1428p pd=1.52u as=0.1323p ps=1.05u w=0.42u l=0.18u
X4612 VDD3 a_311108_215937# analog_io[23] user_project_wrapper_0.IOVSS1 sg13_lv_nmos ad=3.4p pd=20.68u as=3.4p ps=20.68u w=10u l=0.15u
X4613 a_300415_364458# a_300745_360372# user_project_wrapper_0.IOVSS1 rppd l=20u w=1u
X4614 user_project_wrapper_0.IOVSS1 user_project_wrapper_0.sg13g2_IOPadVdd_1.sg13g2_RCClampInverter_noptap_0.out user_project_wrapper_0.VDD2 user_project_wrapper_0.IOVSS1 sg13_hv_nmos ad=1.408p pd=5.04u as=2.596p ps=5.58u w=4.4u l=0.6u
X4615 a_304995_198817# a_304889_199957# a_304196_200821# user_project_wrapper_0.IOVSS1 sg13_lv_nmos ad=0.209p pd=1.48u as=0.209p ps=1.48u w=1.1u l=0.15u
X4616 a_190926_330241# a_189184_329719# a_190824_329719# w_188700_330166# sg13_lv_pmos ad=0.38p pd=2.38u as=0.38p ps=2.38u w=2u l=0.13u
X4617 user_project_wrapper_0.sg13g2_IOPadVdd_0.sg13g2_RCClampInverter_noptap_0.out user_project_wrapper_0.sg13g2_IOPadVdd_0.sg13g2_RCClampResistor_0.p2 VDD3 VDD3 sg13_hv_pmos ad=1.33p pd=7.38u as=1.33p ps=7.38u w=7u l=0.5u
X4618 user_project_wrapper_0.analog_io[35] a_213870_324142# user_project_wrapper_0.IOVSS1 user_project_wrapper_0.IOVSS1 sg13_lv_pmos ad=1.824p pd=9.98u as=1.824p ps=9.98u w=9.6u l=0.13u
X4619 user_project_wrapper_0.IOVSS1 a_182931_326125# user_project_wrapper_0.analog_io[27] user_project_wrapper_0.IOVSS1 sg13_lv_pmos ad=1.824p pd=9.98u as=1.824p ps=9.98u w=9.6u l=0.13u
X4620 a_296731_189665# a_296625_189595# VDD3 VDD3 sg13_lv_pmos ad=0.2603p pd=1.75u as=0.4658p ps=3.42u w=1.37u l=0.35u
X4621 VDD3 a_309516_194555# a_309917_194695# VDD3 sg13_lv_pmos ad=0.19p pd=1.38u as=0.19p ps=1.38u w=1u l=0.7u
X4622 a_309917_194695# a_296731_189665# a_307232_196607# VDD3 sg13_lv_pmos ad=0.24415p pd=1.665u as=0.24415p ps=1.665u w=1.285u l=0.35u
X4623 QDLL_TOP_0.VDD a_190389_101343# user_project_wrapper_0.analog_io[15] QDLL_TOP_0.VDD sg13_lv_pmos ad=0.3808p pd=2.92u as=0.2128p ps=1.5u w=1.12u l=0.13u
X4624 a_296625_208423# a_301940_196388# a_296732_200582# VDD3 sg13_lv_pmos ad=0.7695p pd=4.43u as=0.7695p ps=4.43u w=4.05u l=0.5u
X4625 IOVDD3 a_355624_258244# analog_io[25] IOVDD3 sg13_hv_pmos ad=2.1312p pd=7.3u as=3.9294p ps=7.84u w=6.66u l=0.6u
X4626 a_190868_330987# a_191754_330987# user_project_wrapper_0.IOVSS1 rhigh l=4u w=0.5u
X4627 user_project_wrapper_0.IOVSS1 user_project_wrapper_0.sg13g2_IOPadIOVdd_3.sg13g2_Clamp_N43N43D4R_0.gate IOVDD3 user_project_wrapper_0.IOVSS1 sg13_hv_nmos ad=1.408p pd=5.04u as=2.596p ps=5.58u w=4.4u l=0.6u
X4628 a_87775_125210# a_86507_127725# a_87673_125210# user_project_wrapper_0.IOVSS1 sg13_lv_nmos ad=0.1406p pd=1.12u as=0.1406p ps=1.12u w=0.74u l=0.13u
X4629 user_project_wrapper_0.IOVSS1 user_project_wrapper_0.sg13g2_IOPadIOVdd_0.sg13g2_Clamp_N43N43D4R_0.gate user_project_wrapper_0.IOVDD2 user_project_wrapper_0.IOVSS1 sg13_hv_nmos ad=1.408p pd=5.04u as=2.596p ps=5.58u w=4.4u l=0.6u
X4630 user_project_wrapper_0.VDD1 user_project_wrapper_0.sg13g2_IOPadVdd_2.sg13g2_RCClampInverter_noptap_0.out user_project_wrapper_0.IOVSS1 user_project_wrapper_0.IOVSS1 sg13_hv_nmos ad=2.596p pd=5.58u as=1.408p ps=5.04u w=4.4u l=0.6u
X4631 user_project_wrapper_0.IOVSS1 user_project_wrapper_0.sg13g2_IOPadIOVdd_0.sg13g2_Clamp_N43N43D4R_0.gate user_project_wrapper_0.IOVDD2 user_project_wrapper_0.IOVSS1 sg13_hv_nmos ad=1.408p pd=5.04u as=2.596p ps=5.58u w=4.4u l=0.6u
X4632 a_313884_211353# a_314793_198352# user_project_wrapper_0.IOVSS1 user_project_wrapper_0.IOVSS1 sg13_lv_nmos ad=0.57p pd=3.38u as=1.02p ps=6.68u w=3u l=1u
X4633 user_project_wrapper_0.IOVSS1 a_202114_326125# user_project_wrapper_0.analog_io[32] user_project_wrapper_0.IOVSS1 sg13_lv_pmos ad=1.824p pd=9.98u as=1.824p ps=9.98u w=9.6u l=0.13u
X4634 a_311189_185546# a_296731_189665# a_313884_185173# user_project_wrapper_0.IOVSS1 sg13_lv_nmos ad=1.9p pd=10.38u as=1.9p ps=10.38u w=10u l=0.5u
X4635 user_project_wrapper_0.IOVSS1 a_311846_195517# a_311846_195517# user_project_wrapper_0.IOVSS1 sg13_lv_nmos ad=0.6327p pd=3.71u as=0.6327p ps=3.71u w=3.33u l=0.2u
X4636 IOVDD3 a_355624_237844# analog_io[23] IOVDD3 sg13_hv_pmos ad=2.1312p pd=7.3u as=3.9294p ps=7.84u w=6.66u l=0.6u
X4637 user_project_wrapper_0.sg13g2_IOPadOut4mA$1_1.sg13g2_GateLevelUpInv_noptap$1$1_0.ngate a_57810_281517# user_project_wrapper_0.IOVDD1 user_project_wrapper_0.IOVDD1 sg13_hv_pmos ad=1.326p pd=8.48u as=1.326p ps=8.48u w=3.9u l=0.45u
X4638 a_210109_329719# a_209684_329719# a_210007_329719# user_project_wrapper_0.IOVSS1 sg13_lv_nmos ad=0.19p pd=1.38u as=0.19p ps=1.38u w=1u l=0.13u
X4639 user_project_wrapper_0.analog_io[35] a_213870_324142# user_project_wrapper_0.IOVSS1 user_project_wrapper_0.IOVSS1 sg13_lv_pmos ad=1.824p pd=9.98u as=1.824p ps=9.98u w=9.6u l=0.13u
X4640 user_project_wrapper_0.IOVSS1 user_project_wrapper_0.sg13g2_IOPadVdd_0.sg13g2_RCClampResistor_0.p2 user_project_wrapper_0.sg13g2_IOPadVdd_0.sg13g2_RCClampInverter_noptap_0.out user_project_wrapper_0.IOVSS1 sg13_hv_nmos ad=1.71p pd=9.38u as=1.71p ps=9.38u w=9u l=0.5u
X4641 user_project_wrapper_0.IOVSS1 a_202114_326125# user_project_wrapper_0.analog_io[32] user_project_wrapper_0.IOVSS1 sg13_lv_pmos ad=1.824p pd=9.98u as=1.824p ps=9.98u w=9.6u l=0.13u
X4642 user_project_wrapper_0.IOVSS1 a_182931_326125# user_project_wrapper_0.analog_io[27] user_project_wrapper_0.IOVSS1 sg13_lv_pmos ad=1.824p pd=9.98u as=1.824p ps=9.98u w=9.6u l=0.13u
X4643 user_project_wrapper_0.analog_io[30] a_194687_324142# user_project_wrapper_0.IOVSS1 user_project_wrapper_0.IOVSS1 sg13_lv_nmos ad=0.912p pd=5.18u as=0.912p ps=5.18u w=4.8u l=0.13u
X4644 user_project_wrapper_0.IOVSS1 user_project_wrapper_0.analog_io[13] a_185968_98275# user_project_wrapper_0.IOVSS1 sg13_lv_nmos ad=0.68p pd=4.68u as=0.68p ps=4.68u w=2u l=0.25u
X4645 VDD3 a_296625_189595# a_296731_189665# VDD3 sg13_lv_pmos ad=0.2603p pd=1.75u as=0.2603p ps=1.75u w=1.37u l=0.35u
X4646 VDD3 a_296626_197740# a_296732_200582# VDD3 sg13_lv_pmos ad=2.38p pd=14.68u as=1.33p ps=7.38u w=7u l=0.7u
X4647 user_project_wrapper_0.analog_io[10] a_135844_41476# user_project_wrapper_0.IOVDD2 user_project_wrapper_0.IOVDD2 sg13_hv_pmos ad=3.9294p pd=7.84u as=2.1312p ps=7.3u w=6.66u l=0.6u
X4648 a_89114_127896# a_87434_127896# a_89114_127531# user_project_wrapper_0.IOVSS1 sg13_lv_nmos ad=0.2516p pd=2.16u as=0.1406p ps=1.12u w=0.74u l=0.13u
X4649 user_project_wrapper_0.VDD1 user_project_wrapper_0.sg13g2_IOPadVdd_2.sg13g2_RCClampResistor_0.p2 user_project_wrapper_0.sg13g2_IOPadVdd_2.sg13g2_RCClampInverter_noptap_0.out user_project_wrapper_0.VDD1 sg13_hv_pmos ad=1.33p pd=7.38u as=1.33p ps=7.38u w=7u l=0.5u
X4650 user_project_wrapper_0.IOVSS1 a_186202_326221# a_182931_326125# user_project_wrapper_0.IOVSS1 sg13_lv_pmos ad=3.264p pd=19.88u as=1.824p ps=9.98u w=9.6u l=0.13u
X4651 user_project_wrapper_0.IOVSS1 user_project_wrapper_0.sg13g2_IOPadVdd_3.sg13g2_RCClampInverter_noptap_0.out user_project_wrapper_0.IOVSS1 user_project_wrapper_0.IOVSS1 sg13_hv_nmos ad=1.408p pd=5.04u as=0 ps=0 w=4.4u l=0.6u
X4652 user_project_wrapper_0.IOVSS1 a_156244_29676# user_project_wrapper_0.analog_io[11] user_project_wrapper_0.IOVSS1 sg13_hv_nmos ad=1.408p pd=5.04u as=2.596p ps=5.58u w=4.4u l=0.6u
X4653 user_project_wrapper_0.VDD2 user_project_wrapper_0.sg13g2_IOPadVdd_1.sg13g2_RCClampInverter_noptap_0.out user_project_wrapper_0.IOVSS1 user_project_wrapper_0.IOVSS1 sg13_hv_nmos ad=2.596p pd=5.58u as=1.408p ps=5.04u w=4.4u l=0.6u
X4654 VDD3 a_296625_208423# a_296731_208493# VDD3 sg13_lv_pmos ad=0.4658p pd=3.42u as=0.2603p ps=1.75u w=1.37u l=0.35u
X4655 user_project_wrapper_0.analog_io[13] user_project_wrapper_0.analog_io[12] user_project_wrapper_0.IOVSS1 rppd l=2u w=1u
X4656 user_project_wrapper_0.IOVDD2 a_156244_41476# user_project_wrapper_0.analog_io[11] user_project_wrapper_0.IOVDD2 sg13_hv_pmos ad=2.1312p pd=7.3u as=3.9294p ps=7.84u w=6.66u l=0.6u
X4657 analog_io[18] a_355624_115444# IOVDD3 IOVDD3 sg13_hv_pmos ad=3.9294p pd=7.84u as=2.1312p ps=7.3u w=6.66u l=0.6u
X4658 a_309917_199879# a_309516_194555# VDD3 VDD3 sg13_lv_pmos ad=0.19p pd=1.38u as=0.19p ps=1.38u w=1u l=0.7u
X4659 user_project_wrapper_0.analog_io[32] a_217444_355624# user_project_wrapper_0.IOVDD4 user_project_wrapper_0.IOVDD4 sg13_hv_pmos ad=3.9294p pd=7.84u as=2.1312p ps=7.3u w=6.66u l=0.6u
X4660 VDD3 a_296625_208423# a_296731_208493# VDD3 sg13_lv_pmos ad=0.2603p pd=1.75u as=0.2603p ps=1.75u w=1.37u l=0.35u
X4661 VDD3 user_project_wrapper_0.sg13g2_IOPadVdd_0.sg13g2_RCClampInverter_noptap_0.out user_project_wrapper_0.IOVSS1 user_project_wrapper_0.IOVSS1 sg13_hv_nmos ad=2.596p pd=5.58u as=1.408p ps=5.04u w=4.4u l=0.6u
X4662 user_project_wrapper_0.IOVSS1 a_202114_326125# user_project_wrapper_0.analog_io[32] user_project_wrapper_0.IOVSS1 sg13_lv_pmos ad=1.824p pd=9.98u as=1.824p ps=9.98u w=9.6u l=0.13u
X4663 user_project_wrapper_0.IOVDD1 user_project_wrapper_0.sg13g2_IOPadIOVdd_1.sg13g2_Clamp_N43N43D4R_0.gate user_project_wrapper_0.IOVSS1 user_project_wrapper_0.IOVSS1 sg13_hv_nmos ad=2.596p pd=5.58u as=1.408p ps=5.04u w=4.4u l=0.6u
X4664 user_project_wrapper_0.IOVDD4 a_135844_355624# user_project_wrapper_0.analog_io[28] user_project_wrapper_0.IOVDD4 sg13_hv_pmos ad=2.1312p pd=7.3u as=3.9294p ps=7.84u w=6.66u l=0.6u
X4665 analog_io[23] a_355624_237844# IOVDD3 IOVDD3 sg13_hv_pmos ad=3.9294p pd=7.84u as=2.1312p ps=7.3u w=6.66u l=0.6u
X4666 IOVDD3 a_355624_176644# analog_io[20] IOVDD3 sg13_hv_pmos ad=2.1312p pd=7.3u as=3.9294p ps=7.84u w=6.66u l=0.6u
X4667 user_project_wrapper_0.sg13g2_IOPadIOVdd_0.sg13g2_Clamp_N43N43D4R_0.gate user_project_wrapper_0.sg13g2_IOPadIOVdd_0.sg13g2_RCClampResistor_0.p2 user_project_wrapper_0.IOVSS1 user_project_wrapper_0.IOVSS1 sg13_hv_nmos ad=1.71p pd=9.38u as=1.71p ps=9.38u w=9u l=0.5u
X4668 user_project_wrapper_0.IOVSS1 a_182931_326125# user_project_wrapper_0.analog_io[27] user_project_wrapper_0.IOVSS1 sg13_lv_nmos ad=0.912p pd=5.18u as=0.912p ps=5.18u w=4.8u l=0.13u
X4669 user_project_wrapper_0.IOVSS1 user_project_wrapper_0.sg13g2_IOPadIOVdd_2.sg13g2_RCClampResistor_0.p2 user_project_wrapper_0.IOVSS1 user_project_wrapper_0.IOVSS1 sg13_hv_nmos ad=1.71p pd=9.38u as=0 ps=0 w=9u l=9.5u
X4670 a_309917_199879# a_309516_194555# VDD3 VDD3 sg13_lv_pmos ad=0.19p pd=1.38u as=0.19p ps=1.38u w=1u l=0.7u
X4671 user_project_wrapper_0.IOVSS1 user_project_wrapper_0.analog_io[35] dantenna l=1.26u w=27.78u
X4672 a_189729_99046# a_189395_99046# QDLL_TOP_0.VDD QDLL_TOP_0.VDD sg13_lv_pmos ad=0.2128p pd=1.5u as=0.3808p ps=2.92u w=1.12u l=0.13u
X4673 a_296731_208493# a_301186_192011# user_project_wrapper_0.IOVSS1 user_project_wrapper_0.IOVSS1 sg13_lv_nmos ad=1.632p pd=10.28u as=0.912p ps=5.18u w=4.8u l=1.06u
X4674 VDD3 user_project_wrapper_0.sg13g2_IOPadVdd_0.sg13g2_RCClampInverter_noptap_0.out user_project_wrapper_0.IOVSS1 user_project_wrapper_0.IOVSS1 sg13_hv_nmos ad=2.596p pd=5.58u as=1.408p ps=5.04u w=4.4u l=0.6u
X4675 a_90579_127530# a_84598_130577# user_project_wrapper_0.IOVSS1 user_project_wrapper_0.IOVSS1 sg13_lv_nmos ad=0.2516p pd=2.16u as=0.2516p ps=2.16u w=0.74u l=0.13u
X4676 analog_io[22] a_355624_197044# IOVDD3 IOVDD3 sg13_hv_pmos ad=3.9294p pd=7.84u as=2.1312p ps=7.3u w=6.66u l=0.6u
X4677 user_project_wrapper_0.IOVSS1 user_project_wrapper_0.IOVSS1 user_project_wrapper_0.IOVSS1 rhigh l=4u w=0.5u
X4678 a_82658_129203# a_82348_128838# user_project_wrapper_0.VDD1 user_project_wrapper_0.VDD1 sg13_lv_pmos ad=0.2128p pd=1.5u as=0.3808p ps=2.92u w=1.12u l=0.13u
X4679 user_project_wrapper_0.analog_io[1] user_project_wrapper_0.IOVDD1 dpantenna l=27.78u w=1.26u
X4680 VDD3 a_311108_179669# analog_io[20] user_project_wrapper_0.IOVSS1 sg13_lv_nmos ad=3.4p pd=20.68u as=3.4p ps=20.68u w=10u l=0.15u
X4681 user_project_wrapper_0.analog_io[32] user_project_wrapper_0.IOVDD4 dpantenna l=1.26u w=27.78u
X4682 a_301423_196360# a_296731_189665# cap_cmim l=21.4u w=21.4u
X4683 user_project_wrapper_0.analog_io[4] a_29676_197044# user_project_wrapper_0.IOVSS1 user_project_wrapper_0.IOVSS1 sg13_hv_nmos ad=2.596p pd=5.58u as=2.068p ps=9.74u w=4.4u l=0.6u
X4684 user_project_wrapper_0.IOVDD1 user_project_wrapper_0.sg13g2_IOPadIOVdd_1.sg13g2_Clamp_N43N43D4R_0.gate user_project_wrapper_0.IOVSS1 user_project_wrapper_0.IOVSS1 sg13_hv_nmos ad=2.596p pd=5.58u as=1.408p ps=5.04u w=4.4u l=0.6u
X4685 a_213376_328627# a_208855_324776# user_project_wrapper_0.IOVSS1 user_project_wrapper_0.IOVSS1 sg13_lv_pmos ad=3.264p pd=19.88u as=3.264p ps=19.88u w=9.6u l=0.13u
X4686 VDD3 user_project_wrapper_0.sg13g2_IOPadVdd_0.sg13g2_RCClampInverter_noptap_0.out user_project_wrapper_0.IOVSS1 user_project_wrapper_0.IOVSS1 sg13_hv_nmos ad=2.596p pd=5.58u as=1.408p ps=5.04u w=4.4u l=0.6u
X4687 a_237844_29676# user_project_wrapper_0.IOVSS1 user_project_wrapper_0.IOVSS1 rppd l=3.54u w=0.5u
X4688 user_project_wrapper_0.IOVSS1 a_301186_192011# a_296731_189665# user_project_wrapper_0.IOVSS1 sg13_lv_nmos ad=0.912p pd=5.18u as=0.912p ps=5.18u w=4.8u l=1.06u
X4689 user_project_wrapper_0.IOVSS1 a_208171_324119# a_208103_324155# w_207989_323975# sg13_lv_pmos ad=0.68p pd=4.68u as=0.38p ps=2.38u w=2u l=0.13u
X4690 analog_io[20] a_369296_176644# user_project_wrapper_0.IOVSS1 user_project_wrapper_0.IOVSS1 sg13_hv_nmos ad=2.596p pd=5.58u as=1.408p ps=5.04u w=4.4u l=0.6u
X4691 a_304995_198817# a_304889_199957# a_304196_200821# user_project_wrapper_0.IOVSS1 sg13_lv_nmos ad=0.374p pd=2.88u as=0.209p ps=1.48u w=1.1u l=0.15u
X4692 a_296732_200582# a_301940_196388# a_296625_208423# VDD3 sg13_lv_pmos ad=1.377p pd=8.78u as=0.7695p ps=4.43u w=4.05u l=0.5u
X4693 IOVDD3 a_355624_258244# analog_io[25] IOVDD3 sg13_hv_pmos ad=2.1312p pd=7.3u as=3.9294p ps=7.84u w=6.66u l=0.6u
X4694 user_project_wrapper_0.analog_io[5] a_29676_217444# user_project_wrapper_0.IOVSS1 user_project_wrapper_0.IOVSS1 sg13_hv_nmos ad=2.596p pd=5.58u as=1.408p ps=5.04u w=4.4u l=0.6u
X4695 a_74035_364458# a_73705_360372# user_project_wrapper_0.IOVSS1 rppd l=20u w=1u
X4696 a_304196_200821# a_304090_197941# a_296625_208423# user_project_wrapper_0.IOVSS1 sg13_lv_nmos ad=0.646p pd=4.48u as=0.361p ps=2.28u w=1.9u l=0.16u
X4697 user_project_wrapper_0.sg13g2_IOPadAnalog_23.padres user_project_wrapper_0.IOVDD4 dpantenna l=0.64u w=4.98u
X4698 VDD3 a_296626_197740# a_296732_197880# VDD3 sg13_lv_pmos ad=2.38p pd=14.68u as=1.33p ps=7.38u w=7u l=0.7u
X4699 user_project_wrapper_0.IOVSS1 user_project_wrapper_0.sg13g2_IOPadVdd_3.sg13g2_RCClampInverter_noptap_0.out user_project_wrapper_0.IOVSS1 user_project_wrapper_0.IOVSS1 sg13_hv_nmos ad=1.408p pd=5.04u as=0 ps=0 w=4.4u l=0.6u
X4700 user_project_wrapper_0.IOVSS1 user_project_wrapper_0.sg13g2_IOPadVdd_0.sg13g2_RCClampResistor_0.p2 user_project_wrapper_0.IOVSS1 user_project_wrapper_0.IOVSS1 sg13_hv_nmos ad=1.71p pd=9.38u as=0 ps=0 w=9u l=9.5u
X4701 user_project_wrapper_0.IOVDD1 a_41476_115444# user_project_wrapper_0.analog_io[0] user_project_wrapper_0.IOVDD1 sg13_hv_pmos ad=2.1312p pd=7.3u as=3.9294p ps=7.84u w=6.66u l=0.6u
X4702 user_project_wrapper_0.IOVSS1 user_project_wrapper_0.sg13g2_IOPadVdd_3.sg13g2_RCClampInverter_noptap_0.out user_project_wrapper_0.IOVSS1 user_project_wrapper_0.IOVSS1 sg13_hv_nmos ad=1.408p pd=5.04u as=0 ps=0 w=4.4u l=0.6u
X4703 IOVDD3 a_355624_115444# analog_io[18] IOVDD3 sg13_hv_pmos ad=2.1312p pd=7.3u as=3.9294p ps=7.84u w=6.66u l=0.6u
X4704 user_project_wrapper_0.sg13g2_IOPadIOVdd_3.sg13g2_Clamp_N43N43D4R_0.gate user_project_wrapper_0.sg13g2_IOPadIOVdd_3.sg13g2_RCClampResistor_0.p2 IOVDD3 IOVDD3 sg13_hv_pmos ad=1.33p pd=7.38u as=1.33p ps=7.38u w=7u l=0.5u
X4705 user_project_wrapper_0.VDD1 user_project_wrapper_0.sg13g2_IOPadVdd_2.sg13g2_RCClampResistor_0.p2 user_project_wrapper_0.sg13g2_IOPadVdd_2.sg13g2_RCClampInverter_noptap_0.out user_project_wrapper_0.VDD1 sg13_hv_pmos ad=1.33p pd=7.38u as=1.33p ps=7.38u w=7u l=0.5u
X4706 user_project_wrapper_0.analog_io[12] a_176644_41476# user_project_wrapper_0.IOVDD2 user_project_wrapper_0.IOVDD2 sg13_hv_pmos ad=3.9294p pd=7.84u as=2.1312p ps=7.3u w=6.66u l=0.6u
X4707 VDD3 a_296625_208423# a_296731_208493# VDD3 sg13_lv_pmos ad=0.2603p pd=1.75u as=0.2603p ps=1.75u w=1.37u l=0.35u
X4708 IOVDD3 user_project_wrapper_0.sg13g2_IOPadIOVdd_3.sg13g2_Clamp_N43N43D4R_0.gate user_project_wrapper_0.IOVSS1 user_project_wrapper_0.IOVSS1 sg13_hv_nmos ad=2.596p pd=5.58u as=1.408p ps=5.04u w=4.4u l=0.6u
X4709 user_project_wrapper_0.IOVSS1 a_186202_326221# a_182931_326125# user_project_wrapper_0.IOVSS1 sg13_lv_nmos ad=0.912p pd=5.18u as=0.912p ps=5.18u w=4.8u l=0.13u
X4710 a_209904_331163# a_210937_330987# user_project_wrapper_0.IOVSS1 rhigh l=4u w=0.5u
X4711 analog_io[25] a_369296_258244# user_project_wrapper_0.IOVSS1 user_project_wrapper_0.IOVSS1 sg13_hv_nmos ad=2.596p pd=5.58u as=1.408p ps=5.04u w=4.4u l=0.6u
X4712 user_project_wrapper_0.IOVSS1 a_29676_135844# user_project_wrapper_0.analog_io[1] user_project_wrapper_0.IOVSS1 sg13_hv_nmos ad=1.408p pd=5.04u as=2.596p ps=5.58u w=4.4u l=0.6u
X4713 a_309917_194695# a_309516_194555# VDD3 VDD3 sg13_lv_pmos ad=0.19p pd=1.38u as=0.34p ps=2.68u w=1u l=0.7u
X4714 user_project_wrapper_0.IOVDD4 a_278644_355624# user_project_wrapper_0.analog_io[35] user_project_wrapper_0.IOVDD4 sg13_hv_pmos ad=2.1312p pd=7.3u as=3.9294p ps=7.84u w=6.66u l=0.6u
X4715 user_project_wrapper_0.analog_io[10] a_135844_41476# user_project_wrapper_0.IOVDD2 user_project_wrapper_0.IOVDD2 sg13_hv_pmos ad=3.9294p pd=7.84u as=2.1312p ps=7.3u w=6.66u l=0.6u
X4716 user_project_wrapper_0.IOVSS1 user_project_wrapper_0.sg13g2_IOPadIOVdd_1.sg13g2_Clamp_N43N43D4R_0.gate user_project_wrapper_0.IOVDD1 user_project_wrapper_0.IOVSS1 sg13_hv_nmos ad=1.408p pd=5.04u as=2.596p ps=5.58u w=4.4u l=0.6u
X4717 IOVDD3 a_364458_297775# user_project_wrapper_0.IOVSS1 rppd l=20u w=1u
X4718 user_project_wrapper_0.IOVSS1 user_project_wrapper_0.sg13g2_IOPadVdd_3.sg13g2_RCClampInverter_noptap_0.out user_project_wrapper_0.IOVSS1 user_project_wrapper_0.IOVSS1 sg13_hv_nmos ad=1.408p pd=5.04u as=0 ps=0 w=4.4u l=0.6u
X4719 user_project_wrapper_0.sg13g2_IOPadIOVdd_2.sg13g2_Clamp_N43N43D4R_0.gate user_project_wrapper_0.sg13g2_IOPadIOVdd_2.sg13g2_RCClampResistor_0.p2 user_project_wrapper_0.IOVDD4 user_project_wrapper_0.IOVDD4 sg13_hv_pmos ad=1.33p pd=7.38u as=1.33p ps=7.38u w=7u l=0.5u
X4720 a_190501_327491# a_189184_327491# user_project_wrapper_0.IOVSS1 w_188704_327938# sg13_lv_pmos ad=0.68p pd=4.68u as=0.68p ps=4.68u w=2u l=0.13u
X4721 a_296731_189665# a_296625_189595# VDD3 VDD3 sg13_lv_pmos ad=0.2603p pd=1.75u as=0.2603p ps=1.75u w=1.37u l=0.35u
X4722 user_project_wrapper_0.IOVDD1 user_project_wrapper_0.sg13g2_IOPadIOVdd_1.sg13g2_Clamp_N43N43D4R_0.gate user_project_wrapper_0.IOVSS1 user_project_wrapper_0.IOVSS1 sg13_hv_nmos ad=2.596p pd=5.58u as=1.408p ps=5.04u w=4.4u l=0.6u
X4723 user_project_wrapper_0.IOVSS1 user_project_wrapper_0.sg13g2_IOPadIOVdd_2.sg13g2_Clamp_N43N43D4R_0.gate user_project_wrapper_0.IOVDD4 user_project_wrapper_0.IOVSS1 sg13_hv_nmos ad=1.408p pd=5.04u as=2.596p ps=5.58u w=4.4u l=0.6u
X4724 user_project_wrapper_0.VDD1 user_project_wrapper_0.sg13g2_IOPadVdd_2.sg13g2_RCClampInverter_noptap_0.out user_project_wrapper_0.IOVSS1 user_project_wrapper_0.IOVSS1 sg13_hv_nmos ad=2.596p pd=5.58u as=1.408p ps=5.04u w=4.4u l=0.6u
X4725 user_project_wrapper_0.IOVDD2 a_176644_41476# user_project_wrapper_0.analog_io[12] user_project_wrapper_0.IOVDD2 sg13_hv_pmos ad=2.1312p pd=7.3u as=3.9294p ps=7.84u w=6.66u l=0.6u
X4726 a_86594_129426# a_85127_131750# a_86594_129061# user_project_wrapper_0.IOVSS1 sg13_lv_nmos ad=0.2516p pd=2.16u as=0.1406p ps=1.12u w=0.74u l=0.13u
X4727 user_project_wrapper_0.IOVSS1 analog_io[23] dantenna l=27.78u w=1.26u
X4728 user_project_wrapper_0.IOVSS1 user_project_wrapper_0.sg13g2_IOPadAnalog_22.padres a_208469_329327# user_project_wrapper_0.IOVSS1 sg13_lv_nmos ad=0.34p pd=2.68u as=0.19p ps=1.38u w=1u l=0.13u
X4729 a_296731_189665# a_296625_189595# VDD3 VDD3 sg13_lv_pmos ad=0.2603p pd=1.75u as=0.2603p ps=1.75u w=1.37u l=0.35u
X4730 VDD3 a_296625_208423# a_296731_208493# VDD3 sg13_lv_pmos ad=0.2603p pd=1.75u as=0.2603p ps=1.75u w=1.37u l=0.35u
X4731 a_360372_76345# a_364458_76675# user_project_wrapper_0.IOVSS1 rppd l=20u w=1u
X4732 a_304889_198885# user_project_wrapper_0.sg13g2_IOPadAnalog_26.padres user_project_wrapper_0.IOVSS1 rppd l=6.73u w=0.6u
X4733 user_project_wrapper_0.IOVSS1 a_29676_217444# user_project_wrapper_0.analog_io[5] user_project_wrapper_0.IOVSS1 sg13_hv_nmos ad=2.068p pd=9.74u as=2.596p ps=5.58u w=4.4u l=0.6u
X4734 analog_io[18] IOVDD3 dpantenna l=27.78u w=1.26u
X4735 a_84288_130212# a_83796_129203# user_project_wrapper_0.VDD1 user_project_wrapper_0.VDD1 sg13_lv_pmos ad=0.3808p pd=2.92u as=0.3808p ps=2.92u w=1.12u l=0.13u
X4736 user_project_wrapper_0.IOVSS1 a_190047_324119# a_187364_324106# user_project_wrapper_0.IOVSS1 sg13_lv_nmos ad=0.19p pd=1.38u as=0.34p ps=2.68u w=1u l=0.13u
X4737 user_project_wrapper_0.sg13g2_IOPadOut4mA$1_0.c2p a_93204_129062# user_project_wrapper_0.IOVSS1 user_project_wrapper_0.IOVSS1 sg13_lv_nmos ad=0.2516p pd=2.16u as=0.2516p ps=2.16u w=0.74u l=0.13u
X4738 user_project_wrapper_0.IOVSS1 a_29676_135844# user_project_wrapper_0.IOVSS1 rppd l=3.54u w=0.5u
X4739 user_project_wrapper_0.IOVSS1 user_project_wrapper_0.sg13g2_IOPadVdd_0.sg13g2_RCClampInverter_noptap_0.out VDD3 user_project_wrapper_0.IOVSS1 sg13_hv_nmos ad=1.408p pd=5.04u as=2.596p ps=5.58u w=4.4u l=0.6u
X4740 a_296732_197880# a_301940_196388# a_296625_189595# VDD3 sg13_lv_pmos ad=0.7695p pd=4.43u as=0.7695p ps=4.43u w=4.05u l=0.5u
X4741 a_304995_198817# a_304889_199957# a_304196_200821# user_project_wrapper_0.IOVSS1 sg13_lv_nmos ad=0.209p pd=1.48u as=0.209p ps=1.48u w=1.1u l=0.15u
X4742 user_project_wrapper_0.IOVDD2 user_project_wrapper_0.sg13g2_IOPadIOVdd_0.sg13g2_RCClampResistor_0.p2 user_project_wrapper_0.sg13g2_IOPadIOVdd_0.sg13g2_Clamp_N43N43D4R_0.gate user_project_wrapper_0.IOVDD2 sg13_hv_pmos ad=1.33p pd=7.38u as=1.33p ps=7.38u w=7u l=0.5u
X4743 a_296731_189665# a_296625_189595# VDD3 VDD3 sg13_lv_pmos ad=0.2603p pd=1.75u as=0.4658p ps=3.42u w=1.37u l=0.35u
X4744 user_project_wrapper_0.analog_io[28] a_135844_355624# user_project_wrapper_0.IOVDD4 user_project_wrapper_0.IOVDD4 sg13_hv_pmos ad=3.9294p pd=7.84u as=2.1312p ps=7.3u w=6.66u l=0.6u
X4745 a_296731_189665# a_296625_189595# VDD3 VDD3 sg13_lv_pmos ad=0.2603p pd=1.75u as=0.2603p ps=1.75u w=1.37u l=0.35u
X4746 VDD3 a_296625_189595# a_296731_189665# VDD3 sg13_lv_pmos ad=0.4658p pd=3.42u as=0.2603p ps=1.75u w=1.37u l=0.35u
X4747 a_309917_199879# a_296731_208493# a_307232_196607# VDD3 sg13_lv_pmos ad=0.24415p pd=1.665u as=0.24415p ps=1.665u w=1.285u l=0.35u
X4748 user_project_wrapper_0.VDD1 user_project_wrapper_0.sg13g2_IOPadVdd_2.sg13g2_RCClampInverter_noptap_0.out user_project_wrapper_0.IOVSS1 user_project_wrapper_0.IOVSS1 sg13_hv_nmos ad=2.596p pd=5.58u as=1.408p ps=5.04u w=4.4u l=0.6u
X4749 user_project_wrapper_0.IOVSS1 user_project_wrapper_0.uo_PAD[8] dantenna l=27.78u w=1.26u
X4750 a_87571_125210# a_87468_125419# user_project_wrapper_0.IOVSS1 user_project_wrapper_0.IOVSS1 sg13_lv_nmos ad=0.1406p pd=1.12u as=0.2516p ps=2.16u w=0.74u l=0.13u
X4751 IOVDD3 a_355624_278644# analog_io[26] IOVDD3 sg13_hv_pmos ad=2.1312p pd=7.3u as=3.9294p ps=7.84u w=6.66u l=0.6u
X4752 a_93208_127531# a_92512_127896# user_project_wrapper_0.IOVSS1 user_project_wrapper_0.IOVSS1 sg13_lv_nmos ad=0.2516p pd=2.16u as=0.2516p ps=2.16u w=0.74u l=0.13u
X4753 a_79038_136536# a_78219_135283# a_79025_137844# user_project_wrapper_0.VDD1 sg13_lv_pmos ad=0.95p pd=5.38u as=1.7p ps=10.68u w=5u l=0.3u
X4754 user_project_wrapper_0.analog_io[34] a_258244_355624# user_project_wrapper_0.IOVDD4 user_project_wrapper_0.IOVDD4 sg13_hv_pmos ad=3.9294p pd=7.84u as=2.1312p ps=7.3u w=6.66u l=0.6u
X4755 a_209041_325785# a_208939_326377# a_208939_325263# w_207887_326203# sg13_lv_pmos ad=0.38p pd=2.38u as=0.38p ps=2.38u w=2u l=0.13u
X4756 a_270512_100118# a_270178_100118# QDLL_TOP_0.VDD QDLL_TOP_0.VDD sg13_lv_pmos ad=0.2128p pd=1.5u as=0.3808p ps=2.92u w=1.12u l=0.13u
X4757 user_project_wrapper_0.analog_io[32] a_202114_326125# user_project_wrapper_0.IOVSS1 user_project_wrapper_0.IOVSS1 sg13_lv_nmos ad=0.912p pd=5.18u as=0.912p ps=5.18u w=4.8u l=0.13u
X4758 user_project_wrapper_0.IOVDD2 a_258244_41476# user_project_wrapper_0.analog_io[16] user_project_wrapper_0.IOVDD2 sg13_hv_pmos ad=2.1312p pd=7.3u as=3.9294p ps=7.84u w=6.66u l=0.6u
X4759 user_project_wrapper_0.VDD2 user_project_wrapper_0.sg13g2_IOPadVdd_1.sg13g2_RCClampInverter_noptap_0.out user_project_wrapper_0.IOVSS1 user_project_wrapper_0.IOVSS1 sg13_hv_nmos ad=2.596p pd=5.58u as=1.408p ps=5.04u w=4.4u l=0.6u
X4760 a_83586_127455# a_83164_127820# a_83492_127455# user_project_wrapper_0.IOVSS1 sg13_lv_nmos ad=0.1406p pd=1.12u as=0.2516p ps=2.16u w=0.74u l=0.13u
X4761 a_299095_364458# a_299425_360372# user_project_wrapper_0.IOVSS1 rppd l=20u w=1u
X4762 a_296731_208493# a_296625_208423# VDD3 VDD3 sg13_lv_pmos ad=0.2603p pd=1.75u as=0.2603p ps=1.75u w=1.37u l=0.35u
X4763 user_project_wrapper_0.IOVSS1 user_project_wrapper_0.sg13g2_IOPadIOVdd_2.sg13g2_RCClampResistor_0.p2 user_project_wrapper_0.IOVSS1 user_project_wrapper_0.IOVSS1 sg13_hv_nmos ad=1.71p pd=9.38u as=0 ps=0 w=9u l=9.5u
X4764 user_project_wrapper_0.VDD1 user_project_wrapper_0.sg13g2_IOPadVdd_2.sg13g2_RCClampInverter_noptap_0.out user_project_wrapper_0.IOVSS1 user_project_wrapper_0.IOVSS1 sg13_hv_nmos ad=2.596p pd=5.58u as=1.408p ps=5.04u w=4.4u l=0.6u
X4765 a_304995_198817# a_304889_198885# a_304196_197873# user_project_wrapper_0.IOVSS1 sg13_lv_nmos ad=0.374p pd=2.88u as=0.209p ps=1.48u w=1.1u l=0.15u
X4766 user_project_wrapper_0.analog_io[35] a_213870_324142# user_project_wrapper_0.IOVSS1 user_project_wrapper_0.IOVSS1 sg13_lv_pmos ad=1.824p pd=9.98u as=1.824p ps=9.98u w=9.6u l=0.13u
X4767 a_304196_200821# a_304090_197941# a_296625_208423# user_project_wrapper_0.IOVSS1 sg13_lv_nmos ad=0.646p pd=4.48u as=0.361p ps=2.28u w=1.9u l=0.16u
X4768 user_project_wrapper_0.IOVDD4 a_217444_355624# user_project_wrapper_0.analog_io[32] user_project_wrapper_0.IOVDD4 sg13_hv_pmos ad=2.1312p pd=7.3u as=3.9294p ps=7.84u w=6.66u l=0.6u
X4769 user_project_wrapper_0.IOVSS1 a_182931_326125# user_project_wrapper_0.analog_io[27] user_project_wrapper_0.IOVSS1 sg13_lv_pmos ad=1.824p pd=9.98u as=1.824p ps=9.98u w=9.6u l=0.13u
X4770 a_296731_208493# a_296625_208423# VDD3 VDD3 sg13_lv_pmos ad=0.2603p pd=1.75u as=0.4658p ps=3.42u w=1.37u l=0.35u
X4771 user_project_wrapper_0.sg13g2_IOPadIOVdd_3.sg13g2_Clamp_N43N43D4R_0.gate user_project_wrapper_0.sg13g2_IOPadIOVdd_3.sg13g2_RCClampResistor_0.p2 IOVDD3 IOVDD3 sg13_hv_pmos ad=1.33p pd=7.38u as=1.33p ps=7.38u w=7u l=0.5u
X4772 user_project_wrapper_0.IOVSS1 user_project_wrapper_0.sg13g2_IOPadVdd_0.sg13g2_RCClampInverter_noptap_0.out VDD3 user_project_wrapper_0.IOVSS1 sg13_hv_nmos ad=1.408p pd=5.04u as=2.596p ps=5.58u w=4.4u l=0.6u
X4773 a_296731_208493# a_296625_208423# VDD3 VDD3 sg13_lv_pmos ad=0.2603p pd=1.75u as=0.2603p ps=1.75u w=1.37u l=0.35u
X4774 user_project_wrapper_0.sg13g2_IOPadIOVdd_2.sg13g2_Clamp_N43N43D4R_0.gate user_project_wrapper_0.sg13g2_IOPadIOVdd_2.sg13g2_RCClampResistor_0.p2 user_project_wrapper_0.IOVDD4 user_project_wrapper_0.IOVDD4 sg13_hv_pmos ad=1.33p pd=7.38u as=1.33p ps=7.38u w=7u l=0.5u
X4775 user_project_wrapper_0.IOVSS1 a_186202_326221# a_182931_326125# user_project_wrapper_0.IOVSS1 sg13_lv_pmos ad=1.824p pd=9.98u as=1.824p ps=9.98u w=9.6u l=0.13u
X4776 user_project_wrapper_0.analog_io[11] a_156244_41476# user_project_wrapper_0.IOVDD2 user_project_wrapper_0.IOVDD2 sg13_hv_pmos ad=3.9294p pd=7.84u as=3.1302p ps=14.26u w=6.66u l=0.6u
X4777 a_190722_325785# a_189756_325263# user_project_wrapper_0.IOVSS1 w_188704_326203# sg13_lv_pmos ad=0.38p pd=2.38u as=0.68p ps=4.68u w=2u l=0.13u
X4778 a_213870_324142# a_213462_327536# user_project_wrapper_0.IOVSS1 user_project_wrapper_0.IOVSS1 sg13_lv_nmos ad=0.912p pd=5.18u as=0.912p ps=5.18u w=4.8u l=0.13u
X4779 user_project_wrapper_0.IOVDD2 user_project_wrapper_0.sg13g2_IOPadIOVdd_0.sg13g2_Clamp_N43N43D4R_0.gate user_project_wrapper_0.IOVSS1 user_project_wrapper_0.IOVSS1 sg13_hv_nmos ad=2.596p pd=5.58u as=1.408p ps=5.04u w=4.4u l=0.6u
X4780 analog_io[19] a_369296_135844# user_project_wrapper_0.IOVSS1 user_project_wrapper_0.IOVSS1 sg13_hv_nmos ad=2.596p pd=5.58u as=1.408p ps=5.04u w=4.4u l=0.6u
X4781 user_project_wrapper_0.IOVSS1 a_29676_258244# user_project_wrapper_0.analog_io[7] user_project_wrapper_0.IOVSS1 sg13_hv_nmos ad=1.408p pd=5.04u as=2.596p ps=5.58u w=4.4u l=0.6u
X4782 user_project_wrapper_0.IOVSS1 user_project_wrapper_0.sg13g2_IOPadVdd_3.sg13g2_RCClampInverter_noptap_0.out user_project_wrapper_0.IOVSS1 user_project_wrapper_0.IOVSS1 sg13_hv_nmos ad=1.408p pd=5.04u as=0 ps=0 w=4.4u l=0.6u
X4783 a_190287_98223# a_190218_98097# QDLL_TOP_0.VDD QDLL_TOP_0.VDD sg13_lv_pmos ad=0.1225p pd=1.245u as=0.36p ps=2.72u w=1u l=0.13u
X4784 user_project_wrapper_0.analog_io[12] user_project_wrapper_0.IOVDD2 dpantenna l=1.26u w=27.78u
X4785 user_project_wrapper_0.IOVDD2 user_project_wrapper_0.sg13g2_IOPadIOVdd_0.sg13g2_Clamp_N43N43D4R_0.gate user_project_wrapper_0.IOVSS1 user_project_wrapper_0.IOVSS1 sg13_hv_nmos ad=3.256p pd=10.28u as=1.408p ps=5.04u w=4.4u l=0.6u
X4786 user_project_wrapper_0.sg13g2_IOPadAnalog_15.padres user_project_wrapper_0.IOVDD1 dpantenna l=4.98u w=0.64u
X4787 user_project_wrapper_0.VDD1 a_89953_129061# a_93461_128591# user_project_wrapper_0.VDD1 sg13_lv_pmos ad=0.3808p pd=2.92u as=0.2128p ps=1.5u w=1.12u l=0.13u
X4788 a_79025_129571# a_79038_128322# user_project_wrapper_0.IOVSS1 user_project_wrapper_0.IOVSS1 sg13_lv_nmos ad=0.1428p pd=1.52u as=0.1428p ps=1.52u w=0.42u l=0.56u
X4789 user_project_wrapper_0.analog_io[28] a_135844_369296# user_project_wrapper_0.IOVSS1 user_project_wrapper_0.IOVSS1 sg13_hv_nmos ad=2.596p pd=5.58u as=1.408p ps=5.04u w=4.4u l=0.6u
X4790 user_project_wrapper_0.IOVSS1 a_202114_326125# user_project_wrapper_0.analog_io[32] user_project_wrapper_0.IOVSS1 sg13_lv_pmos ad=1.824p pd=9.98u as=1.824p ps=9.98u w=9.6u l=0.13u
X4791 a_311108_179669# analog_io[20] a_313884_185173# user_project_wrapper_0.IOVSS1 sg13_lv_nmos ad=1.9p pd=10.38u as=1.9p ps=10.38u w=10u l=0.5u
X4792 user_project_wrapper_0.IOVDD2 user_project_wrapper_0.sg13g2_IOPadIOVdd_0.sg13g2_Clamp_N43N43D4R_0.gate user_project_wrapper_0.IOVSS1 user_project_wrapper_0.IOVSS1 sg13_hv_nmos ad=2.596p pd=5.58u as=1.408p ps=5.04u w=4.4u l=0.6u
X4793 QDLL_TOP_0.VDD a_188572_99046# a_188760_99480# QDLL_TOP_0.VDD sg13_lv_pmos ad=0.2481p pd=1.56u as=0.1428p ps=1.52u w=0.42u l=0.13u
X4794 user_project_wrapper_0.IOVSS1 user_project_wrapper_0.sg13g2_IOPadVdd_0.sg13g2_RCClampResistor_0.p2 user_project_wrapper_0.sg13g2_IOPadVdd_0.sg13g2_RCClampInverter_noptap_0.out user_project_wrapper_0.IOVSS1 sg13_hv_nmos ad=1.71p pd=9.38u as=1.71p ps=9.38u w=9u l=0.5u
X4795 user_project_wrapper_0.analog_io[34] a_258244_355624# user_project_wrapper_0.IOVDD4 user_project_wrapper_0.IOVDD4 sg13_hv_pmos ad=3.9294p pd=7.84u as=2.1312p ps=7.3u w=6.66u l=0.6u
X4796 user_project_wrapper_0.IOVDD1 user_project_wrapper_0.sg13g2_IOPadIOVdd_1.sg13g2_Clamp_N43N43D4R_0.gate user_project_wrapper_0.IOVSS1 user_project_wrapper_0.IOVSS1 sg13_hv_nmos ad=2.596p pd=5.58u as=1.408p ps=5.04u w=4.4u l=0.6u
X4797 user_project_wrapper_0.IOVSS1 a_156244_29676# user_project_wrapper_0.analog_io[11] user_project_wrapper_0.IOVSS1 sg13_hv_nmos ad=1.408p pd=5.04u as=2.596p ps=5.58u w=4.4u l=0.6u
X4798 VDD3 a_309516_194555# a_309917_194695# VDD3 sg13_lv_pmos ad=0.19p pd=1.38u as=0.19p ps=1.38u w=1u l=0.7u
X4799 user_project_wrapper_0.IOVDD2 user_project_wrapper_0.sg13g2_IOPadIOVdd_0.sg13g2_Clamp_N43N43D4R_0.gate user_project_wrapper_0.IOVSS1 user_project_wrapper_0.IOVSS1 sg13_hv_nmos ad=2.596p pd=5.58u as=1.408p ps=5.04u w=4.4u l=0.6u
X4800 VDD3 a_296625_189595# a_296731_189665# VDD3 sg13_lv_pmos ad=0.2603p pd=1.75u as=0.2603p ps=1.75u w=1.37u l=0.35u
X4801 user_project_wrapper_0.IOVSS1 a_186202_326221# a_182931_326125# user_project_wrapper_0.IOVSS1 sg13_lv_pmos ad=1.824p pd=9.98u as=1.824p ps=9.98u w=9.6u l=0.13u
X4802 user_project_wrapper_0.IOVDD2 a_156244_41476# user_project_wrapper_0.analog_io[11] user_project_wrapper_0.IOVDD2 sg13_hv_pmos ad=3.1302p pd=14.26u as=3.9294p ps=7.84u w=6.66u l=0.6u
X4803 user_project_wrapper_0.IOVSS1 user_project_wrapper_0.sg13g2_IOPadVdd_3.sg13g2_RCClampInverter_noptap_0.out user_project_wrapper_0.IOVSS1 user_project_wrapper_0.IOVSS1 sg13_hv_nmos ad=2.596p pd=5.58u as=0 ps=0 w=4.4u l=0.6u
X4804 user_project_wrapper_0.IOVDD4 a_135844_355624# user_project_wrapper_0.analog_io[28] user_project_wrapper_0.IOVDD4 sg13_hv_pmos ad=2.1312p pd=7.3u as=3.9294p ps=7.84u w=6.66u l=0.6u
X4805 user_project_wrapper_0.IOVSS1 user_project_wrapper_0.sg13g2_IOPadAnalog_20.padres dantenna l=3.1u w=0.64u
X4806 analog_io[23] a_369296_237844# user_project_wrapper_0.IOVSS1 user_project_wrapper_0.IOVSS1 sg13_hv_nmos ad=2.596p pd=5.58u as=1.408p ps=5.04u w=4.4u l=0.6u
X4807 user_project_wrapper_0.IOVSS1 user_project_wrapper_0.sg13g2_IOPadVdd_2.sg13g2_RCClampInverter_noptap_0.out user_project_wrapper_0.VDD1 user_project_wrapper_0.IOVSS1 sg13_hv_nmos ad=1.408p pd=5.04u as=2.596p ps=5.58u w=4.4u l=0.6u
X4808 a_304995_198817# a_304889_198885# a_304196_197873# user_project_wrapper_0.IOVSS1 sg13_lv_nmos ad=0.209p pd=1.48u as=0.209p ps=1.48u w=1.1u l=0.15u
X4809 user_project_wrapper_0.analog_io[6] a_41476_237844# user_project_wrapper_0.IOVDD1 user_project_wrapper_0.IOVDD1 sg13_hv_pmos ad=3.9294p pd=7.84u as=2.1312p ps=7.3u w=6.66u l=0.6u
X4810 user_project_wrapper_0.IOVSS1 a_208171_324119# a_208103_324155# w_207989_323975# sg13_lv_pmos ad=0.38p pd=2.38u as=0.68p ps=4.68u w=2u l=0.13u
X4811 analog_io[23] a_355624_237844# IOVDD3 IOVDD3 sg13_hv_pmos ad=3.9294p pd=7.84u as=2.1312p ps=7.3u w=6.66u l=0.6u
X4812 a_309917_194695# user_project_wrapper_0.sg13g2_IOPadAnalog_29.padres a_311846_195517# VDD3 sg13_lv_pmos ad=0.24415p pd=1.665u as=0.24415p ps=1.665u w=1.285u l=0.35u
X4813 a_79025_129164# a_78824_128711# user_project_wrapper_0.VDD1 user_project_wrapper_0.VDD1 sg13_lv_pmos ad=0.95p pd=5.38u as=1.7p ps=10.68u w=5u l=0.15u
X4814 user_project_wrapper_0.IOVSS1 a_307232_196607# a_304995_198817# user_project_wrapper_0.IOVSS1 sg13_lv_nmos ad=0.6327p pd=3.71u as=0.6327p ps=3.71u w=3.33u l=0.2u
X4815 user_project_wrapper_0.IOVSS1 user_project_wrapper_0.sg13g2_IOPadIOVdd_1.sg13g2_Clamp_N43N43D4R_0.gate user_project_wrapper_0.IOVDD1 user_project_wrapper_0.IOVSS1 sg13_hv_nmos ad=1.408p pd=5.04u as=2.596p ps=5.58u w=4.4u l=0.6u
X4816 user_project_wrapper_0.analog_io[6] a_29676_237844# user_project_wrapper_0.IOVSS1 user_project_wrapper_0.IOVSS1 sg13_hv_nmos ad=2.596p pd=5.58u as=1.408p ps=5.04u w=4.4u l=0.6u
X4817 user_project_wrapper_0.IOVSS1 a_182931_326125# user_project_wrapper_0.analog_io[27] user_project_wrapper_0.IOVSS1 sg13_lv_nmos ad=0.912p pd=5.18u as=0.912p ps=5.18u w=4.8u l=0.13u
X4818 user_project_wrapper_0.analog_io[5] a_41476_217444# user_project_wrapper_0.IOVDD1 user_project_wrapper_0.IOVDD1 sg13_hv_pmos ad=3.9294p pd=7.84u as=2.1312p ps=7.3u w=6.66u l=0.6u
X4819 a_296731_189665# a_301186_192011# user_project_wrapper_0.IOVSS1 user_project_wrapper_0.IOVSS1 sg13_lv_nmos ad=0.912p pd=5.18u as=0.912p ps=5.18u w=4.8u l=1.06u
X4820 a_213462_327536# a_213376_328627# user_project_wrapper_0.IOVSS1 user_project_wrapper_0.IOVSS1 sg13_lv_pmos ad=1.824p pd=9.98u as=3.264p ps=19.88u w=9.6u l=0.13u
X4821 a_314697_196700# a_314793_201808# a_315347_192648# user_project_wrapper_0.IOVSS1 sg13_lv_nmos ad=1.14p pd=6.38u as=1.14p ps=6.38u w=6u l=6.4u
X4822 user_project_wrapper_0.IOVDD4 user_project_wrapper_0.sg13g2_IOPadIOVdd_2.sg13g2_Clamp_N43N43D4R_0.gate user_project_wrapper_0.IOVSS1 user_project_wrapper_0.IOVSS1 sg13_hv_nmos ad=2.596p pd=5.58u as=1.408p ps=5.04u w=4.4u l=0.6u
X4823 user_project_wrapper_0.analog_io[13] a_197044_41476# user_project_wrapper_0.IOVDD2 user_project_wrapper_0.IOVDD2 sg13_hv_pmos ad=3.9294p pd=7.84u as=2.1312p ps=7.3u w=6.66u l=0.6u
X4824 user_project_wrapper_0.analog_io[30] a_176644_355624# user_project_wrapper_0.IOVDD4 user_project_wrapper_0.IOVDD4 sg13_hv_pmos ad=3.9294p pd=7.84u as=2.1312p ps=7.3u w=6.66u l=0.6u
X4825 a_89953_129061# a_89114_129426# user_project_wrapper_0.VDD1 user_project_wrapper_0.VDD1 sg13_lv_pmos ad=0.3808p pd=2.92u as=0.3808p ps=2.92u w=1.12u l=0.13u
X4826 a_190297_327491# a_189756_327491# user_project_wrapper_0.IOVSS1 w_188704_327938# sg13_lv_pmos ad=0.68p pd=4.68u as=0.68p ps=4.68u w=2u l=0.13u
X4827 a_85875_125209# a_85211_124842# a_85435_125173# user_project_wrapper_0.VDD1 sg13_lv_pmos ad=0.2128p pd=1.5u as=0.2128p ps=1.5u w=1.12u l=0.13u
X4828 user_project_wrapper_0.IOVSS1 user_project_wrapper_0.sg13g2_IOPadVdd_0.sg13g2_RCClampResistor_0.p2 user_project_wrapper_0.IOVSS1 user_project_wrapper_0.IOVSS1 sg13_hv_nmos ad=1.71p pd=9.38u as=0 ps=0 w=9u l=9.5u
X4829 user_project_wrapper_0.VDD1 user_project_wrapper_0.sg13g2_IOPadVdd_2.sg13g2_RCClampInverter_noptap_0.out user_project_wrapper_0.IOVSS1 user_project_wrapper_0.IOVSS1 sg13_hv_nmos ad=2.596p pd=5.58u as=1.408p ps=5.04u w=4.4u l=0.6u
X4830 user_project_wrapper_0.analog_io[12] a_176644_29676# user_project_wrapper_0.IOVSS1 user_project_wrapper_0.IOVSS1 sg13_hv_nmos ad=2.596p pd=5.58u as=1.408p ps=5.04u w=4.4u l=0.6u
X4831 a_213870_324142# a_213462_327536# user_project_wrapper_0.IOVSS1 user_project_wrapper_0.IOVSS1 sg13_lv_pmos ad=1.824p pd=9.98u as=1.824p ps=9.98u w=9.6u l=0.13u
X4832 user_project_wrapper_0.analog_io[0] a_41476_115444# user_project_wrapper_0.IOVDD1 user_project_wrapper_0.IOVDD1 sg13_hv_pmos ad=3.9294p pd=7.84u as=2.1312p ps=7.3u w=6.66u l=0.6u
X4833 a_296732_200582# a_301940_196388# a_296625_208423# VDD3 sg13_lv_pmos ad=0.7695p pd=4.43u as=0.7695p ps=4.43u w=4.05u l=0.5u
X4834 user_project_wrapper_0.IOVDD4 a_135844_355624# user_project_wrapper_0.analog_io[28] user_project_wrapper_0.IOVDD4 sg13_hv_pmos ad=2.1312p pd=7.3u as=3.9294p ps=7.84u w=6.66u l=0.6u
X4835 user_project_wrapper_0.IOVSS1 a_217444_369296# user_project_wrapper_0.analog_io[32] user_project_wrapper_0.IOVSS1 sg13_hv_nmos ad=2.068p pd=9.74u as=2.596p ps=5.58u w=4.4u l=0.6u
X4836 a_208367_328605# user_project_wrapper_0.IOVSS1 user_project_wrapper_0.IOVSS1 user_project_wrapper_0.IOVSS1 sg13_lv_nmos ad=0.19p pd=1.38u as=0.34p ps=2.68u w=1u l=0.13u
X4837 user_project_wrapper_0.IOVSS1 a_29676_258244# user_project_wrapper_0.analog_io[7] user_project_wrapper_0.IOVSS1 sg13_hv_nmos ad=1.408p pd=5.04u as=2.596p ps=5.58u w=4.4u l=0.6u
X4838 a_189858_329719# a_189756_325263# a_189756_329719# user_project_wrapper_0.IOVSS1 sg13_lv_nmos ad=0.19p pd=1.38u as=0.19p ps=1.38u w=1u l=0.13u
X4839 a_35456_73375# a_39542_73705# user_project_wrapper_0.IOVSS1 rppd l=20u w=1u
X4840 user_project_wrapper_0.analog_io[10] a_135844_29676# user_project_wrapper_0.IOVSS1 user_project_wrapper_0.IOVSS1 sg13_hv_nmos ad=2.596p pd=5.58u as=1.408p ps=5.04u w=4.4u l=0.6u
X4841 a_84332_125209# a_82667_125418# user_project_wrapper_0.VDD1 user_project_wrapper_0.VDD1 sg13_lv_pmos ad=0.3808p pd=2.92u as=0.3808p ps=2.92u w=1.12u l=0.13u
X4842 user_project_wrapper_0.IOVSS1 user_project_wrapper_0.sg13g2_IOPadVdd_1.sg13g2_RCClampInverter_noptap_0.out user_project_wrapper_0.VDD2 user_project_wrapper_0.IOVSS1 sg13_hv_nmos ad=1.408p pd=5.04u as=2.596p ps=5.58u w=4.4u l=0.6u
X4843 user_project_wrapper_0.IOVSS1 a_369296_237844# analog_io[23] user_project_wrapper_0.IOVSS1 sg13_hv_nmos ad=2.068p pd=9.74u as=2.596p ps=5.58u w=4.4u l=0.6u
X4844 user_project_wrapper_0.IOVDD1 a_41476_237844# user_project_wrapper_0.analog_io[6] user_project_wrapper_0.IOVDD1 sg13_hv_pmos ad=2.1312p pd=7.3u as=3.9294p ps=7.84u w=6.66u l=0.6u
X4845 user_project_wrapper_0.sg13g2_IOPadAnalog_6.padres user_project_wrapper_0.analog_io[10] user_project_wrapper_0.IOVSS1 rppd l=2u w=1u
X4846 user_project_wrapper_0.IOVSS1 a_208017_326341# a_209041_328013# w_207887_327938# sg13_lv_pmos ad=0.68p pd=4.68u as=0.38p ps=2.38u w=2u l=0.13u
X4847 a_79975_364458# a_80305_360372# user_project_wrapper_0.IOVSS1 rppd l=20u w=1u
X4848 a_369296_156244# user_project_wrapper_0.IOVSS1 user_project_wrapper_0.IOVSS1 rppd l=3.54u w=0.5u
X4849 user_project_wrapper_0.IOVDD1 user_project_wrapper_0.sg13g2_IOPadOut4mA$1_0.sg13g2_GateLevelUpInv_noptap$1$1_0.pgate user_project_wrapper_0.uo_PAD[3] user_project_wrapper_0.IOVDD1 sg13_hv_pmos ad=3.1302p pd=14.26u as=3.9294p ps=7.84u w=6.66u l=0.6u
X4850 user_project_wrapper_0.analog_io[27] a_182931_326125# user_project_wrapper_0.IOVSS1 user_project_wrapper_0.IOVSS1 sg13_lv_nmos ad=0.912p pd=5.18u as=0.912p ps=5.18u w=4.8u l=0.13u
X4851 a_87627_124843# a_86507_127725# user_project_wrapper_0.VDD1 user_project_wrapper_0.VDD1 sg13_lv_pmos ad=0.3808p pd=2.92u as=0.3808p ps=2.92u w=1.12u l=0.13u
X4852 IOVDD3 a_355624_115444# analog_io[18] IOVDD3 sg13_hv_pmos ad=2.1312p pd=7.3u as=3.9294p ps=7.84u w=6.66u l=0.6u
X4853 user_project_wrapper_0.IOVSS1 user_project_wrapper_0.sg13g2_IOPadVdd_1.sg13g2_RCClampInverter_noptap_0.out user_project_wrapper_0.VDD2 user_project_wrapper_0.IOVSS1 sg13_hv_nmos ad=1.408p pd=5.04u as=2.596p ps=5.58u w=4.4u l=0.6u
X4854 user_project_wrapper_0.IOVSS1 user_project_wrapper_0.sg13g2_IOPadIOVdd_1.sg13g2_Clamp_N43N43D4R_0.gate user_project_wrapper_0.IOVDD1 user_project_wrapper_0.IOVSS1 sg13_hv_nmos ad=1.408p pd=5.04u as=2.596p ps=5.58u w=4.4u l=0.6u
X4855 a_91090_129425# a_86507_127725# a_91090_129060# user_project_wrapper_0.IOVSS1 sg13_lv_nmos ad=0.2516p pd=2.16u as=0.1406p ps=1.12u w=0.74u l=0.13u
X4856 a_309917_194695# a_309516_194555# VDD3 VDD3 sg13_lv_pmos ad=0.19p pd=1.38u as=0.34p ps=2.68u w=1u l=0.7u
X4857 user_project_wrapper_0.IOVSS1 user_project_wrapper_0.sg13g2_IOPadVdd_3.sg13g2_RCClampInverter_noptap_0.out user_project_wrapper_0.IOVSS1 user_project_wrapper_0.IOVSS1 sg13_hv_nmos ad=2.596p pd=5.58u as=0 ps=0 w=4.4u l=0.6u
X4858 user_project_wrapper_0.IOVDD2 a_176644_41476# user_project_wrapper_0.analog_io[12] user_project_wrapper_0.IOVDD2 sg13_hv_pmos ad=2.1312p pd=7.3u as=3.9294p ps=7.84u w=6.66u l=0.6u
X4859 VDD3 a_309516_194555# a_309917_199879# VDD3 sg13_lv_pmos ad=0.19p pd=1.38u as=0.19p ps=1.38u w=1u l=0.7u
X4860 user_project_wrapper_0.IOVSS1 analog_io[26] dantenna l=27.78u w=1.26u
X4861 user_project_wrapper_0.sg13g2_IOPadIOVdd_2.sg13g2_Clamp_N43N43D4R_0.gate user_project_wrapper_0.sg13g2_IOPadIOVdd_2.sg13g2_RCClampResistor_0.p2 user_project_wrapper_0.IOVDD4 user_project_wrapper_0.IOVDD4 sg13_hv_pmos ad=1.33p pd=7.38u as=2.38p ps=14.68u w=7u l=0.5u
X4862 user_project_wrapper_0.IOVSS1 a_187018_328627# a_186202_326221# user_project_wrapper_0.IOVSS1 sg13_lv_nmos ad=1.632p pd=10.28u as=0.912p ps=5.18u w=4.8u l=0.13u
X4863 VDD3 a_309516_194555# a_309917_194695# VDD3 sg13_lv_pmos ad=0.19p pd=1.38u as=0.19p ps=1.38u w=1u l=0.7u
X4864 IOVDD3 user_project_wrapper_0.sg13g2_IOPadIOVdd_3.sg13g2_Clamp_N43N43D4R_0.gate user_project_wrapper_0.IOVSS1 user_project_wrapper_0.IOVSS1 sg13_hv_nmos ad=2.596p pd=5.58u as=1.408p ps=5.04u w=4.4u l=0.6u
X4865 a_190824_327491# a_190501_327491# a_190722_328013# w_188704_327938# sg13_lv_pmos ad=0.38p pd=2.38u as=0.38p ps=2.38u w=2u l=0.13u
X4866 analog_io[18] a_369296_115444# user_project_wrapper_0.IOVSS1 user_project_wrapper_0.IOVSS1 sg13_hv_nmos ad=2.596p pd=5.58u as=1.408p ps=5.04u w=4.4u l=0.6u
X4867 a_83492_127455# a_83164_127820# user_project_wrapper_0.VDD1 user_project_wrapper_0.VDD1 sg13_lv_pmos ad=0.2128p pd=1.5u as=0.3808p ps=2.92u w=1.12u l=0.13u
X4868 user_project_wrapper_0.analog_io[32] a_202114_326125# user_project_wrapper_0.IOVSS1 user_project_wrapper_0.IOVSS1 sg13_lv_nmos ad=0.912p pd=5.18u as=0.912p ps=5.18u w=4.8u l=0.13u
X4869 a_197044_29676# user_project_wrapper_0.IOVSS1 user_project_wrapper_0.IOVSS1 rppd l=3.54u w=0.5u
X4870 a_78824_137391# user_project_wrapper_0.sg13g2_IOPadAnalog_8.padres user_project_wrapper_0.IOVSS1 user_project_wrapper_0.IOVSS1 sg13_lv_nmos ad=0.17p pd=1.68u as=0.17p ps=1.68u w=0.5u l=0.15u
X4871 user_project_wrapper_0.analog_io[27] a_115444_355624# user_project_wrapper_0.IOVDD4 user_project_wrapper_0.IOVDD4 sg13_hv_pmos ad=3.9294p pd=7.84u as=2.1312p ps=7.3u w=6.66u l=0.6u
X4872 user_project_wrapper_0.IOVSS1 a_135844_369296# user_project_wrapper_0.analog_io[28] user_project_wrapper_0.IOVSS1 sg13_hv_nmos ad=1.408p pd=5.04u as=2.596p ps=5.58u w=4.4u l=0.6u
X4873 a_309917_194695# a_309516_194555# VDD3 VDD3 sg13_lv_pmos ad=0.19p pd=1.38u as=0.19p ps=1.38u w=1u l=0.7u
X4874 a_307232_196607# a_296731_208493# a_309917_199879# VDD3 sg13_lv_pmos ad=0.24415p pd=1.665u as=0.24415p ps=1.665u w=1.285u l=0.35u
X4875 user_project_wrapper_0.IOVSS1 a_213870_324142# user_project_wrapper_0.analog_io[35] user_project_wrapper_0.IOVSS1 sg13_lv_nmos ad=0.912p pd=5.18u as=0.912p ps=5.18u w=4.8u l=0.13u
X4876 user_project_wrapper_0.IOVSS1 user_project_wrapper_0.sg13g2_IOPadVdd_3.sg13g2_RCClampInverter_noptap_0.out user_project_wrapper_0.IOVSS1 user_project_wrapper_0.IOVSS1 sg13_hv_nmos ad=1.408p pd=5.04u as=0 ps=0 w=4.4u l=0.6u
X4877 user_project_wrapper_0.IOVSS1 user_project_wrapper_0.sg13g2_IOPadVdd_3.sg13g2_RCClampInverter_noptap_0.out user_project_wrapper_0.IOVSS1 user_project_wrapper_0.IOVSS1 sg13_hv_nmos ad=1.408p pd=5.04u as=0 ps=0 w=4.4u l=0.6u
X4878 a_296732_197880# a_301940_196388# a_296625_189595# VDD3 sg13_lv_pmos ad=0.7695p pd=4.43u as=0.7695p ps=4.43u w=4.05u l=0.5u
X4879 a_296625_189595# a_304090_197941# a_304196_197873# user_project_wrapper_0.IOVSS1 sg13_lv_nmos ad=0.361p pd=2.28u as=0.646p ps=4.48u w=1.9u l=0.16u
X4880 user_project_wrapper_0.IOVSS1 a_258244_29676# user_project_wrapper_0.analog_io[16] user_project_wrapper_0.IOVSS1 sg13_hv_nmos ad=1.408p pd=5.04u as=2.596p ps=5.58u w=4.4u l=0.6u
X4881 a_79038_137002# user_project_wrapper_0.sg13g2_IOPadAnalog_9.padres a_79025_137844# user_project_wrapper_0.VDD1 sg13_lv_pmos ad=0.95p pd=5.38u as=1.7p ps=10.68u w=5u l=0.3u
X4882 user_project_wrapper_0.analog_io[34] a_258244_369296# user_project_wrapper_0.IOVSS1 user_project_wrapper_0.IOVSS1 sg13_hv_nmos ad=2.596p pd=5.58u as=1.408p ps=5.04u w=4.4u l=0.6u
X4883 user_project_wrapper_0.IOVSS1 user_project_wrapper_0.IOVDD2 dpantenna l=27.78u w=1.26u
X4884 IOVDD3 user_project_wrapper_0.sg13g2_IOPadIOVdd_3.sg13g2_Clamp_N43N43D4R_0.gate user_project_wrapper_0.IOVSS1 user_project_wrapper_0.IOVSS1 sg13_hv_nmos ad=2.596p pd=5.58u as=1.408p ps=5.04u w=4.4u l=0.6u
X4885 user_project_wrapper_0.VDD2 user_project_wrapper_0.sg13g2_IOPadVdd_1.sg13g2_RCClampInverter_noptap_0.out user_project_wrapper_0.IOVSS1 user_project_wrapper_0.IOVSS1 sg13_hv_nmos ad=2.596p pd=5.58u as=1.408p ps=5.04u w=4.4u l=0.6u
X4886 user_project_wrapper_0.IOVDD2 user_project_wrapper_0.sg13g2_IOPadIOVdd_0.sg13g2_Clamp_N43N43D4R_0.gate user_project_wrapper_0.IOVSS1 user_project_wrapper_0.IOVSS1 sg13_hv_nmos ad=2.596p pd=5.58u as=1.408p ps=5.04u w=4.4u l=0.6u
X4887 user_project_wrapper_0.IOVSS1 a_369296_135844# analog_io[19] user_project_wrapper_0.IOVSS1 sg13_hv_nmos ad=1.408p pd=5.04u as=2.596p ps=5.58u w=4.4u l=0.6u
X4888 a_79038_134832# a_79038_134366# user_project_wrapper_0.IOVSS1 user_project_wrapper_0.IOVSS1 sg13_lv_nmos ad=0.1428p pd=1.52u as=0.1428p ps=1.52u w=0.42u l=0.56u
X4889 analog_io[22] a_369296_197044# user_project_wrapper_0.IOVSS1 user_project_wrapper_0.IOVSS1 sg13_hv_nmos ad=2.596p pd=5.58u as=1.408p ps=5.04u w=4.4u l=0.6u
X4890 user_project_wrapper_0.IOVSS1 user_project_wrapper_0.sg13g2_IOPadVdd_1.sg13g2_RCClampInverter_noptap_0.out user_project_wrapper_0.VDD2 user_project_wrapper_0.IOVSS1 sg13_hv_nmos ad=1.408p pd=5.04u as=2.596p ps=5.58u w=4.4u l=0.6u
X4891 user_project_wrapper_0.IOVSS1 user_project_wrapper_0.sg13g2_IOPadIOVdd_3.sg13g2_Clamp_N43N43D4R_0.gate IOVDD3 user_project_wrapper_0.IOVSS1 sg13_hv_nmos ad=1.408p pd=5.04u as=2.596p ps=5.58u w=4.4u l=0.6u
X4892 user_project_wrapper_0.analog_io[10] a_135844_41476# user_project_wrapper_0.IOVDD2 user_project_wrapper_0.IOVDD2 sg13_hv_pmos ad=3.9294p pd=7.84u as=2.1312p ps=7.3u w=6.66u l=0.6u
X4893 user_project_wrapper_0.IOVSS1 user_project_wrapper_0.sg13g2_IOPadIOVdd_3.sg13g2_Clamp_N43N43D4R_0.gate IOVDD3 user_project_wrapper_0.IOVSS1 sg13_hv_nmos ad=1.408p pd=5.04u as=2.596p ps=5.58u w=4.4u l=0.6u
X4894 analog_io[18] a_355624_115444# IOVDD3 IOVDD3 sg13_hv_pmos ad=3.9294p pd=7.84u as=2.1312p ps=7.3u w=6.66u l=0.6u
X4895 user_project_wrapper_0.IOVSS1 a_176644_369296# user_project_wrapper_0.analog_io[30] user_project_wrapper_0.IOVSS1 sg13_hv_nmos ad=1.408p pd=5.04u as=2.596p ps=5.58u w=4.4u l=0.6u
X4896 a_309917_194695# a_309516_194555# VDD3 VDD3 sg13_lv_pmos ad=0.19p pd=1.38u as=0.19p ps=1.38u w=1u l=0.7u
X4897 user_project_wrapper_0.IOVSS1 user_project_wrapper_0.sg13g2_IOPadVdd_1.sg13g2_RCClampInverter_noptap_0.out user_project_wrapper_0.VDD2 user_project_wrapper_0.IOVSS1 sg13_hv_nmos ad=1.408p pd=5.04u as=2.596p ps=5.58u w=4.4u l=0.6u
X4898 user_project_wrapper_0.IOVDD2 user_project_wrapper_0.sg13g2_IOPadIOVdd_0.sg13g2_RCClampResistor_0.p2 user_project_wrapper_0.sg13g2_IOPadIOVdd_0.sg13g2_Clamp_N43N43D4R_0.gate user_project_wrapper_0.IOVDD2 sg13_hv_pmos ad=1.33p pd=7.38u as=1.33p ps=7.38u w=7u l=0.5u
X4899 user_project_wrapper_0.IOVSS1 a_190389_99046# user_project_wrapper_0.analog_io[14] user_project_wrapper_0.IOVSS1 sg13_lv_nmos ad=0.1406p pd=1.12u as=0.1406p ps=1.12u w=0.74u l=0.13u
X4900 user_project_wrapper_0.IOVDD2 a_176644_41476# user_project_wrapper_0.analog_io[12] user_project_wrapper_0.IOVDD2 sg13_hv_pmos ad=2.1312p pd=7.3u as=3.9294p ps=7.84u w=6.66u l=0.6u
X4901 user_project_wrapper_0.analog_io[30] a_194687_324142# user_project_wrapper_0.IOVSS1 user_project_wrapper_0.IOVSS1 sg13_lv_nmos ad=0.912p pd=5.18u as=0.912p ps=5.18u w=4.8u l=0.13u
X4902 VDD3 user_project_wrapper_0.sg13g2_IOPadVdd_0.sg13g2_RCClampResistor_0.p2 user_project_wrapper_0.sg13g2_IOPadVdd_0.sg13g2_RCClampInverter_noptap_0.out VDD3 sg13_hv_pmos ad=1.33p pd=7.38u as=1.33p ps=7.38u w=7u l=0.5u
X4903 analog_io[23] IOVDD3 dpantenna l=27.78u w=1.26u
X4904 a_85052_125418# a_85875_125209# user_project_wrapper_0.IOVSS1 user_project_wrapper_0.IOVSS1 sg13_lv_nmos ad=0.2516p pd=2.16u as=0.2516p ps=2.16u w=0.74u l=0.13u
X4905 analog_io[23] a_355624_217444# IOVDD3 IOVDD3 sg13_hv_pmos ad=3.9294p pd=7.84u as=2.1312p ps=7.3u w=6.66u l=0.6u
X4906 user_project_wrapper_0.IOVDD1 a_41476_197044# user_project_wrapper_0.analog_io[4] user_project_wrapper_0.IOVDD1 sg13_hv_pmos ad=2.1312p pd=7.3u as=3.9294p ps=7.84u w=6.66u l=0.6u
X4907 user_project_wrapper_0.analog_io[7] a_41476_258244# user_project_wrapper_0.IOVDD1 user_project_wrapper_0.IOVDD1 sg13_hv_pmos ad=3.9294p pd=7.84u as=2.1312p ps=7.3u w=6.66u l=0.6u
X4908 a_296731_208493# a_296625_208423# VDD3 VDD3 sg13_lv_pmos ad=0.2603p pd=1.75u as=0.2603p ps=1.75u w=1.37u l=0.35u
X4909 user_project_wrapper_0.analog_io[32] a_202114_326125# user_project_wrapper_0.IOVSS1 user_project_wrapper_0.IOVSS1 sg13_lv_nmos ad=0.912p pd=5.18u as=0.912p ps=5.18u w=4.8u l=0.13u
X4910 analog_io[20] a_311108_179669# VDD3 user_project_wrapper_0.IOVSS1 sg13_lv_nmos ad=3.4p pd=20.68u as=3.4p ps=20.68u w=10u l=0.15u
X4911 a_302395_364458# a_302065_360372# user_project_wrapper_0.IOVSS1 rppd l=20u w=1u
X4912 user_project_wrapper_0.IOVDD2 a_135844_41476# user_project_wrapper_0.analog_io[10] user_project_wrapper_0.IOVDD2 sg13_hv_pmos ad=2.1312p pd=7.3u as=3.9294p ps=7.84u w=6.66u l=0.6u
X4913 user_project_wrapper_0.VDD1 user_project_wrapper_0.sg13g2_IOPadVdd_2.sg13g2_RCClampResistor_0.p2 user_project_wrapper_0.sg13g2_IOPadVdd_2.sg13g2_RCClampInverter_noptap_0.out user_project_wrapper_0.VDD1 sg13_hv_pmos ad=1.33p pd=7.38u as=1.33p ps=7.38u w=7u l=0.5u
X4914 user_project_wrapper_0.IOVSS1 user_project_wrapper_0.sg13g2_IOPadIOVdd_0.sg13g2_Clamp_N43N43D4R_0.gate user_project_wrapper_0.IOVDD2 user_project_wrapper_0.IOVSS1 sg13_hv_nmos ad=1.408p pd=5.04u as=2.596p ps=5.58u w=4.4u l=0.6u
X4915 user_project_wrapper_0.IOVSS1 a_186202_326221# a_182931_326125# user_project_wrapper_0.IOVSS1 sg13_lv_pmos ad=1.824p pd=9.98u as=1.824p ps=9.98u w=9.6u l=0.13u
X4916 user_project_wrapper_0.IOVSS1 user_project_wrapper_0.sg13g2_IOPadIOVdd_0.sg13g2_Clamp_N43N43D4R_0.gate user_project_wrapper_0.IOVDD2 user_project_wrapper_0.IOVSS1 sg13_hv_nmos ad=1.408p pd=5.04u as=2.596p ps=5.58u w=4.4u l=0.6u
X4917 user_project_wrapper_0.IOVSS1 user_project_wrapper_0.sg13g2_IOPadVdd_1.sg13g2_RCClampResistor_0.p2 user_project_wrapper_0.IOVSS1 user_project_wrapper_0.IOVSS1 sg13_hv_nmos ad=1.71p pd=9.38u as=0 ps=0 w=9u l=9.5u
X4918 a_309917_199879# a_309516_194555# VDD3 VDD3 sg13_lv_pmos ad=0.19p pd=1.38u as=0.19p ps=1.38u w=1u l=0.7u
X4919 user_project_wrapper_0.IOVSS1 user_project_wrapper_0.sg13g2_IOPadVdd_3.sg13g2_RCClampInverter_noptap_0.out user_project_wrapper_0.IOVSS1 user_project_wrapper_0.IOVSS1 sg13_hv_nmos ad=2.596p pd=5.58u as=0 ps=0 w=4.4u l=0.6u
X4920 analog_io[26] a_355624_278644# IOVDD3 IOVDD3 sg13_hv_pmos ad=3.9294p pd=7.84u as=2.1312p ps=7.3u w=6.66u l=0.6u
X4921 user_project_wrapper_0.IOVDD2 a_176644_41476# user_project_wrapper_0.analog_io[12] user_project_wrapper_0.IOVDD2 sg13_hv_pmos ad=2.1312p pd=7.3u as=3.9294p ps=7.84u w=6.66u l=0.6u
X4922 user_project_wrapper_0.analog_io[34] a_258244_355624# user_project_wrapper_0.IOVDD4 user_project_wrapper_0.IOVDD4 sg13_hv_pmos ad=3.9294p pd=7.84u as=2.1312p ps=7.3u w=6.66u l=0.6u
X4923 user_project_wrapper_0.VDD2 user_project_wrapper_0.sg13g2_IOPadVdd_1.sg13g2_RCClampInverter_noptap_0.out user_project_wrapper_0.IOVSS1 user_project_wrapper_0.IOVSS1 sg13_hv_nmos ad=2.596p pd=5.58u as=1.408p ps=5.04u w=4.4u l=0.6u
X4924 a_304196_200821# a_304889_199957# a_304995_198817# user_project_wrapper_0.IOVSS1 sg13_lv_nmos ad=0.209p pd=1.48u as=0.209p ps=1.48u w=1.1u l=0.15u
X4925 a_296731_189665# a_296625_189595# VDD3 VDD3 sg13_lv_pmos ad=0.2603p pd=1.75u as=0.2603p ps=1.75u w=1.37u l=0.35u
X4926 a_189286_325785# a_189184_326377# a_189184_325263# w_188704_326203# sg13_lv_pmos ad=0.38p pd=2.38u as=0.38p ps=2.38u w=2u l=0.13u
X4927 user_project_wrapper_0.analog_io[35] a_213870_324142# user_project_wrapper_0.IOVSS1 user_project_wrapper_0.IOVSS1 sg13_lv_nmos ad=0.912p pd=5.18u as=0.912p ps=5.18u w=4.8u l=0.13u
X4928 user_project_wrapper_0.IOVSS1 user_project_wrapper_0.ui_PAD[9] dantenna l=27.78u w=1.26u
X4929 user_project_wrapper_0.IOVSS1 a_156244_29676# user_project_wrapper_0.analog_io[11] user_project_wrapper_0.IOVSS1 sg13_hv_nmos ad=2.068p pd=9.74u as=2.596p ps=5.58u w=4.4u l=0.6u
X4930 user_project_wrapper_0.IOVSS1 user_project_wrapper_0.sg13g2_IOPadVdd_3.sg13g2_RCClampResistor_0.p2 user_project_wrapper_0.sg13g2_IOPadVdd_3.sg13g2_RCClampInverter_noptap_0.out user_project_wrapper_0.IOVSS1 sg13_hv_pmos ad=1.33p pd=7.38u as=1.33p ps=7.38u w=7u l=0.5u
X4931 user_project_wrapper_0.IOVDD4 a_176644_355624# user_project_wrapper_0.analog_io[30] user_project_wrapper_0.IOVDD4 sg13_hv_pmos ad=2.1312p pd=7.3u as=3.9294p ps=7.84u w=6.66u l=0.6u
X4932 user_project_wrapper_0.IOVSS1 a_182931_326125# user_project_wrapper_0.analog_io[27] user_project_wrapper_0.IOVSS1 sg13_lv_nmos ad=0.912p pd=5.18u as=0.912p ps=5.18u w=4.8u l=0.13u
X4933 VDD3 user_project_wrapper_0.sg13g2_IOPadVdd_0.sg13g2_RCClampInverter_noptap_0.out user_project_wrapper_0.IOVSS1 user_project_wrapper_0.IOVSS1 sg13_hv_nmos ad=2.596p pd=5.58u as=1.408p ps=5.04u w=4.4u l=0.6u
X4934 user_project_wrapper_0.IOVDD4 a_278644_355624# user_project_wrapper_0.analog_io[35] user_project_wrapper_0.IOVDD4 sg13_hv_pmos ad=2.1312p pd=7.3u as=3.9294p ps=7.84u w=6.66u l=0.6u
X4935 a_296731_189665# a_301186_192011# user_project_wrapper_0.IOVSS1 user_project_wrapper_0.IOVSS1 sg13_lv_nmos ad=0.912p pd=5.18u as=0.912p ps=5.18u w=4.8u l=1.06u
X4936 QDLL_TOP_0.VDD a_271172_100118# QDLL_TOP_0.VOUT QDLL_TOP_0.VDD sg13_lv_pmos ad=0.2128p pd=1.5u as=0.2128p ps=1.5u w=1.12u l=0.13u
X4937 analog_io[18] a_369296_115444# user_project_wrapper_0.IOVSS1 user_project_wrapper_0.IOVSS1 sg13_hv_nmos ad=2.596p pd=5.58u as=1.408p ps=5.04u w=4.4u l=0.6u
X4938 user_project_wrapper_0.analog_io[7] a_41476_258244# user_project_wrapper_0.IOVDD1 user_project_wrapper_0.IOVDD1 sg13_hv_pmos ad=3.9294p pd=7.84u as=2.1312p ps=7.3u w=6.66u l=0.6u
X4939 user_project_wrapper_0.VDD2 user_project_wrapper_0.sg13g2_IOPadVdd_1.sg13g2_RCClampInverter_noptap_0.out user_project_wrapper_0.IOVSS1 user_project_wrapper_0.IOVSS1 sg13_hv_nmos ad=2.596p pd=5.58u as=1.408p ps=5.04u w=4.4u l=0.6u
X4940 a_79038_126152# a_79038_125686# user_project_wrapper_0.IOVSS1 user_project_wrapper_0.IOVSS1 sg13_lv_nmos ad=0.1428p pd=1.52u as=0.1428p ps=1.52u w=0.42u l=0.56u
X4941 user_project_wrapper_0.IOVDD1 a_41476_197044# user_project_wrapper_0.analog_io[4] user_project_wrapper_0.IOVDD1 sg13_hv_pmos ad=2.1312p pd=7.3u as=3.9294p ps=7.84u w=6.66u l=0.6u
X4942 user_project_wrapper_0.IOVSS1 user_project_wrapper_0.IOVSS1 user_project_wrapper_0.IOVSS1 rppd l=0.5u w=0.5u
X4943 user_project_wrapper_0.VDD1 a_79025_125231# a_83070_130577# user_project_wrapper_0.VDD1 sg13_lv_pmos ad=0.3808p pd=2.92u as=0.2128p ps=1.5u w=1.12u l=0.13u
X4944 user_project_wrapper_0.IOVSS1 user_project_wrapper_0.sg13g2_IOPadOut4mA$1_0.c2p a_58170_179951# user_project_wrapper_0.IOVSS1 sg13_hv_nmos ad=0.361p pd=2.28u as=0.646p ps=4.48u w=1.9u l=0.45u
X4945 user_project_wrapper_0.IOVSS1 user_project_wrapper_0.sg13g2_IOPadIOVdd_3.sg13g2_Clamp_N43N43D4R_0.gate IOVDD3 user_project_wrapper_0.IOVSS1 sg13_hv_nmos ad=1.408p pd=5.04u as=2.596p ps=5.58u w=4.4u l=0.6u
X4946 user_project_wrapper_0.IOVSS1 a_307232_196607# a_307232_196607# user_project_wrapper_0.IOVSS1 sg13_lv_nmos ad=0.6327p pd=3.71u as=0.6327p ps=3.71u w=3.33u l=0.2u
X4947 analog_io[26] a_355624_278644# IOVDD3 IOVDD3 sg13_hv_pmos ad=3.9294p pd=7.84u as=2.1312p ps=7.3u w=6.66u l=0.6u
X4948 a_92512_129426# a_89953_129061# user_project_wrapper_0.VDD1 user_project_wrapper_0.VDD1 sg13_lv_pmos ad=0.2128p pd=1.5u as=0.3808p ps=2.92u w=1.12u l=0.13u
X4949 user_project_wrapper_0.IOVSS1 a_191234_328605# a_191438_328605# user_project_wrapper_0.IOVSS1 sg13_lv_nmos ad=0.19p pd=1.38u as=0.19p ps=1.38u w=1u l=0.13u
X4950 user_project_wrapper_0.IOVDD1 a_41476_217444# user_project_wrapper_0.analog_io[5] user_project_wrapper_0.IOVDD1 sg13_hv_pmos ad=2.1312p pd=7.3u as=3.9294p ps=7.84u w=6.66u l=0.6u
X4951 user_project_wrapper_0.IOVDD1 a_41476_237844# user_project_wrapper_0.analog_io[6] user_project_wrapper_0.IOVDD1 sg13_hv_pmos ad=2.1312p pd=7.3u as=3.9294p ps=7.84u w=6.66u l=0.6u
X4952 user_project_wrapper_0.IOVSS1 user_project_wrapper_0.sg13g2_IOPadVdd_1.sg13g2_RCClampResistor_0.p2 user_project_wrapper_0.IOVSS1 user_project_wrapper_0.IOVSS1 sg13_hv_nmos ad=1.71p pd=9.38u as=0 ps=0 w=9u l=9.5u
X4953 user_project_wrapper_0.IOVSS1 user_project_wrapper_0.sg13g2_IOPadVdd_3.sg13g2_RCClampInverter_noptap_0.out user_project_wrapper_0.IOVSS1 user_project_wrapper_0.IOVSS1 sg13_hv_nmos ad=1.408p pd=5.04u as=0 ps=0 w=4.4u l=0.6u
X4954 user_project_wrapper_0.IOVSS1 user_project_wrapper_0.IOVSS1 dantenna l=27.78u w=1.26u
X4955 analog_io[19] a_355624_135844# IOVDD3 IOVDD3 sg13_hv_pmos ad=3.9294p pd=7.84u as=2.1312p ps=7.3u w=6.66u l=0.6u
X4956 user_project_wrapper_0.analog_io[11] a_156244_41476# user_project_wrapper_0.IOVDD2 user_project_wrapper_0.IOVDD2 sg13_hv_pmos ad=3.9294p pd=7.84u as=2.1312p ps=7.3u w=6.66u l=0.6u
X4957 VDD3 user_project_wrapper_0.sg13g2_IOPadVdd_0.sg13g2_RCClampResistor_0.p2 user_project_wrapper_0.sg13g2_IOPadVdd_0.sg13g2_RCClampInverter_noptap_0.out VDD3 sg13_hv_pmos ad=1.33p pd=7.38u as=1.33p ps=7.38u w=7u l=0.5u
X4958 user_project_wrapper_0.IOVSS1 a_369296_278644# analog_io[26] user_project_wrapper_0.IOVSS1 sg13_hv_nmos ad=1.408p pd=5.04u as=2.596p ps=5.58u w=4.4u l=0.6u
X4959 VDD3 a_364458_73375# user_project_wrapper_0.IOVSS1 rppd l=20u w=1u
X4960 a_213870_324142# a_213462_327536# user_project_wrapper_0.IOVSS1 user_project_wrapper_0.IOVSS1 sg13_lv_pmos ad=1.824p pd=9.98u as=1.824p ps=9.98u w=9.6u l=0.13u
X4961 IOVDD3 a_355624_197044# analog_io[22] IOVDD3 sg13_hv_pmos ad=2.1312p pd=7.3u as=3.9294p ps=7.84u w=6.66u l=0.6u
X4962 VDD3 a_296625_189595# a_296731_189665# VDD3 sg13_lv_pmos ad=0.2603p pd=1.75u as=0.2603p ps=1.75u w=1.37u l=0.35u
X4963 a_315347_192648# a_314793_201808# a_314697_196700# user_project_wrapper_0.IOVSS1 sg13_lv_nmos ad=1.14p pd=6.38u as=2.04p ps=12.68u w=6u l=6.4u
X4964 user_project_wrapper_0.IOVSS1 user_project_wrapper_0.sg13g2_IOPadAnalog_7.padres dantenna l=3.1u w=0.64u
X4965 VDD3 a_309516_194555# a_309917_199879# VDD3 sg13_lv_pmos ad=0.34p pd=2.68u as=0.19p ps=1.38u w=1u l=0.7u
X4966 user_project_wrapper_0.analog_io[13] a_197044_29676# user_project_wrapper_0.IOVSS1 user_project_wrapper_0.IOVSS1 sg13_hv_nmos ad=2.596p pd=5.58u as=1.408p ps=5.04u w=4.4u l=0.6u
X4967 user_project_wrapper_0.IOVDD4 user_project_wrapper_0.sg13g2_IOPadIOVdd_2.sg13g2_Clamp_N43N43D4R_0.gate user_project_wrapper_0.IOVSS1 user_project_wrapper_0.IOVSS1 sg13_hv_nmos ad=2.596p pd=5.58u as=1.408p ps=5.04u w=4.4u l=0.6u
X4968 a_309917_194695# a_309516_194555# VDD3 VDD3 sg13_lv_pmos ad=0.19p pd=1.38u as=0.19p ps=1.38u w=1u l=0.7u
X4969 VDD3 user_project_wrapper_0.sg13g2_IOPadVdd_0.sg13g2_RCClampInverter_noptap_0.out user_project_wrapper_0.IOVSS1 user_project_wrapper_0.IOVSS1 sg13_hv_nmos ad=2.596p pd=5.58u as=1.408p ps=5.04u w=4.4u l=0.6u
X4970 user_project_wrapper_0.IOVDD2 a_176644_41476# user_project_wrapper_0.analog_io[12] user_project_wrapper_0.IOVDD2 sg13_hv_pmos ad=2.1312p pd=7.3u as=3.9294p ps=7.84u w=6.66u l=0.6u
X4971 VDD3 a_296625_189595# a_296731_189665# VDD3 sg13_lv_pmos ad=0.2603p pd=1.75u as=0.2603p ps=1.75u w=1.37u l=0.35u
X4972 user_project_wrapper_0.analog_io[30] a_194687_324142# user_project_wrapper_0.IOVSS1 user_project_wrapper_0.IOVSS1 sg13_lv_pmos ad=1.824p pd=9.98u as=1.824p ps=9.98u w=9.6u l=0.13u
X4973 a_35456_76675# a_39542_77005# user_project_wrapper_0.IOVSS1 rppd l=20u w=1u
X4974 user_project_wrapper_0.analog_io[5] a_41476_217444# user_project_wrapper_0.IOVDD1 user_project_wrapper_0.IOVDD1 sg13_hv_pmos ad=3.9294p pd=7.84u as=2.1312p ps=7.3u w=6.66u l=0.6u
X4975 user_project_wrapper_0.analog_io[27] a_182931_326125# user_project_wrapper_0.IOVSS1 user_project_wrapper_0.IOVSS1 sg13_lv_nmos ad=0.912p pd=5.18u as=0.912p ps=5.18u w=4.8u l=0.13u
X4976 user_project_wrapper_0.VDD2 user_project_wrapper_0.sg13g2_IOPadVdd_1.sg13g2_RCClampInverter_noptap_0.out user_project_wrapper_0.IOVSS1 user_project_wrapper_0.IOVSS1 sg13_hv_nmos ad=2.596p pd=5.58u as=1.408p ps=5.04u w=4.4u l=0.6u
X4977 IOVDD3 a_355624_156244# analog_io[20] IOVDD3 sg13_hv_pmos ad=2.1312p pd=7.3u as=3.9294p ps=7.84u w=6.66u l=0.6u
X4978 analog_io[23] a_355624_217444# IOVDD3 IOVDD3 sg13_hv_pmos ad=3.9294p pd=7.84u as=2.1312p ps=7.3u w=6.66u l=0.6u
X4979 a_77638_59490# user_project_wrapper_0.sg13g2_IOPadIn$1_1.sg13g2_LevelDown_noptap$1_0.sg13g2_SecondaryProtection$1$1_0.core user_project_wrapper_0.IOVSS1 user_project_wrapper_0.IOVSS1 sg13_hv_nmos ad=0.901p pd=5.98u as=0.901p ps=5.98u w=2.65u l=0.45u
X4980 VDD3 a_296625_208423# a_296731_208493# VDD3 sg13_lv_pmos ad=0.2603p pd=1.75u as=0.2603p ps=1.75u w=1.37u l=0.35u
X4981 IOVDD3 user_project_wrapper_0.sg13g2_IOPadIOVdd_3.sg13g2_Clamp_N43N43D4R_0.gate user_project_wrapper_0.IOVSS1 user_project_wrapper_0.IOVSS1 sg13_hv_nmos ad=2.596p pd=5.58u as=1.408p ps=5.04u w=4.4u l=0.6u
X4982 IOVDD3 user_project_wrapper_0.sg13g2_IOPadIOVdd_3.sg13g2_Clamp_N43N43D4R_0.gate user_project_wrapper_0.IOVSS1 user_project_wrapper_0.IOVSS1 sg13_hv_nmos ad=2.596p pd=5.58u as=1.408p ps=5.04u w=4.4u l=0.6u
X4983 a_78824_130881# user_project_wrapper_0.sg13g2_IOPadAnalog_8.padres user_project_wrapper_0.IOVSS1 user_project_wrapper_0.IOVSS1 sg13_lv_nmos ad=0.17p pd=1.68u as=0.17p ps=1.68u w=0.5u l=0.15u
X4984 VDD3 a_296625_208423# a_296731_208493# VDD3 sg13_lv_pmos ad=0.2603p pd=1.75u as=0.2603p ps=1.75u w=1.37u l=0.35u
X4985 user_project_wrapper_0.IOVSS1 user_project_wrapper_0.sg13g2_IOPadIOVdd_2.sg13g2_RCClampResistor_0.p2 user_project_wrapper_0.IOVSS1 user_project_wrapper_0.IOVSS1 sg13_hv_nmos ad=1.71p pd=9.38u as=0 ps=0 w=9u l=9.5u
X4986 user_project_wrapper_0.IOVSS1 user_project_wrapper_0.sg13g2_IOPadVdd_0.sg13g2_RCClampInverter_noptap_0.out VDD3 user_project_wrapper_0.IOVSS1 sg13_hv_nmos ad=1.408p pd=5.04u as=2.596p ps=5.58u w=4.4u l=0.6u
X4987 user_project_wrapper_0.IOVSS1 a_187018_328627# a_186202_326221# user_project_wrapper_0.IOVSS1 sg13_lv_nmos ad=0.912p pd=5.18u as=0.912p ps=5.18u w=4.8u l=0.13u
X4988 a_209869_324119# a_209940_324686# user_project_wrapper_0.IOVSS1 w_207989_323975# sg13_lv_pmos ad=0.38p pd=2.38u as=0.38p ps=2.38u w=2u l=0.13u
X4989 user_project_wrapper_0.IOVDD2 user_project_wrapper_0.sg13g2_IOPadIOVdd_0.sg13g2_RCClampResistor_0.p2 user_project_wrapper_0.sg13g2_IOPadIOVdd_0.sg13g2_Clamp_N43N43D4R_0.gate user_project_wrapper_0.IOVDD2 sg13_hv_pmos ad=1.33p pd=7.38u as=1.33p ps=7.38u w=7u l=0.5u
X4990 IOVDD3 a_355624_278644# analog_io[26] IOVDD3 sg13_hv_pmos ad=2.1312p pd=7.3u as=3.9294p ps=7.84u w=6.66u l=0.6u
X4991 user_project_wrapper_0.IOVSS1 user_project_wrapper_0.sg13g2_IOPadVdd_3.sg13g2_RCClampInverter_noptap_0.out user_project_wrapper_0.IOVSS1 user_project_wrapper_0.IOVSS1 sg13_hv_nmos ad=2.596p pd=5.58u as=0 ps=0 w=4.4u l=0.6u
X4992 a_208469_327099# a_208367_327491# a_208367_326377# user_project_wrapper_0.IOVSS1 sg13_lv_nmos ad=0.19p pd=1.38u as=0.19p ps=1.38u w=1u l=0.13u
X4993 user_project_wrapper_0.IOVDD1 user_project_wrapper_0.sg13g2_IOPadIOVdd_1.sg13g2_Clamp_N43N43D4R_0.gate user_project_wrapper_0.IOVSS1 user_project_wrapper_0.IOVSS1 sg13_hv_nmos ad=2.596p pd=5.58u as=1.408p ps=5.04u w=4.4u l=0.6u
X4994 a_213870_324142# a_213462_327536# user_project_wrapper_0.IOVSS1 user_project_wrapper_0.IOVSS1 sg13_lv_pmos ad=1.824p pd=9.98u as=1.824p ps=9.98u w=9.6u l=0.13u
X4995 a_296732_200582# a_296626_197740# VDD3 VDD3 sg13_lv_pmos ad=1.33p pd=7.38u as=1.33p ps=7.38u w=7u l=0.7u
X4996 a_296731_208493# a_301186_192011# user_project_wrapper_0.IOVSS1 user_project_wrapper_0.IOVSS1 sg13_lv_nmos ad=0.912p pd=5.18u as=0.912p ps=5.18u w=4.8u l=1.06u
X4997 VDD3 a_296625_208423# a_296731_208493# VDD3 sg13_lv_pmos ad=0.2603p pd=1.75u as=0.2603p ps=1.75u w=1.37u l=0.35u
X4998 user_project_wrapper_0.IOVSS1 a_258244_369296# user_project_wrapper_0.analog_io[34] user_project_wrapper_0.IOVSS1 sg13_hv_nmos ad=1.408p pd=5.04u as=2.596p ps=5.58u w=4.4u l=0.6u
X4999 a_309917_194695# a_309516_194555# VDD3 VDD3 sg13_lv_pmos ad=0.19p pd=1.38u as=0.19p ps=1.38u w=1u l=0.7u
X5000 user_project_wrapper_0.IOVSS1 user_project_wrapper_0.sg13g2_IOPadVdd_2.sg13g2_RCClampInverter_noptap_0.out user_project_wrapper_0.VDD1 user_project_wrapper_0.IOVSS1 sg13_hv_nmos ad=1.408p pd=5.04u as=2.596p ps=5.58u w=4.4u l=0.6u
X5001 user_project_wrapper_0.analog_io[4] a_41476_197044# user_project_wrapper_0.IOVDD1 user_project_wrapper_0.IOVDD1 sg13_hv_pmos ad=3.9294p pd=7.84u as=2.1312p ps=7.3u w=6.66u l=0.6u
X5002 user_project_wrapper_0.IOVDD1 a_41476_135844# user_project_wrapper_0.analog_io[1] user_project_wrapper_0.IOVDD1 sg13_hv_pmos ad=2.1312p pd=7.3u as=3.9294p ps=7.84u w=6.66u l=0.6u
X5003 user_project_wrapper_0.IOVSS1 user_project_wrapper_0.IOVSS1 user_project_wrapper_0.IOVSS1 rppd l=0.5u w=0.5u
X5004 a_309917_199879# a_309516_194555# VDD3 VDD3 sg13_lv_pmos ad=0.19p pd=1.38u as=0.19p ps=1.38u w=1u l=0.7u
X5005 user_project_wrapper_0.uo_PAD[3] user_project_wrapper_0.IOVDD1 dpantenna l=27.78u w=1.26u
X5006 a_35456_302395# a_39542_302725# user_project_wrapper_0.IOVSS1 rppd l=20u w=1u
X5007 user_project_wrapper_0.analog_io[35] a_213870_324142# user_project_wrapper_0.IOVSS1 user_project_wrapper_0.IOVSS1 sg13_lv_pmos ad=1.824p pd=9.98u as=1.824p ps=9.98u w=9.6u l=0.13u
X5008 user_project_wrapper_0.IOVSS1 a_182931_326125# user_project_wrapper_0.analog_io[27] user_project_wrapper_0.IOVSS1 sg13_lv_pmos ad=1.824p pd=9.98u as=1.824p ps=9.98u w=9.6u l=0.13u
X5009 a_258244_29676# user_project_wrapper_0.IOVSS1 user_project_wrapper_0.IOVSS1 rppd l=3.54u w=0.5u
X5010 a_78824_137391# a_78824_137391# user_project_wrapper_0.VDD1 user_project_wrapper_0.VDD1 sg13_lv_pmos ad=0.95p pd=5.38u as=1.7p ps=10.68u w=5u l=0.15u
X5011 a_35456_79975# a_39542_79645# user_project_wrapper_0.IOVSS1 rppd l=20u w=1u
X5012 a_82872_125209# a_82826_124842# a_82770_125209# user_project_wrapper_0.IOVSS1 sg13_lv_nmos ad=0.1406p pd=1.12u as=0.1406p ps=1.12u w=0.74u l=0.13u
X5013 user_project_wrapper_0.IOVDD1 a_57810_180219# a_58170_179951# user_project_wrapper_0.IOVDD1 sg13_hv_pmos ad=57f pd=0.68u as=0.102p ps=1.28u w=0.3u l=0.45u
X5014 a_296625_208423# a_301940_196388# a_296732_200582# VDD3 sg13_lv_pmos ad=0.7695p pd=4.43u as=1.377p ps=8.78u w=4.05u l=0.5u
X5015 VDD3 user_project_wrapper_0.sg13g2_IOPadVdd_0.sg13g2_RCClampResistor_0.p2 user_project_wrapper_0.sg13g2_IOPadVdd_0.sg13g2_RCClampInverter_noptap_0.out VDD3 sg13_hv_pmos ad=1.33p pd=7.38u as=1.33p ps=7.38u w=7u l=0.5u
X5016 user_project_wrapper_0.IOVSS1 user_project_wrapper_0.sg13g2_IOPadVdd_1.sg13g2_RCClampResistor_0.p2 user_project_wrapper_0.IOVSS1 user_project_wrapper_0.IOVSS1 sg13_hv_nmos ad=1.71p pd=9.38u as=0 ps=0 w=9u l=9.5u
X5017 user_project_wrapper_0.VDD1 user_project_wrapper_0.sg13g2_IOPadVdd_2.sg13g2_RCClampInverter_noptap_0.out user_project_wrapper_0.IOVSS1 user_project_wrapper_0.IOVSS1 sg13_hv_nmos ad=2.596p pd=5.58u as=1.408p ps=5.04u w=4.4u l=0.6u
X5018 user_project_wrapper_0.VDD1 a_78824_128711# a_79025_129164# user_project_wrapper_0.VDD1 sg13_lv_pmos ad=1.7p pd=10.68u as=0.95p ps=5.38u w=5u l=0.15u
X5019 user_project_wrapper_0.analog_io[30] a_176644_355624# user_project_wrapper_0.IOVDD4 user_project_wrapper_0.IOVDD4 sg13_hv_pmos ad=3.9294p pd=7.84u as=2.1312p ps=7.3u w=6.66u l=0.6u
X5020 user_project_wrapper_0.IOVSS1 a_210417_328605# a_210621_328605# user_project_wrapper_0.IOVSS1 sg13_lv_nmos ad=0.19p pd=1.38u as=0.19p ps=1.38u w=1u l=0.13u
X5021 a_309516_194555# a_309516_194555# VDD3 VDD3 sg13_lv_pmos ad=0.19p pd=1.38u as=0.19p ps=1.38u w=1u l=0.7u
X5022 VDD3 a_309516_194555# a_309516_194555# VDD3 sg13_lv_pmos ad=0.19p pd=1.38u as=0.19p ps=1.38u w=1u l=0.7u
X5023 user_project_wrapper_0.IOVSS1 a_213870_324142# user_project_wrapper_0.analog_io[35] user_project_wrapper_0.IOVSS1 sg13_lv_nmos ad=0.912p pd=5.18u as=0.912p ps=5.18u w=4.8u l=0.13u
X5024 user_project_wrapper_0.IOVSS1 a_29676_115444# user_project_wrapper_0.analog_io[0] user_project_wrapper_0.IOVSS1 sg13_hv_nmos ad=1.408p pd=5.04u as=2.596p ps=5.58u w=4.4u l=0.6u
X5025 user_project_wrapper_0.analog_io[27] a_182931_326125# user_project_wrapper_0.IOVSS1 user_project_wrapper_0.IOVSS1 sg13_lv_nmos ad=0.912p pd=5.18u as=0.912p ps=5.18u w=4.8u l=0.13u
X5026 a_188966_92557# a_188408_90472# user_project_wrapper_0.IOVSS1 rppd l=10u w=1u
X5027 VDD3 a_296625_208423# a_296731_208493# VDD3 sg13_lv_pmos ad=0.2603p pd=1.75u as=0.2603p ps=1.75u w=1.37u l=0.35u
X5028 analog_io[20] a_355624_156244# IOVDD3 IOVDD3 sg13_hv_pmos ad=3.9294p pd=7.84u as=2.1312p ps=7.3u w=6.66u l=0.6u
X5029 user_project_wrapper_0.sg13g2_IOPadVdd_1.sg13g2_RCClampResistor_0.p2 a_122095_35456# user_project_wrapper_0.IOVSS1 rppd l=20u w=1u
X5030 VDD3 user_project_wrapper_0.sg13g2_IOPadVdd_0.sg13g2_RCClampResistor_0.p2 user_project_wrapper_0.sg13g2_IOPadVdd_0.sg13g2_RCClampInverter_noptap_0.out VDD3 sg13_hv_pmos ad=1.33p pd=7.38u as=1.33p ps=7.38u w=7u l=0.5u
X5031 user_project_wrapper_0.IOVDD1 a_41476_217444# user_project_wrapper_0.analog_io[5] user_project_wrapper_0.IOVDD1 sg13_hv_pmos ad=2.1312p pd=7.3u as=3.9294p ps=7.84u w=6.66u l=0.6u
X5032 user_project_wrapper_0.IOVDD2 a_278644_41476# QDLL_TOP_0.VOUT user_project_wrapper_0.IOVDD2 sg13_hv_pmos ad=2.1312p pd=7.3u as=3.9294p ps=7.84u w=6.66u l=0.6u
X5033 VDD3 a_309516_194555# a_309917_199879# VDD3 sg13_lv_pmos ad=0.19p pd=1.38u as=0.19p ps=1.38u w=1u l=0.7u
X5034 user_project_wrapper_0.sg13g2_IOPadIOVdd_2.sg13g2_Clamp_N43N43D4R_0.gate user_project_wrapper_0.sg13g2_IOPadIOVdd_2.sg13g2_RCClampResistor_0.p2 user_project_wrapper_0.IOVDD4 user_project_wrapper_0.IOVDD4 sg13_hv_pmos ad=1.33p pd=7.38u as=1.33p ps=7.38u w=7u l=0.5u
X5035 user_project_wrapper_0.analog_io[11] a_156244_41476# user_project_wrapper_0.IOVDD2 user_project_wrapper_0.IOVDD2 sg13_hv_pmos ad=3.9294p pd=7.84u as=2.1312p ps=7.3u w=6.66u l=0.6u
X5036 a_309917_199879# user_project_wrapper_0.sg13g2_IOPadAnalog_29.padres a_311846_195517# VDD3 sg13_lv_pmos ad=0.24415p pd=1.665u as=0.24415p ps=1.665u w=1.285u l=0.35u
X5037 user_project_wrapper_0.IOVSS1 user_project_wrapper_0.IOVSS1 user_project_wrapper_0.IOVSS1 rhigh l=4u w=0.5u
X5038 user_project_wrapper_0.VDD1 user_project_wrapper_0.sg13g2_IOPadVdd_2.sg13g2_RCClampInverter_noptap_0.out user_project_wrapper_0.IOVSS1 user_project_wrapper_0.IOVSS1 sg13_hv_nmos ad=2.596p pd=5.58u as=1.408p ps=5.04u w=4.4u l=0.6u
X5039 user_project_wrapper_0.IOVDD4 user_project_wrapper_0.sg13g2_IOPadIOVdd_2.sg13g2_Clamp_N43N43D4R_0.gate user_project_wrapper_0.IOVSS1 user_project_wrapper_0.IOVSS1 sg13_hv_nmos ad=2.596p pd=5.58u as=1.408p ps=5.04u w=4.4u l=0.6u
X5040 a_311846_195517# user_project_wrapper_0.sg13g2_IOPadAnalog_29.padres a_309917_199879# VDD3 sg13_lv_pmos ad=0.24415p pd=1.665u as=0.24415p ps=1.665u w=1.285u l=0.35u
X5041 VDD3 a_309516_194555# a_309917_199879# VDD3 sg13_lv_pmos ad=0.19p pd=1.38u as=0.19p ps=1.38u w=1u l=0.7u
X5042 user_project_wrapper_0.IOVSS1 a_188834_327918# a_189286_328013# w_188704_327938# sg13_lv_pmos ad=0.68p pd=4.68u as=0.38p ps=2.38u w=2u l=0.13u
X5043 user_project_wrapper_0.analog_io[10] a_135844_29676# user_project_wrapper_0.IOVSS1 user_project_wrapper_0.IOVSS1 sg13_hv_nmos ad=2.596p pd=5.58u as=1.408p ps=5.04u w=4.4u l=0.6u
X5044 user_project_wrapper_0.IOVSS1 user_project_wrapper_0.sg13g2_IOPadVdd_3.sg13g2_RCClampInverter_noptap_0.out user_project_wrapper_0.IOVSS1 user_project_wrapper_0.IOVSS1 sg13_hv_nmos ad=2.596p pd=5.58u as=0 ps=0 w=4.4u l=0.6u
X5045 user_project_wrapper_0.analog_io[29] a_156244_355624# user_project_wrapper_0.IOVDD4 user_project_wrapper_0.IOVDD4 sg13_hv_pmos ad=3.9294p pd=7.84u as=3.1302p ps=14.26u w=6.66u l=0.6u
X5046 a_84288_130212# a_83796_129203# user_project_wrapper_0.IOVSS1 user_project_wrapper_0.IOVSS1 sg13_lv_nmos ad=0.2516p pd=2.16u as=0.2516p ps=2.16u w=0.74u l=0.13u
X5047 a_296731_189665# a_296625_189595# VDD3 VDD3 sg13_lv_pmos ad=0.2603p pd=1.75u as=0.2603p ps=1.75u w=1.37u l=0.35u
X5048 user_project_wrapper_0.analog_io[33] a_237844_369296# user_project_wrapper_0.IOVSS1 user_project_wrapper_0.IOVSS1 sg13_hv_nmos ad=2.596p pd=5.58u as=1.408p ps=5.04u w=4.4u l=0.6u
X5049 user_project_wrapper_0.analog_io[32] a_202114_326125# user_project_wrapper_0.IOVSS1 user_project_wrapper_0.IOVSS1 sg13_lv_nmos ad=0.912p pd=5.18u as=0.912p ps=5.18u w=4.8u l=0.13u
X5050 user_project_wrapper_0.IOVSS1 user_project_wrapper_0.sg13g2_IOPadVdd_1.sg13g2_RCClampResistor_0.p2 user_project_wrapper_0.IOVSS1 user_project_wrapper_0.IOVSS1 sg13_hv_nmos ad=1.71p pd=9.38u as=0 ps=0 w=9u l=9.5u
X5051 user_project_wrapper_0.IOVSS1 user_project_wrapper_0.sg13g2_IOPadVdd_3.sg13g2_RCClampResistor_0.p2 user_project_wrapper_0.sg13g2_IOPadVdd_3.sg13g2_RCClampInverter_noptap_0.out user_project_wrapper_0.IOVSS1 sg13_hv_pmos ad=1.33p pd=7.38u as=1.33p ps=7.38u w=7u l=0.5u
X5052 user_project_wrapper_0.IOVSS1 user_project_wrapper_0.sg13g2_IOPadVdd_1.sg13g2_RCClampInverter_noptap_0.out user_project_wrapper_0.VDD2 user_project_wrapper_0.IOVSS1 sg13_hv_nmos ad=1.408p pd=5.04u as=2.596p ps=5.58u w=4.4u l=0.6u
X5053 user_project_wrapper_0.IOVSS1 user_project_wrapper_0.IOVSS1 user_project_wrapper_0.IOVSS1 rppd l=0.5u w=0.5u
X5054 user_project_wrapper_0.IOVDD4 a_135844_355624# user_project_wrapper_0.analog_io[28] user_project_wrapper_0.IOVDD4 sg13_hv_pmos ad=2.1312p pd=7.3u as=3.9294p ps=7.84u w=6.66u l=0.6u
X5055 QDLL_TOP_0.VDD a_189395_101343# a_189729_101343# QDLL_TOP_0.VDD sg13_lv_pmos ad=0.2128p pd=1.5u as=0.2128p ps=1.5u w=1.12u l=0.13u
X5056 VDD3 a_309516_194555# a_309917_194695# VDD3 sg13_lv_pmos ad=0.19p pd=1.38u as=0.19p ps=1.38u w=1u l=0.7u
X5057 user_project_wrapper_0.sg13g2_IOPadIOVdd_1.sg13g2_Clamp_N43N43D4R_0.gate user_project_wrapper_0.sg13g2_IOPadIOVdd_1.sg13g2_RCClampResistor_0.p2 user_project_wrapper_0.IOVDD1 user_project_wrapper_0.IOVDD1 sg13_hv_pmos ad=1.33p pd=7.38u as=1.33p ps=7.38u w=7u l=0.5u
X5058 user_project_wrapper_0.IOVSS1 user_project_wrapper_0.sg13g2_IOPadVdd_3.sg13g2_RCClampInverter_noptap_0.out user_project_wrapper_0.IOVSS1 user_project_wrapper_0.IOVSS1 sg13_hv_nmos ad=2.596p pd=5.58u as=0 ps=0 w=4.4u l=0.6u
X5059 a_269355_100412# a_269079_100182# QDLL_TOP_0.VDD QDLL_TOP_0.VDD sg13_lv_pmos ad=0.4256p pd=3u as=0.2254p ps=1.53u w=1.12u l=0.13u
X5060 user_project_wrapper_0.IOVSS1 user_project_wrapper_0.IOVSS1 user_project_wrapper_0.IOVSS1 rhigh l=0.96u w=0.5u
X5061 user_project_wrapper_0.IOVDD1 a_41476_217444# user_project_wrapper_0.analog_io[5] user_project_wrapper_0.IOVDD1 sg13_hv_pmos ad=2.1312p pd=7.3u as=3.9294p ps=7.84u w=6.66u l=0.6u
X5062 a_296731_189665# a_296625_189595# VDD3 VDD3 sg13_lv_pmos ad=0.2603p pd=1.75u as=0.2603p ps=1.75u w=1.37u l=0.35u
X5063 user_project_wrapper_0.IOVDD2 a_135844_41476# user_project_wrapper_0.analog_io[10] user_project_wrapper_0.IOVDD2 sg13_hv_pmos ad=2.1312p pd=7.3u as=3.9294p ps=7.84u w=6.66u l=0.6u
X5064 user_project_wrapper_0.analog_io[0] a_29676_115444# user_project_wrapper_0.IOVSS1 user_project_wrapper_0.IOVSS1 sg13_hv_nmos ad=2.596p pd=5.58u as=1.408p ps=5.04u w=4.4u l=0.6u
X5065 IOVDD3 a_355624_156244# analog_io[20] IOVDD3 sg13_hv_pmos ad=2.1312p pd=7.3u as=3.9294p ps=7.84u w=6.66u l=0.6u
X5066 user_project_wrapper_0.analog_io[35] a_278644_369296# user_project_wrapper_0.IOVSS1 user_project_wrapper_0.IOVSS1 sg13_hv_nmos ad=2.596p pd=5.58u as=1.408p ps=5.04u w=4.4u l=0.6u
X5067 a_296731_189665# a_296625_189595# VDD3 VDD3 sg13_lv_pmos ad=0.2603p pd=1.75u as=0.2603p ps=1.75u w=1.37u l=0.35u
X5068 user_project_wrapper_0.IOVSS1 a_182931_326125# user_project_wrapper_0.analog_io[27] user_project_wrapper_0.IOVSS1 sg13_lv_nmos ad=0.912p pd=5.18u as=0.912p ps=5.18u w=4.8u l=0.13u
X5069 user_project_wrapper_0.IOVSS1 user_project_wrapper_0.sg13g2_IOPadVdd_2.sg13g2_RCClampResistor_0.p2 user_project_wrapper_0.IOVSS1 user_project_wrapper_0.IOVSS1 sg13_hv_nmos ad=1.71p pd=9.38u as=0 ps=0 w=9u l=9.5u
X5070 user_project_wrapper_0.IOVSS1 user_project_wrapper_0.sg13g2_IOPadVdd_2.sg13g2_RCClampInverter_noptap_0.out user_project_wrapper_0.VDD1 user_project_wrapper_0.IOVSS1 sg13_hv_nmos ad=1.408p pd=5.04u as=2.596p ps=5.58u w=4.4u l=0.6u
X5071 a_309917_194695# a_296731_189665# a_307232_196607# VDD3 sg13_lv_pmos ad=0.24415p pd=1.665u as=0.24415p ps=1.665u w=1.285u l=0.35u
X5072 a_313884_185173# a_296731_189665# a_311189_185546# user_project_wrapper_0.IOVSS1 sg13_lv_nmos ad=1.9p pd=10.38u as=1.9p ps=10.38u w=10u l=0.5u
X5073 user_project_wrapper_0.IOVSS1 a_135844_369296# user_project_wrapper_0.analog_io[28] user_project_wrapper_0.IOVSS1 sg13_hv_nmos ad=2.068p pd=9.74u as=2.596p ps=5.58u w=4.4u l=0.6u
X5074 VDD3 user_project_wrapper_0.sg13g2_IOPadVdd_0.sg13g2_RCClampResistor_0.p2 user_project_wrapper_0.sg13g2_IOPadVdd_0.sg13g2_RCClampInverter_noptap_0.out VDD3 sg13_hv_pmos ad=1.33p pd=7.38u as=1.33p ps=7.38u w=7u l=0.5u
X5075 user_project_wrapper_0.IOVSS1 a_176644_29676# user_project_wrapper_0.analog_io[12] user_project_wrapper_0.IOVSS1 sg13_hv_nmos ad=1.408p pd=5.04u as=2.596p ps=5.58u w=4.4u l=0.6u
X5076 user_project_wrapper_0.IOVSS1 a_369296_115444# analog_io[18] user_project_wrapper_0.IOVSS1 sg13_hv_nmos ad=1.408p pd=5.04u as=2.596p ps=5.58u w=4.4u l=0.6u
X5077 analog_io[23] a_311108_215937# VDD3 user_project_wrapper_0.IOVSS1 sg13_lv_nmos ad=3.4p pd=20.68u as=3.4p ps=20.68u w=10u l=0.15u
X5078 IOVDD3 a_355624_258244# analog_io[25] IOVDD3 sg13_hv_pmos ad=2.1312p pd=7.3u as=3.9294p ps=7.84u w=6.66u l=0.6u
X5079 user_project_wrapper_0.analog_io[30] a_194687_324142# user_project_wrapper_0.IOVSS1 user_project_wrapper_0.IOVSS1 sg13_lv_nmos ad=0.912p pd=5.18u as=0.912p ps=5.18u w=4.8u l=0.13u
X5080 VDD3 a_309516_194555# a_309917_194695# VDD3 sg13_lv_pmos ad=0.19p pd=1.38u as=0.19p ps=1.38u w=1u l=0.7u
X5081 user_project_wrapper_0.IOVDD1 user_project_wrapper_0.sg13g2_IOPadIOVdd_1.sg13g2_Clamp_N43N43D4R_0.gate user_project_wrapper_0.IOVSS1 user_project_wrapper_0.IOVSS1 sg13_hv_nmos ad=2.596p pd=5.58u as=1.408p ps=5.04u w=4.4u l=0.6u
X5082 user_project_wrapper_0.VDD1 user_project_wrapper_0.sg13g2_IOPadVdd_2.sg13g2_RCClampInverter_noptap_0.out user_project_wrapper_0.IOVSS1 user_project_wrapper_0.IOVSS1 sg13_hv_nmos ad=2.596p pd=5.58u as=1.408p ps=5.04u w=4.4u l=0.6u
X5083 user_project_wrapper_0.IOVSS1 user_project_wrapper_0.sg13g2_IOPadIOVdd_2.sg13g2_RCClampResistor_0.p2 user_project_wrapper_0.IOVSS1 user_project_wrapper_0.IOVSS1 sg13_hv_nmos ad=1.71p pd=9.38u as=0 ps=0 w=9u l=9.5u
X5084 user_project_wrapper_0.IOVDD2 a_278644_41476# QDLL_TOP_0.VOUT user_project_wrapper_0.IOVDD2 sg13_hv_pmos ad=2.1312p pd=7.3u as=3.9294p ps=7.84u w=6.66u l=0.6u
X5085 analog_io[20] a_355624_176644# IOVDD3 IOVDD3 sg13_hv_pmos ad=3.9294p pd=7.84u as=3.1302p ps=14.26u w=6.66u l=0.6u
X5086 a_35456_81295# a_39542_80965# user_project_wrapper_0.IOVSS1 rppd l=20u w=1u
X5087 a_296731_189665# a_296625_189595# VDD3 VDD3 sg13_lv_pmos ad=0.2603p pd=1.75u as=0.4658p ps=3.42u w=1.37u l=0.35u
X5088 a_296625_208423# a_304090_197941# a_304196_200821# user_project_wrapper_0.IOVSS1 sg13_lv_nmos ad=0.361p pd=2.28u as=0.361p ps=2.28u w=1.9u l=0.16u
X5089 a_188572_101637# a_188296_101407# user_project_wrapper_0.IOVSS1 user_project_wrapper_0.IOVSS1 sg13_lv_nmos ad=0.2516p pd=2.16u as=0.1426p ps=1.16u w=0.74u l=0.13u
X5090 a_296731_189665# a_296625_189595# VDD3 VDD3 sg13_lv_pmos ad=0.2603p pd=1.75u as=0.2603p ps=1.75u w=1.37u l=0.35u
X5091 user_project_wrapper_0.IOVSS1 a_176644_369296# user_project_wrapper_0.analog_io[30] user_project_wrapper_0.IOVSS1 sg13_hv_nmos ad=1.408p pd=5.04u as=2.596p ps=5.58u w=4.4u l=0.6u
X5092 user_project_wrapper_0.IOVSS1 user_project_wrapper_0.sg13g2_IOPadVdd_3.sg13g2_RCClampInverter_noptap_0.out user_project_wrapper_0.IOVSS1 user_project_wrapper_0.IOVSS1 sg13_hv_nmos ad=2.068p pd=9.74u as=0 ps=0 w=4.4u l=0.6u
X5093 user_project_wrapper_0.IOVSS1 user_project_wrapper_0.sg13g2_IOPadIOVdd_0.sg13g2_RCClampResistor_0.p2 user_project_wrapper_0.IOVSS1 user_project_wrapper_0.IOVSS1 sg13_hv_nmos ad=1.71p pd=9.38u as=0 ps=0 w=9u l=9.5u
X5094 user_project_wrapper_0.sg13g2_IOPadIOVdd_1.sg13g2_Clamp_N43N43D4R_0.gate user_project_wrapper_0.sg13g2_IOPadIOVdd_1.sg13g2_RCClampResistor_0.p2 user_project_wrapper_0.IOVDD1 user_project_wrapper_0.IOVDD1 sg13_hv_pmos ad=1.33p pd=7.38u as=1.33p ps=7.38u w=7u l=0.5u
X5095 user_project_wrapper_0.ui_PAD[9] user_project_wrapper_0.IOVDD1 dpantenna l=27.78u w=1.26u
X5096 a_82859_239842# a_82859_239376# user_project_wrapper_0.IOVSS1 user_project_wrapper_0.IOVSS1 sg13_lv_nmos ad=0.1428p pd=1.52u as=0.1428p ps=1.52u w=0.42u l=0.56u
X5097 a_93461_128591# a_89953_129061# a_93719_127531# user_project_wrapper_0.IOVSS1 sg13_lv_nmos ad=0.2516p pd=2.16u as=0.1406p ps=1.12u w=0.74u l=0.13u
X5098 VDD3 a_296625_189595# a_296731_189665# VDD3 sg13_lv_pmos ad=0.2603p pd=1.75u as=0.2603p ps=1.75u w=1.37u l=0.35u
X5099 user_project_wrapper_0.IOVDD4 user_project_wrapper_0.sg13g2_IOPadIOVdd_2.sg13g2_Clamp_N43N43D4R_0.gate user_project_wrapper_0.IOVSS1 user_project_wrapper_0.IOVSS1 sg13_hv_nmos ad=2.596p pd=5.58u as=1.408p ps=5.04u w=4.4u l=0.6u
X5100 user_project_wrapper_0.IOVDD4 user_project_wrapper_0.sg13g2_IOPadIOVdd_2.sg13g2_Clamp_N43N43D4R_0.gate user_project_wrapper_0.IOVSS1 user_project_wrapper_0.IOVSS1 sg13_hv_nmos ad=2.596p pd=5.58u as=1.408p ps=5.04u w=4.4u l=0.6u
X5101 a_304995_198817# a_307232_196607# user_project_wrapper_0.IOVSS1 user_project_wrapper_0.IOVSS1 sg13_lv_nmos ad=0.6327p pd=3.71u as=0.6327p ps=3.71u w=3.33u l=0.2u
X5102 user_project_wrapper_0.analog_io[4] a_41476_197044# user_project_wrapper_0.IOVDD1 user_project_wrapper_0.IOVDD1 sg13_hv_pmos ad=3.9294p pd=7.84u as=2.1312p ps=7.3u w=6.66u l=0.6u
X5103 IOVDD3 a_355624_258244# analog_io[25] IOVDD3 sg13_hv_pmos ad=2.1312p pd=7.3u as=3.9294p ps=7.84u w=6.66u l=0.6u
X5104 user_project_wrapper_0.analog_io[12] a_176644_41476# user_project_wrapper_0.IOVDD2 user_project_wrapper_0.IOVDD2 sg13_hv_pmos ad=3.9294p pd=7.84u as=3.1302p ps=14.26u w=6.66u l=0.6u
X5105 user_project_wrapper_0.analog_io[35] a_213870_324142# user_project_wrapper_0.IOVSS1 user_project_wrapper_0.IOVSS1 sg13_lv_nmos ad=0.912p pd=5.18u as=0.912p ps=5.18u w=4.8u l=0.13u
X5106 QDLL_TOP_0.VDD a_189395_101343# a_189729_101343# QDLL_TOP_0.VDD sg13_lv_pmos ad=0.3808p pd=2.92u as=0.2128p ps=1.5u w=1.12u l=0.13u
X5107 a_297775_364458# a_298105_360372# user_project_wrapper_0.IOVSS1 rppd l=20u w=1u
X5108 analog_io[25] a_355624_258244# IOVDD3 IOVDD3 sg13_hv_pmos ad=3.9294p pd=7.84u as=2.1312p ps=7.3u w=6.66u l=0.6u
X5109 a_191438_326377# a_191234_326377# user_project_wrapper_0.IOVSS1 user_project_wrapper_0.IOVSS1 sg13_lv_nmos ad=0.34p pd=2.68u as=0.19p ps=1.38u w=1u l=0.13u
X5110 a_296731_208493# a_296625_208423# VDD3 VDD3 sg13_lv_pmos ad=0.2603p pd=1.75u as=0.2603p ps=1.75u w=1.37u l=0.35u
X5111 user_project_wrapper_0.analog_io[35] a_278644_369296# user_project_wrapper_0.IOVSS1 user_project_wrapper_0.IOVSS1 sg13_hv_nmos ad=2.596p pd=5.58u as=1.408p ps=5.04u w=4.4u l=0.6u
X5112 user_project_wrapper_0.IOVDD1 a_41476_135844# user_project_wrapper_0.analog_io[1] user_project_wrapper_0.IOVDD1 sg13_hv_pmos ad=2.1312p pd=7.3u as=3.9294p ps=7.84u w=6.66u l=0.6u
X5113 a_304196_197873# a_304090_197941# a_296625_189595# user_project_wrapper_0.IOVSS1 sg13_lv_nmos ad=0.646p pd=4.48u as=0.361p ps=2.28u w=1.9u l=0.16u
X5114 user_project_wrapper_0.analog_io[30] a_194687_324142# user_project_wrapper_0.IOVSS1 user_project_wrapper_0.IOVSS1 sg13_lv_pmos ad=1.824p pd=9.98u as=1.824p ps=9.98u w=9.6u l=0.13u
X5115 IOVDD3 a_355624_217444# analog_io[23] IOVDD3 sg13_hv_pmos ad=2.1312p pd=7.3u as=3.9294p ps=7.84u w=6.66u l=0.6u
X5116 user_project_wrapper_0.IOVDD4 a_237844_355624# user_project_wrapper_0.analog_io[33] user_project_wrapper_0.IOVDD4 sg13_hv_pmos ad=3.1302p pd=14.26u as=3.9294p ps=7.84u w=6.66u l=0.6u
X5117 a_209869_324119# a_208855_324776# a_209997_324870# user_project_wrapper_0.IOVSS1 sg13_lv_nmos ad=0.34p pd=2.68u as=0.19p ps=1.38u w=1u l=0.13u
X5118 a_296731_208493# a_296625_208423# VDD3 VDD3 sg13_lv_pmos ad=0.2603p pd=1.75u as=0.2603p ps=1.75u w=1.37u l=0.35u
X5119 user_project_wrapper_0.IOVSS1 user_project_wrapper_0.analog_io[32] dantenna l=1.26u w=27.78u
X5120 user_project_wrapper_0.IOVSS1 user_project_wrapper_0.IOVDD2 dpantenna l=27.78u w=1.26u
X5121 VDD3 a_296625_189595# a_296731_189665# VDD3 sg13_lv_pmos ad=0.2603p pd=1.75u as=0.2603p ps=1.75u w=1.37u l=0.35u
X5122 a_78824_126541# a_78824_126541# user_project_wrapper_0.VDD1 user_project_wrapper_0.VDD1 sg13_lv_pmos ad=0.95p pd=5.38u as=1.7p ps=10.68u w=5u l=0.15u
X5123 user_project_wrapper_0.IOVDD4 a_176644_355624# user_project_wrapper_0.analog_io[30] user_project_wrapper_0.IOVDD4 sg13_hv_pmos ad=2.1312p pd=7.3u as=3.9294p ps=7.84u w=6.66u l=0.6u
X5124 user_project_wrapper_0.IOVSS1 a_176644_29676# user_project_wrapper_0.analog_io[12] user_project_wrapper_0.IOVSS1 sg13_hv_nmos ad=1.408p pd=5.04u as=2.596p ps=5.58u w=4.4u l=0.6u
X5125 a_296625_189595# a_301940_196388# a_296732_197880# VDD3 sg13_lv_pmos ad=0.7695p pd=4.43u as=0.7695p ps=4.43u w=4.05u l=0.5u
X5126 user_project_wrapper_0.IOVSS1 user_project_wrapper_0.sg13g2_IOPadVdd_0.sg13g2_RCClampInverter_noptap_0.out VDD3 user_project_wrapper_0.IOVSS1 sg13_hv_nmos ad=1.408p pd=5.04u as=2.596p ps=5.58u w=4.4u l=0.6u
X5127 user_project_wrapper_0.VDD1 user_project_wrapper_0.sg13g2_IOPadOut4mA$1_0.c2p a_58798_179249# user_project_wrapper_0.VDD1 sg13_lv_pmos ad=1.615p pd=10.18u as=1.615p ps=10.18u w=4.75u l=0.13u
X5128 a_360372_302725# a_364458_303055# user_project_wrapper_0.IOVSS1 rppd l=20u w=1u
X5129 VDD3 a_309516_194555# a_309917_199879# VDD3 sg13_lv_pmos ad=0.19p pd=1.38u as=0.19p ps=1.38u w=1u l=0.7u
X5130 user_project_wrapper_0.IOVSS1 user_project_wrapper_0.sg13g2_IOPadIOVdd_2.sg13g2_Clamp_N43N43D4R_0.gate user_project_wrapper_0.IOVDD4 user_project_wrapper_0.IOVSS1 sg13_hv_nmos ad=1.408p pd=5.04u as=2.596p ps=5.58u w=4.4u l=0.6u
X5131 user_project_wrapper_0.VDD1 user_project_wrapper_0.sg13g2_IOPadVdd_2.sg13g2_RCClampResistor_0.p2 user_project_wrapper_0.sg13g2_IOPadVdd_2.sg13g2_RCClampInverter_noptap_0.out user_project_wrapper_0.VDD1 sg13_hv_pmos ad=1.33p pd=7.38u as=1.33p ps=7.38u w=7u l=0.5u
X5132 user_project_wrapper_0.IOVDD2 a_176644_41476# user_project_wrapper_0.analog_io[12] user_project_wrapper_0.IOVDD2 sg13_hv_pmos ad=3.1302p pd=14.26u as=3.9294p ps=7.84u w=6.66u l=0.6u
X5133 IOVDD3 a_355624_176644# analog_io[20] IOVDD3 sg13_hv_pmos ad=2.1312p pd=7.3u as=3.9294p ps=7.84u w=6.66u l=0.6u
X5134 user_project_wrapper_0.IOVDD4 a_278644_355624# user_project_wrapper_0.analog_io[35] user_project_wrapper_0.IOVDD4 sg13_hv_pmos ad=2.1312p pd=7.3u as=3.9294p ps=7.84u w=6.66u l=0.6u
X5135 a_213870_324142# a_213462_327536# user_project_wrapper_0.IOVSS1 user_project_wrapper_0.IOVSS1 sg13_lv_pmos ad=1.824p pd=9.98u as=1.824p ps=9.98u w=9.6u l=0.13u
X5136 user_project_wrapper_0.analog_io[34] user_project_wrapper_0.sg13g2_IOPadAnalog_22.padres user_project_wrapper_0.IOVSS1 rppd l=2u w=1u
X5137 a_313884_185173# analog_io[20] a_311108_179669# user_project_wrapper_0.IOVSS1 sg13_lv_nmos ad=1.9p pd=10.38u as=1.9p ps=10.38u w=10u l=0.5u
X5138 user_project_wrapper_0.IOVSS1 user_project_wrapper_0.sg13g2_IOPadVdd_0.sg13g2_RCClampInverter_noptap_0.out VDD3 user_project_wrapper_0.IOVSS1 sg13_hv_nmos ad=1.408p pd=5.04u as=2.596p ps=5.58u w=4.4u l=0.6u
X5139 user_project_wrapper_0.analog_io[29] a_156244_369296# user_project_wrapper_0.IOVSS1 user_project_wrapper_0.IOVSS1 sg13_hv_nmos ad=2.596p pd=5.58u as=1.408p ps=5.04u w=4.4u l=0.6u
X5140 VDD3 user_project_wrapper_0.sg13g2_IOPadVdd_0.sg13g2_RCClampResistor_0.p2 user_project_wrapper_0.sg13g2_IOPadVdd_0.sg13g2_RCClampInverter_noptap_0.out VDD3 sg13_hv_pmos ad=1.33p pd=7.38u as=1.33p ps=7.38u w=7u l=0.5u
X5141 a_309516_194555# a_309516_194555# VDD3 VDD3 sg13_lv_pmos ad=0.19p pd=1.38u as=0.19p ps=1.38u w=1u l=0.7u
X5142 user_project_wrapper_0.IOVDD1 a_41476_217444# user_project_wrapper_0.analog_io[5] user_project_wrapper_0.IOVDD1 sg13_hv_pmos ad=2.1312p pd=7.3u as=3.9294p ps=7.84u w=6.66u l=0.6u
X5143 IOVDD3 a_355624_197044# analog_io[22] IOVDD3 sg13_hv_pmos ad=3.1302p pd=14.26u as=3.9294p ps=7.84u w=6.66u l=0.6u
X5144 user_project_wrapper_0.IOVDD2 a_135844_41476# user_project_wrapper_0.analog_io[10] user_project_wrapper_0.IOVDD2 sg13_hv_pmos ad=2.1312p pd=7.3u as=3.9294p ps=7.84u w=6.66u l=0.6u
X5145 user_project_wrapper_0.IOVSS1 user_project_wrapper_0.IOVSS1 user_project_wrapper_0.IOVSS1 rppd l=0.5u w=0.5u
X5146 user_project_wrapper_0.IOVSS1 a_29676_197044# user_project_wrapper_0.analog_io[4] user_project_wrapper_0.IOVSS1 sg13_hv_nmos ad=1.408p pd=5.04u as=2.596p ps=5.58u w=4.4u l=0.6u
X5147 user_project_wrapper_0.analog_io[35] a_213870_324142# user_project_wrapper_0.IOVSS1 user_project_wrapper_0.IOVSS1 sg13_lv_pmos ad=1.824p pd=9.98u as=1.824p ps=9.98u w=9.6u l=0.13u
X5148 user_project_wrapper_0.analog_io[30] a_194687_324142# user_project_wrapper_0.IOVSS1 user_project_wrapper_0.IOVSS1 sg13_lv_pmos ad=1.824p pd=9.98u as=1.824p ps=9.98u w=9.6u l=0.13u
X5149 user_project_wrapper_0.IOVSS1 a_182931_326125# user_project_wrapper_0.analog_io[27] user_project_wrapper_0.IOVSS1 sg13_lv_pmos ad=1.824p pd=9.98u as=1.824p ps=9.98u w=9.6u l=0.13u
X5150 user_project_wrapper_0.VDD1 user_project_wrapper_0.sg13g2_IOPadVdd_2.sg13g2_RCClampInverter_noptap_0.out user_project_wrapper_0.IOVSS1 user_project_wrapper_0.IOVSS1 sg13_hv_nmos ad=2.596p pd=5.58u as=1.408p ps=5.04u w=4.4u l=0.6u
X5151 a_35456_305695# user_project_wrapper_0.sg13g2_IOPadIOVdd_1.sg13g2_RCClampResistor_0.p2 user_project_wrapper_0.IOVSS1 rppd l=20u w=1u
X5152 user_project_wrapper_0.IOVSS1 user_project_wrapper_0.IOVSS1 user_project_wrapper_0.IOVSS1 rppd l=0.5u w=0.5u
X5153 user_project_wrapper_0.IOVDD2 user_project_wrapper_0.sg13g2_IOPadIOVdd_0.sg13g2_RCClampResistor_0.p2 user_project_wrapper_0.sg13g2_IOPadIOVdd_0.sg13g2_Clamp_N43N43D4R_0.gate user_project_wrapper_0.IOVDD2 sg13_hv_pmos ad=1.33p pd=7.38u as=1.33p ps=7.38u w=7u l=0.5u
X5154 user_project_wrapper_0.analog_io[14] a_190389_99046# QDLL_TOP_0.VDD QDLL_TOP_0.VDD sg13_lv_pmos ad=0.2128p pd=1.5u as=0.2128p ps=1.5u w=1.12u l=0.13u
X5155 analog_io[20] a_311108_179669# VDD3 user_project_wrapper_0.IOVSS1 sg13_lv_nmos ad=3.4p pd=20.68u as=3.4p ps=20.68u w=10u l=0.15u
X5156 a_82859_242012# a_82859_241546# user_project_wrapper_0.IOVSS1 user_project_wrapper_0.IOVSS1 sg13_lv_nmos ad=0.1428p pd=1.52u as=0.1428p ps=1.52u w=0.42u l=0.56u
X5157 user_project_wrapper_0.IOVSS1 user_project_wrapper_0.sg13g2_IOPadIOVdd_1.sg13g2_Clamp_N43N43D4R_0.gate user_project_wrapper_0.IOVDD1 user_project_wrapper_0.IOVSS1 sg13_hv_nmos ad=1.408p pd=5.04u as=2.596p ps=5.58u w=4.4u l=0.6u
X5158 user_project_wrapper_0.IOVSS1 a_190319_97955# QDLL_TOP_0.CPIN user_project_wrapper_0.IOVSS1 sg13_lv_nmos ad=0.3108p pd=2.32u as=0.1628p ps=1.18u w=0.74u l=0.13u
X5159 VDD3 a_309516_194555# a_309917_199879# VDD3 sg13_lv_pmos ad=0.19p pd=1.38u as=0.19p ps=1.38u w=1u l=0.7u
X5160 user_project_wrapper_0.analog_io[30] a_194687_324142# user_project_wrapper_0.IOVSS1 user_project_wrapper_0.IOVSS1 sg13_lv_pmos ad=1.824p pd=9.98u as=1.824p ps=9.98u w=9.6u l=0.13u
X5161 user_project_wrapper_0.IOVSS1 a_213870_324142# user_project_wrapper_0.analog_io[35] user_project_wrapper_0.IOVSS1 sg13_lv_nmos ad=0.912p pd=5.18u as=0.912p ps=5.18u w=4.8u l=0.13u
X5162 user_project_wrapper_0.IOVSS1 user_project_wrapper_0.sg13g2_IOPadVdd_0.sg13g2_RCClampInverter_noptap_0.out VDD3 user_project_wrapper_0.IOVSS1 sg13_hv_nmos ad=1.408p pd=5.04u as=2.596p ps=5.58u w=4.4u l=0.6u
X5163 analog_io[23] a_355624_217444# IOVDD3 IOVDD3 sg13_hv_pmos ad=3.9294p pd=7.84u as=3.1302p ps=14.26u w=6.66u l=0.6u
X5164 user_project_wrapper_0.sg13g2_IOPadIOVdd_1.sg13g2_Clamp_N43N43D4R_0.gate user_project_wrapper_0.sg13g2_IOPadIOVdd_1.sg13g2_RCClampResistor_0.p2 user_project_wrapper_0.IOVDD1 user_project_wrapper_0.IOVDD1 sg13_hv_pmos ad=1.33p pd=7.38u as=1.33p ps=7.38u w=7u l=0.5u
X5165 user_project_wrapper_0.analog_io[27] a_182931_326125# user_project_wrapper_0.IOVSS1 user_project_wrapper_0.IOVSS1 sg13_lv_nmos ad=0.912p pd=5.18u as=0.912p ps=5.18u w=4.8u l=0.13u
X5166 VDD3 a_296626_197740# a_296732_197880# VDD3 sg13_lv_pmos ad=1.33p pd=7.38u as=1.33p ps=7.38u w=7u l=0.7u
X5167 a_59490_159238# user_project_wrapper_0.sg13g2_IOPadIn$1_0.sg13g2_LevelDown_noptap$1_0.sg13g2_SecondaryProtection$1$1_0.core user_project_wrapper_0.VDD1 user_project_wrapper_0.VDD1 sg13_hv_pmos ad=1.581p pd=9.98u as=1.581p ps=9.98u w=4.65u l=0.45u
X5168 user_project_wrapper_0.IOVSS1 user_project_wrapper_0.sg13g2_IOPadVdd_3.sg13g2_RCClampResistor_0.p2 user_project_wrapper_0.IOVSS1 user_project_wrapper_0.IOVSS1 sg13_hv_nmos ad=1.71p pd=9.38u as=0 ps=0 w=9u l=9.5u
X5169 user_project_wrapper_0.IOVSS1 a_213870_324142# user_project_wrapper_0.analog_io[35] user_project_wrapper_0.IOVSS1 sg13_lv_nmos ad=0.912p pd=5.18u as=0.912p ps=5.18u w=4.8u l=0.13u
X5170 user_project_wrapper_0.IOVDD4 user_project_wrapper_0.sg13g2_IOPadIOVdd_2.sg13g2_RCClampResistor_0.p2 user_project_wrapper_0.sg13g2_IOPadIOVdd_2.sg13g2_Clamp_N43N43D4R_0.gate user_project_wrapper_0.IOVDD4 sg13_hv_pmos ad=1.33p pd=7.38u as=1.33p ps=7.38u w=7u l=0.5u
X5171 a_79025_133911# a_79038_132662# user_project_wrapper_0.IOVSS1 user_project_wrapper_0.IOVSS1 sg13_lv_nmos ad=0.1428p pd=1.52u as=0.1428p ps=1.52u w=0.42u l=0.56u
X5172 user_project_wrapper_0.IOVSS1 a_307232_196607# a_307232_196607# user_project_wrapper_0.IOVSS1 sg13_lv_nmos ad=0.6327p pd=3.71u as=0.6327p ps=3.71u w=3.33u l=0.2u
X5173 user_project_wrapper_0.IOVDD1 a_41476_197044# user_project_wrapper_0.IOVDD1 rppd l=12.9u w=0.5u
X5174 user_project_wrapper_0.IOVSS1 user_project_wrapper_0.IOVSS1 user_project_wrapper_0.IOVSS1 rppd l=0.5u w=0.5u
X5175 VDD3 user_project_wrapper_0.sg13g2_IOPadVdd_0.sg13g2_RCClampInverter_noptap_0.out user_project_wrapper_0.IOVSS1 user_project_wrapper_0.IOVSS1 sg13_hv_nmos ad=2.596p pd=5.58u as=1.408p ps=5.04u w=4.4u l=0.6u
X5176 a_309917_199879# a_309516_194555# VDD3 VDD3 sg13_lv_pmos ad=0.19p pd=1.38u as=0.19p ps=1.38u w=1u l=0.7u
X5177 IOVDD3 user_project_wrapper_0.sg13g2_IOPadIOVdd_3.sg13g2_Clamp_N43N43D4R_0.gate user_project_wrapper_0.IOVSS1 user_project_wrapper_0.IOVSS1 sg13_hv_nmos ad=2.596p pd=5.58u as=1.408p ps=5.04u w=4.4u l=0.6u
X5178 IOVDD3 user_project_wrapper_0.sg13g2_IOPadIOVdd_3.sg13g2_Clamp_N43N43D4R_0.gate user_project_wrapper_0.IOVSS1 user_project_wrapper_0.IOVSS1 sg13_hv_nmos ad=2.596p pd=5.58u as=1.408p ps=5.04u w=4.4u l=0.6u
X5179 user_project_wrapper_0.analog_io[35] a_213870_324142# user_project_wrapper_0.IOVSS1 user_project_wrapper_0.IOVSS1 sg13_lv_pmos ad=1.824p pd=9.98u as=1.824p ps=9.98u w=9.6u l=0.13u
X5180 a_309516_194555# a_309516_194555# VDD3 VDD3 sg13_lv_pmos ad=0.19p pd=1.38u as=0.19p ps=1.38u w=1u l=0.7u
X5181 user_project_wrapper_0.IOVSS1 a_182931_326125# user_project_wrapper_0.analog_io[27] user_project_wrapper_0.IOVSS1 sg13_lv_pmos ad=1.824p pd=9.98u as=1.824p ps=9.98u w=9.6u l=0.13u
X5182 a_210621_326377# a_210417_326377# user_project_wrapper_0.IOVSS1 user_project_wrapper_0.IOVSS1 sg13_lv_nmos ad=0.34p pd=2.68u as=0.19p ps=1.38u w=1u l=0.13u
X5183 user_project_wrapper_0.IOVSS1 a_278644_369296# user_project_wrapper_0.analog_io[35] user_project_wrapper_0.IOVSS1 sg13_hv_nmos ad=1.408p pd=5.04u as=2.596p ps=5.58u w=4.4u l=0.6u
X5184 a_304995_198817# a_307232_196607# user_project_wrapper_0.IOVSS1 user_project_wrapper_0.IOVSS1 sg13_lv_nmos ad=0.6327p pd=3.71u as=0.6327p ps=3.71u w=3.33u l=0.2u
X5185 user_project_wrapper_0.VDD2 user_project_wrapper_0.sg13g2_IOPadVdd_1.sg13g2_RCClampInverter_noptap_0.out user_project_wrapper_0.IOVSS1 user_project_wrapper_0.IOVSS1 sg13_hv_nmos ad=2.596p pd=5.58u as=1.408p ps=5.04u w=4.4u l=0.6u
X5186 user_project_wrapper_0.analog_io[35] a_213870_324142# user_project_wrapper_0.IOVSS1 user_project_wrapper_0.IOVSS1 sg13_lv_pmos ad=1.824p pd=9.98u as=1.824p ps=9.98u w=9.6u l=0.13u
X5187 user_project_wrapper_0.IOVDD1 user_project_wrapper_0.sg13g2_IOPadIOVdd_1.sg13g2_Clamp_N43N43D4R_0.gate user_project_wrapper_0.IOVSS1 user_project_wrapper_0.IOVSS1 sg13_hv_nmos ad=2.596p pd=5.58u as=1.408p ps=5.04u w=4.4u l=0.6u
X5188 user_project_wrapper_0.IOVDD4 user_project_wrapper_0.sg13g2_IOPadIOVdd_2.sg13g2_Clamp_N43N43D4R_0.gate user_project_wrapper_0.IOVSS1 user_project_wrapper_0.IOVSS1 sg13_hv_nmos ad=2.596p pd=5.58u as=1.408p ps=5.04u w=4.4u l=0.6u
X5189 user_project_wrapper_0.IOVSS1 a_278644_29676# QDLL_TOP_0.VOUT user_project_wrapper_0.IOVSS1 sg13_hv_nmos ad=1.408p pd=5.04u as=2.596p ps=5.58u w=4.4u l=0.6u
X5190 user_project_wrapper_0.IOVSS1 user_project_wrapper_0.sg13g2_IOPadAnalog_5.padres dantenna l=3.1u w=0.64u
X5191 user_project_wrapper_0.analog_io[11] a_156244_29676# user_project_wrapper_0.IOVSS1 user_project_wrapper_0.IOVSS1 sg13_hv_nmos ad=2.596p pd=5.58u as=1.408p ps=5.04u w=4.4u l=0.6u
X5192 user_project_wrapper_0.IOVSS1 user_project_wrapper_0.sg13g2_IOPadIOVdd_0.sg13g2_RCClampResistor_0.p2 user_project_wrapper_0.IOVSS1 user_project_wrapper_0.IOVSS1 sg13_hv_nmos ad=1.71p pd=9.38u as=0 ps=0 w=9u l=9.5u
X5193 a_78220_130691# a_78220_128592# user_project_wrapper_0.IOVSS1 rppd l=2u w=0.5u
X5194 a_304196_197873# a_304090_197941# a_296625_189595# user_project_wrapper_0.IOVSS1 sg13_lv_nmos ad=0.646p pd=4.48u as=0.361p ps=2.28u w=1.9u l=0.16u
X5195 analog_io[26] a_355624_278644# IOVDD3 IOVDD3 sg13_hv_pmos ad=3.9294p pd=7.84u as=2.1312p ps=7.3u w=6.66u l=0.6u
X5196 user_project_wrapper_0.sg13g2_IOPadIOVdd_3.sg13g2_Clamp_N43N43D4R_0.gate user_project_wrapper_0.sg13g2_IOPadIOVdd_3.sg13g2_RCClampResistor_0.p2 IOVDD3 IOVDD3 sg13_hv_pmos ad=1.33p pd=7.38u as=1.33p ps=7.38u w=7u l=0.5u
X5197 user_project_wrapper_0.analog_io[11] a_156244_41476# user_project_wrapper_0.IOVDD2 user_project_wrapper_0.IOVDD2 sg13_hv_pmos ad=3.9294p pd=7.84u as=2.1312p ps=7.3u w=6.66u l=0.6u
X5198 user_project_wrapper_0.sg13g2_IOPadAnalog_6.padres user_project_wrapper_0.analog_io[11] user_project_wrapper_0.IOVSS1 rppd l=2u w=1u
X5199 a_182931_326125# a_186202_326221# user_project_wrapper_0.IOVSS1 user_project_wrapper_0.IOVSS1 sg13_lv_nmos ad=0.912p pd=5.18u as=0.912p ps=5.18u w=4.8u l=0.13u
X5200 a_190501_328605# a_189184_328605# user_project_wrapper_0.IOVSS1 user_project_wrapper_0.IOVSS1 sg13_lv_nmos ad=0.34p pd=2.68u as=0.34p ps=2.68u w=1u l=0.13u
X5201 IOVDD3 user_project_wrapper_0.sg13g2_IOPadIOVdd_3.sg13g2_Clamp_N43N43D4R_0.gate user_project_wrapper_0.IOVSS1 user_project_wrapper_0.IOVSS1 sg13_hv_nmos ad=2.596p pd=5.58u as=1.408p ps=5.04u w=4.4u l=0.6u
X5202 VDD3 a_309516_194555# a_309917_194695# VDD3 sg13_lv_pmos ad=0.19p pd=1.38u as=0.19p ps=1.38u w=1u l=0.7u
X5203 IOVDD3 a_355624_217444# analog_io[23] IOVDD3 sg13_hv_pmos ad=2.1312p pd=7.3u as=3.9294p ps=7.84u w=6.66u l=0.6u
X5204 a_304705_39542# a_304375_35456# user_project_wrapper_0.IOVSS1 rppd l=20u w=1u
X5205 user_project_wrapper_0.IOVDD2 user_project_wrapper_0.sg13g2_IOPadIOVdd_0.sg13g2_Clamp_N43N43D4R_0.gate user_project_wrapper_0.IOVSS1 user_project_wrapper_0.IOVSS1 sg13_hv_nmos ad=2.596p pd=5.58u as=1.408p ps=5.04u w=4.4u l=0.6u
X5206 user_project_wrapper_0.IOVSS1 user_project_wrapper_0.sg13g2_IOPadIOVdd_2.sg13g2_Clamp_N43N43D4R_0.gate user_project_wrapper_0.IOVDD4 user_project_wrapper_0.IOVSS1 sg13_hv_nmos ad=1.408p pd=5.04u as=2.596p ps=5.58u w=4.4u l=0.6u
X5207 user_project_wrapper_0.IOVSS1 user_project_wrapper_0.sg13g2_IOPadVdd_2.sg13g2_RCClampInverter_noptap_0.out user_project_wrapper_0.VDD1 user_project_wrapper_0.IOVSS1 sg13_hv_nmos ad=1.408p pd=5.04u as=2.596p ps=5.58u w=4.4u l=0.6u
X5208 user_project_wrapper_0.IOVSS1 a_301186_192011# a_296731_208493# user_project_wrapper_0.IOVSS1 sg13_lv_nmos ad=0.912p pd=5.18u as=0.912p ps=5.18u w=4.8u l=1.06u
X5209 a_313884_211353# a_296731_208493# a_311189_211724# user_project_wrapper_0.IOVSS1 sg13_lv_nmos ad=1.9p pd=10.38u as=1.9p ps=10.38u w=10u l=0.5u
X5210 user_project_wrapper_0.IOVSS1 a_182931_326125# user_project_wrapper_0.analog_io[27] user_project_wrapper_0.IOVSS1 sg13_lv_nmos ad=0.912p pd=5.18u as=0.912p ps=5.18u w=4.8u l=0.13u
X5211 user_project_wrapper_0.IOVSS1 user_project_wrapper_0.sg13g2_IOPadVdd_0.sg13g2_RCClampInverter_noptap_0.out VDD3 user_project_wrapper_0.IOVSS1 sg13_hv_nmos ad=1.408p pd=5.04u as=2.596p ps=5.58u w=4.4u l=0.6u
X5212 analog_io[19] a_355624_135844# IOVDD3 IOVDD3 sg13_hv_pmos ad=3.9294p pd=7.84u as=2.1312p ps=7.3u w=6.66u l=0.6u
X5213 user_project_wrapper_0.IOVSS1 a_307232_196607# a_304995_198817# user_project_wrapper_0.IOVSS1 sg13_lv_nmos ad=0.6327p pd=3.71u as=0.6327p ps=3.71u w=3.33u l=0.2u
X5214 user_project_wrapper_0.IOVSS1 user_project_wrapper_0.sg13g2_IOPadAnalog_9.padres dantenna l=0.64u w=3.1u
X5215 a_296731_189665# a_296625_189595# VDD3 VDD3 sg13_lv_pmos ad=0.2603p pd=1.75u as=0.2603p ps=1.75u w=1.37u l=0.35u
X5216 user_project_wrapper_0.IOVSS1 user_project_wrapper_0.sg13g2_IOPadVdd_3.sg13g2_RCClampInverter_noptap_0.out user_project_wrapper_0.IOVSS1 user_project_wrapper_0.IOVSS1 sg13_hv_nmos ad=2.596p pd=5.58u as=0 ps=0 w=4.4u l=0.6u
X5217 user_project_wrapper_0.IOVSS1 user_project_wrapper_0.sg13g2_IOPadIOVdd_2.sg13g2_Clamp_N43N43D4R_0.gate user_project_wrapper_0.IOVDD4 user_project_wrapper_0.IOVSS1 sg13_hv_nmos ad=1.408p pd=5.04u as=2.596p ps=5.58u w=4.4u l=0.6u
X5218 a_296731_189665# a_296625_189595# VDD3 VDD3 sg13_lv_pmos ad=0.2603p pd=1.75u as=0.2603p ps=1.75u w=1.37u l=0.35u
X5219 a_309917_199879# a_296731_208493# a_307232_196607# VDD3 sg13_lv_pmos ad=0.24415p pd=1.665u as=0.24415p ps=1.665u w=1.285u l=0.35u
X5220 user_project_wrapper_0.IOVSS1 user_project_wrapper_0.sg13g2_IOPadIOVdd_2.sg13g2_Clamp_N43N43D4R_0.gate user_project_wrapper_0.IOVDD4 user_project_wrapper_0.IOVSS1 sg13_hv_nmos ad=1.408p pd=5.04u as=2.596p ps=5.58u w=4.4u l=0.6u
X5221 user_project_wrapper_0.VDD1 a_86507_127725# a_88274_127896# user_project_wrapper_0.VDD1 sg13_lv_pmos ad=0.3808p pd=2.92u as=0.2128p ps=1.5u w=1.12u l=0.13u
X5222 user_project_wrapper_0.IOVDD2 a_135844_41476# user_project_wrapper_0.analog_io[10] user_project_wrapper_0.IOVDD2 sg13_hv_pmos ad=2.1312p pd=7.3u as=3.9294p ps=7.84u w=6.66u l=0.6u
X5223 a_217444_29676# user_project_wrapper_0.IOVSS1 user_project_wrapper_0.IOVSS1 rppd l=3.54u w=0.5u
X5224 user_project_wrapper_0.VDD1 a_78824_137391# a_78824_137391# user_project_wrapper_0.VDD1 sg13_lv_pmos ad=1.7p pd=10.68u as=0.95p ps=5.38u w=5u l=0.15u
X5225 IOVDD3 user_project_wrapper_0.sg13g2_IOPadIOVdd_3.sg13g2_Clamp_N43N43D4R_0.gate user_project_wrapper_0.IOVSS1 user_project_wrapper_0.IOVSS1 sg13_hv_nmos ad=2.596p pd=5.58u as=1.408p ps=5.04u w=4.4u l=0.6u
X5226 user_project_wrapper_0.IOVDD4 user_project_wrapper_0.sg13g2_IOPadIOVdd_2.sg13g2_RCClampResistor_0.p2 user_project_wrapper_0.sg13g2_IOPadIOVdd_2.sg13g2_Clamp_N43N43D4R_0.gate user_project_wrapper_0.IOVDD4 sg13_hv_pmos ad=1.33p pd=7.38u as=1.33p ps=7.38u w=7u l=0.5u
X5227 user_project_wrapper_0.VDD2 user_project_wrapper_0.sg13g2_IOPadVdd_1.sg13g2_RCClampResistor_0.p2 user_project_wrapper_0.sg13g2_IOPadVdd_1.sg13g2_RCClampInverter_noptap_0.out user_project_wrapper_0.VDD2 sg13_hv_pmos ad=1.33p pd=7.38u as=1.33p ps=7.38u w=7u l=0.5u
X5228 a_300745_39542# a_301075_35456# user_project_wrapper_0.IOVSS1 rppd l=20u w=1u
X5229 a_309917_194695# a_309516_194555# VDD3 VDD3 sg13_lv_pmos ad=0.19p pd=1.38u as=0.19p ps=1.38u w=1u l=0.7u
X5230 user_project_wrapper_0.IOVSS1 user_project_wrapper_0.sg13g2_IOPadIOVdd_3.sg13g2_RCClampResistor_0.p2 user_project_wrapper_0.IOVSS1 user_project_wrapper_0.IOVSS1 sg13_hv_nmos ad=1.71p pd=9.38u as=0 ps=0 w=9u l=9.5u
X5231 a_296731_189665# a_296625_189595# VDD3 VDD3 sg13_lv_pmos ad=0.2603p pd=1.75u as=0.2603p ps=1.75u w=1.37u l=0.35u
X5232 user_project_wrapper_0.IOVSS1 user_project_wrapper_0.sg13g2_IOPadVdd_0.sg13g2_RCClampInverter_noptap_0.out VDD3 user_project_wrapper_0.IOVSS1 sg13_hv_nmos ad=1.408p pd=5.04u as=2.596p ps=5.58u w=4.4u l=0.6u
X5233 user_project_wrapper_0.IOVSS1 user_project_wrapper_0.sg13g2_IOPadIOVdd_0.sg13g2_Clamp_N43N43D4R_0.gate user_project_wrapper_0.IOVDD2 user_project_wrapper_0.IOVSS1 sg13_hv_nmos ad=1.408p pd=5.04u as=2.596p ps=5.58u w=4.4u l=0.6u
X5234 user_project_wrapper_0.IOVSS1 a_270512_100118# a_271172_100118# user_project_wrapper_0.IOVSS1 sg13_lv_nmos ad=0.1406p pd=1.12u as=0.1406p ps=1.12u w=0.74u l=0.13u
X5235 a_296731_208493# a_296625_208423# VDD3 VDD3 sg13_lv_pmos ad=0.2603p pd=1.75u as=0.2603p ps=1.75u w=1.37u l=0.35u
X5236 user_project_wrapper_0.IOVSS1 a_278644_29676# QDLL_TOP_0.VOUT user_project_wrapper_0.IOVSS1 sg13_hv_nmos ad=1.408p pd=5.04u as=2.596p ps=5.58u w=4.4u l=0.6u
X5237 user_project_wrapper_0.analog_io[7] a_41476_258244# user_project_wrapper_0.IOVDD1 user_project_wrapper_0.IOVDD1 sg13_hv_pmos ad=3.9294p pd=7.84u as=2.1312p ps=7.3u w=6.66u l=0.6u
X5238 user_project_wrapper_0.sg13g2_IOPadVdd_3.sg13g2_RCClampInverter_noptap_0.out user_project_wrapper_0.sg13g2_IOPadVdd_3.sg13g2_RCClampResistor_0.p2 user_project_wrapper_0.IOVSS1 user_project_wrapper_0.IOVSS1 sg13_hv_pmos ad=1.33p pd=7.38u as=1.33p ps=7.38u w=7u l=0.5u
X5239 user_project_wrapper_0.analog_io[32] a_202114_326125# user_project_wrapper_0.IOVSS1 user_project_wrapper_0.IOVSS1 sg13_lv_pmos ad=1.824p pd=9.98u as=1.824p ps=9.98u w=9.6u l=0.13u
X5240 user_project_wrapper_0.analog_io[33] a_237844_369296# user_project_wrapper_0.IOVSS1 user_project_wrapper_0.IOVSS1 sg13_hv_nmos ad=2.596p pd=5.58u as=1.408p ps=5.04u w=4.4u l=0.6u
X5241 a_313884_185173# a_296731_189665# a_311189_185546# user_project_wrapper_0.IOVSS1 sg13_lv_nmos ad=1.9p pd=10.38u as=1.9p ps=10.38u w=10u l=0.5u
X5242 user_project_wrapper_0.analog_io[11] a_156244_41476# user_project_wrapper_0.IOVDD2 user_project_wrapper_0.IOVDD2 sg13_hv_pmos ad=3.9294p pd=7.84u as=2.1312p ps=7.3u w=6.66u l=0.6u
X5243 VDD3 a_309516_194555# a_309917_194695# VDD3 sg13_lv_pmos ad=0.19p pd=1.38u as=0.19p ps=1.38u w=1u l=0.7u
X5244 a_191438_326377# a_191234_326377# user_project_wrapper_0.IOVSS1 user_project_wrapper_0.IOVSS1 sg13_lv_nmos ad=0.19p pd=1.38u as=0.34p ps=2.68u w=1u l=0.13u
X5245 a_309917_199879# a_309516_194555# VDD3 VDD3 sg13_lv_pmos ad=0.19p pd=1.38u as=0.19p ps=1.38u w=1u l=0.7u
X5246 user_project_wrapper_0.VDD2 user_project_wrapper_0.sg13g2_IOPadVdd_1.sg13g2_RCClampInverter_noptap_0.out user_project_wrapper_0.IOVSS1 user_project_wrapper_0.IOVSS1 sg13_hv_nmos ad=2.596p pd=5.58u as=1.408p ps=5.04u w=4.4u l=0.6u
X5247 a_115165_39542# a_115495_35456# user_project_wrapper_0.IOVSS1 rppd l=20u w=1u
X5248 user_project_wrapper_0.IOVSS1 user_project_wrapper_0.sg13g2_IOPadIOVdd_3.sg13g2_Clamp_N43N43D4R_0.gate IOVDD3 user_project_wrapper_0.IOVSS1 sg13_hv_nmos ad=1.408p pd=5.04u as=2.596p ps=5.58u w=4.4u l=0.6u
X5249 user_project_wrapper_0.IOVSS1 user_project_wrapper_0.sg13g2_IOPadIOVdd_3.sg13g2_RCClampResistor_0.p2 user_project_wrapper_0.IOVSS1 user_project_wrapper_0.IOVSS1 sg13_hv_nmos ad=1.71p pd=9.38u as=0 ps=0 w=9u l=9.5u
X5250 user_project_wrapper_0.IOVSS1 user_project_wrapper_0.sg13g2_IOPadVdd_3.sg13g2_RCClampResistor_0.p2 user_project_wrapper_0.IOVSS1 user_project_wrapper_0.IOVSS1 sg13_hv_nmos ad=1.71p pd=9.38u as=0 ps=0 w=9u l=9.5u
X5251 IOVDD3 a_355624_135844# analog_io[19] IOVDD3 sg13_hv_pmos ad=2.1312p pd=7.3u as=3.9294p ps=7.84u w=6.66u l=0.6u
X5252 user_project_wrapper_0.VDD2 user_project_wrapper_0.sg13g2_IOPadVdd_1.sg13g2_RCClampInverter_noptap_0.out user_project_wrapper_0.IOVSS1 user_project_wrapper_0.IOVSS1 sg13_hv_nmos ad=2.596p pd=5.58u as=1.408p ps=5.04u w=4.4u l=0.6u
X5253 user_project_wrapper_0.IOVDD2 user_project_wrapper_0.sg13g2_IOPadIOVdd_0.sg13g2_Clamp_N43N43D4R_0.gate user_project_wrapper_0.IOVSS1 user_project_wrapper_0.IOVSS1 sg13_hv_nmos ad=2.596p pd=5.58u as=1.408p ps=5.04u w=4.4u l=0.6u
X5254 user_project_wrapper_0.analog_io[12] a_176644_41476# user_project_wrapper_0.IOVDD2 user_project_wrapper_0.IOVDD2 sg13_hv_pmos ad=3.9294p pd=7.84u as=2.1312p ps=7.3u w=6.66u l=0.6u
X5255 user_project_wrapper_0.analog_io[35] a_278644_369296# user_project_wrapper_0.IOVSS1 user_project_wrapper_0.IOVSS1 sg13_hv_nmos ad=2.596p pd=5.58u as=1.408p ps=5.04u w=4.4u l=0.6u
X5256 user_project_wrapper_0.IOVSS1 user_project_wrapper_0.sg13g2_IOPadIOVdd_1.sg13g2_Clamp_N43N43D4R_0.gate user_project_wrapper_0.IOVDD1 user_project_wrapper_0.IOVSS1 sg13_hv_nmos ad=1.408p pd=5.04u as=2.596p ps=5.58u w=4.4u l=0.6u
X5257 user_project_wrapper_0.IOVSS1 user_project_wrapper_0.sg13g2_IOPadVdd_3.sg13g2_RCClampResistor_0.p2 user_project_wrapper_0.sg13g2_IOPadVdd_3.sg13g2_RCClampInverter_noptap_0.out user_project_wrapper_0.IOVSS1 sg13_hv_pmos ad=1.33p pd=7.38u as=1.33p ps=7.38u w=7u l=0.5u
X5258 IOVDD3 a_355624_237844# analog_io[23] IOVDD3 sg13_hv_pmos ad=2.1312p pd=7.3u as=3.9294p ps=7.84u w=6.66u l=0.6u
X5259 user_project_wrapper_0.sg13g2_IOPadVdd_1.sg13g2_RCClampInverter_noptap_0.out user_project_wrapper_0.sg13g2_IOPadVdd_1.sg13g2_RCClampResistor_0.p2 user_project_wrapper_0.VDD2 user_project_wrapper_0.VDD2 sg13_hv_pmos ad=1.33p pd=7.38u as=1.33p ps=7.38u w=7u l=0.5u
X5260 a_115165_39542# a_114835_35456# user_project_wrapper_0.IOVSS1 rppd l=20u w=1u
X5261 a_296731_208493# a_296625_208423# VDD3 VDD3 sg13_lv_pmos ad=0.2603p pd=1.75u as=0.4658p ps=3.42u w=1.37u l=0.35u
X5262 user_project_wrapper_0.IOVSS1 user_project_wrapper_0.sg13g2_IOPadIOVdd_2.sg13g2_Clamp_N43N43D4R_0.gate user_project_wrapper_0.IOVDD4 user_project_wrapper_0.IOVSS1 sg13_hv_nmos ad=1.408p pd=5.04u as=2.596p ps=5.58u w=4.4u l=0.6u
X5263 user_project_wrapper_0.IOVSS1 a_213462_327536# a_213870_324142# user_project_wrapper_0.IOVSS1 sg13_lv_nmos ad=0.912p pd=5.18u as=0.912p ps=5.18u w=4.8u l=0.13u
X5264 a_78220_123062# user_project_wrapper_0.IOVSS1 user_project_wrapper_0.IOVSS1 rppd l=4u w=0.5u
X5265 user_project_wrapper_0.analog_io[27] a_182931_326125# user_project_wrapper_0.IOVSS1 user_project_wrapper_0.IOVSS1 sg13_lv_nmos ad=0.912p pd=5.18u as=1.632p ps=10.28u w=4.8u l=0.13u
X5266 user_project_wrapper_0.analog_io[33] a_237844_355624# user_project_wrapper_0.IOVDD4 user_project_wrapper_0.IOVDD4 sg13_hv_pmos ad=3.9294p pd=7.84u as=2.1312p ps=7.3u w=6.66u l=0.6u
X5267 user_project_wrapper_0.IOVSS1 user_project_wrapper_0.sg13g2_IOPadIOVdd_2.sg13g2_Clamp_N43N43D4R_0.gate user_project_wrapper_0.IOVDD4 user_project_wrapper_0.IOVSS1 sg13_hv_nmos ad=1.408p pd=5.04u as=2.596p ps=5.58u w=4.4u l=0.6u
X5268 a_35456_76675# a_39542_76345# user_project_wrapper_0.IOVSS1 rppd l=20u w=1u
X5269 a_296731_208493# a_296625_208423# VDD3 VDD3 sg13_lv_pmos ad=0.2603p pd=1.75u as=0.2603p ps=1.75u w=1.37u l=0.35u
X5270 user_project_wrapper_0.IOVDD2 a_197044_41476# user_project_wrapper_0.analog_io[13] user_project_wrapper_0.IOVDD2 sg13_hv_pmos ad=2.1312p pd=7.3u as=3.9294p ps=7.84u w=6.66u l=0.6u
X5271 a_296731_189665# a_296625_189595# VDD3 VDD3 sg13_lv_pmos ad=0.2603p pd=1.75u as=0.2603p ps=1.75u w=1.37u l=0.35u
X5272 user_project_wrapper_0.IOVSS1 a_29676_258244# user_project_wrapper_0.analog_io[7] user_project_wrapper_0.IOVSS1 sg13_hv_nmos ad=1.408p pd=5.04u as=2.596p ps=5.58u w=4.4u l=0.6u
X5273 a_311846_195517# user_project_wrapper_0.sg13g2_IOPadAnalog_29.padres a_309917_199879# VDD3 sg13_lv_pmos ad=0.24415p pd=1.665u as=0.24415p ps=1.665u w=1.285u l=0.35u
X5274 user_project_wrapper_0.analog_io[30] a_194687_324142# user_project_wrapper_0.IOVSS1 user_project_wrapper_0.IOVSS1 sg13_lv_pmos ad=1.824p pd=9.98u as=1.824p ps=9.98u w=9.6u l=0.13u
X5275 a_83070_130577# a_79025_125231# a_83070_130212# user_project_wrapper_0.IOVSS1 sg13_lv_nmos ad=0.2516p pd=2.16u as=0.1406p ps=1.12u w=0.74u l=0.13u
X5276 user_project_wrapper_0.IOVSS1 user_project_wrapper_0.sg13g2_IOPadIOVdd_1.sg13g2_Clamp_N43N43D4R_0.gate user_project_wrapper_0.IOVDD1 user_project_wrapper_0.IOVSS1 sg13_hv_nmos ad=1.408p pd=5.04u as=2.596p ps=5.58u w=4.4u l=0.6u
X5277 a_301075_364458# a_300745_360372# user_project_wrapper_0.IOVSS1 rppd l=20u w=1u
X5278 user_project_wrapper_0.IOVSS1 user_project_wrapper_0.IOVSS1 dantenna l=27.78u w=1.26u
X5279 a_309917_199879# user_project_wrapper_0.sg13g2_IOPadAnalog_29.padres a_311846_195517# VDD3 sg13_lv_pmos ad=0.24415p pd=1.665u as=0.24415p ps=1.665u w=1.285u l=0.35u
X5280 user_project_wrapper_0.IOVDD1 a_41476_258244# user_project_wrapper_0.analog_io[7] user_project_wrapper_0.IOVDD1 sg13_hv_pmos ad=2.1312p pd=7.3u as=3.9294p ps=7.84u w=6.66u l=0.6u
X5281 user_project_wrapper_0.IOVDD4 a_278644_355624# user_project_wrapper_0.analog_io[35] user_project_wrapper_0.IOVDD4 sg13_hv_pmos ad=2.1312p pd=7.3u as=3.9294p ps=7.84u w=6.66u l=0.6u
X5282 user_project_wrapper_0.IOVSS1 a_176644_29676# user_project_wrapper_0.analog_io[12] user_project_wrapper_0.IOVSS1 sg13_hv_nmos ad=2.068p pd=9.74u as=2.596p ps=5.58u w=4.4u l=0.6u
X5283 user_project_wrapper_0.IOVSS1 a_208017_327918# a_208469_328605# w_207887_327938# sg13_lv_pmos ad=0.68p pd=4.68u as=0.38p ps=2.38u w=2u l=0.13u
X5284 user_project_wrapper_0.IOVSS1 user_project_wrapper_0.sg13g2_IOPadVdd_1.sg13g2_RCClampInverter_noptap_0.out user_project_wrapper_0.VDD2 user_project_wrapper_0.IOVSS1 sg13_hv_nmos ad=1.408p pd=5.04u as=2.596p ps=5.58u w=4.4u l=0.6u
X5285 VDD3 a_296625_189595# a_296731_189665# VDD3 sg13_lv_pmos ad=0.2603p pd=1.75u as=0.2603p ps=1.75u w=1.37u l=0.35u
X5286 user_project_wrapper_0.analog_io[29] a_156244_369296# user_project_wrapper_0.IOVSS1 user_project_wrapper_0.IOVSS1 sg13_hv_nmos ad=2.596p pd=5.58u as=1.408p ps=5.04u w=4.4u l=0.6u
X5287 user_project_wrapper_0.IOVSS1 a_85435_125173# a_85359_125209# user_project_wrapper_0.IOVSS1 sg13_lv_nmos ad=0.2516p pd=2.16u as=0.1406p ps=1.12u w=0.74u l=0.13u
X5288 user_project_wrapper_0.IOVSS1 user_project_wrapper_0.IOVSS1 user_project_wrapper_0.IOVSS1 rppd l=0.5u w=0.5u
X5289 user_project_wrapper_0.IOVSS1 a_135844_29676# user_project_wrapper_0.analog_io[10] user_project_wrapper_0.IOVSS1 sg13_hv_nmos ad=1.408p pd=5.04u as=2.596p ps=5.58u w=4.4u l=0.6u
X5290 a_314697_196700# a_314793_201808# a_315347_192648# user_project_wrapper_0.IOVSS1 sg13_lv_nmos ad=1.14p pd=6.38u as=1.14p ps=6.38u w=6u l=6.4u
X5291 user_project_wrapper_0.analog_io[30] a_194687_324142# user_project_wrapper_0.IOVSS1 user_project_wrapper_0.IOVSS1 sg13_lv_pmos ad=1.824p pd=9.98u as=1.824p ps=9.98u w=9.6u l=0.13u
X5292 user_project_wrapper_0.VDD2 user_project_wrapper_0.sg13g2_IOPadVdd_1.sg13g2_RCClampResistor_0.p2 user_project_wrapper_0.sg13g2_IOPadVdd_1.sg13g2_RCClampInverter_noptap_0.out user_project_wrapper_0.VDD2 sg13_hv_pmos ad=1.33p pd=7.38u as=1.33p ps=7.38u w=7u l=0.5u
X5293 VDD3 a_311108_215937# analog_io[23] user_project_wrapper_0.IOVSS1 sg13_lv_nmos ad=3.4p pd=20.68u as=3.4p ps=20.68u w=10u l=0.15u
X5294 VDD3 a_309516_194555# a_309917_194695# VDD3 sg13_lv_pmos ad=0.19p pd=1.38u as=0.19p ps=1.38u w=1u l=0.7u
X5295 user_project_wrapper_0.sg13g2_IOPadIOVdd_1.sg13g2_Clamp_N43N43D4R_0.gate user_project_wrapper_0.sg13g2_IOPadIOVdd_1.sg13g2_RCClampResistor_0.p2 user_project_wrapper_0.IOVDD1 user_project_wrapper_0.IOVDD1 sg13_hv_pmos ad=1.33p pd=7.38u as=1.33p ps=7.38u w=7u l=0.5u
X5296 a_309917_194695# a_296731_189665# a_307232_196607# VDD3 sg13_lv_pmos ad=0.24415p pd=1.665u as=0.24415p ps=1.665u w=1.285u l=0.35u
X5297 user_project_wrapper_0.IOVSS1 a_369296_278644# analog_io[26] user_project_wrapper_0.IOVSS1 sg13_hv_nmos ad=1.408p pd=5.04u as=2.596p ps=5.58u w=4.4u l=0.6u
X5298 user_project_wrapper_0.analog_io[27] a_115444_355624# user_project_wrapper_0.IOVDD4 user_project_wrapper_0.IOVDD4 sg13_hv_pmos ad=3.9294p pd=7.84u as=2.1312p ps=7.3u w=6.66u l=0.6u
X5299 a_296731_189665# a_296625_189595# VDD3 VDD3 sg13_lv_pmos ad=0.2603p pd=1.75u as=0.2603p ps=1.75u w=1.37u l=0.35u
X5300 user_project_wrapper_0.IOVDD1 user_project_wrapper_0.sg13g2_IOPadIOVdd_1.sg13g2_Clamp_N43N43D4R_0.gate user_project_wrapper_0.IOVSS1 user_project_wrapper_0.IOVSS1 sg13_hv_nmos ad=2.596p pd=5.58u as=1.408p ps=5.04u w=4.4u l=0.6u
X5301 user_project_wrapper_0.VDD2 user_project_wrapper_0.sg13g2_IOPadVdd_1.sg13g2_RCClampInverter_noptap_0.out user_project_wrapper_0.IOVSS1 user_project_wrapper_0.IOVSS1 sg13_hv_nmos ad=2.596p pd=5.58u as=1.408p ps=5.04u w=4.4u l=0.6u
X5302 user_project_wrapper_0.sg13g2_IOPadVdd_3.sg13g2_RCClampInverter_noptap_0.out user_project_wrapper_0.sg13g2_IOPadVdd_3.sg13g2_RCClampResistor_0.p2 user_project_wrapper_0.IOVSS1 user_project_wrapper_0.IOVSS1 sg13_hv_pmos ad=1.33p pd=7.38u as=1.33p ps=7.38u w=7u l=0.5u
X5303 a_296625_208423# a_301940_196388# a_296732_200582# VDD3 sg13_lv_pmos ad=0.7695p pd=4.43u as=1.377p ps=8.78u w=4.05u l=0.5u
X5304 user_project_wrapper_0.analog_io[35] a_213870_324142# user_project_wrapper_0.IOVSS1 user_project_wrapper_0.IOVSS1 sg13_lv_pmos ad=1.824p pd=9.98u as=1.824p ps=9.98u w=9.6u l=0.13u
X5305 user_project_wrapper_0.IOVSS1 a_182931_326125# user_project_wrapper_0.analog_io[27] user_project_wrapper_0.IOVSS1 sg13_lv_pmos ad=1.824p pd=9.98u as=1.824p ps=9.98u w=9.6u l=0.13u
X5306 a_296731_208493# a_296625_208423# VDD3 VDD3 sg13_lv_pmos ad=0.2603p pd=1.75u as=0.2603p ps=1.75u w=1.37u l=0.35u
X5307 a_209905_330241# a_208939_329719# user_project_wrapper_0.IOVSS1 w_207883_330166# sg13_lv_pmos ad=0.38p pd=2.38u as=0.68p ps=4.68u w=2u l=0.13u
X5308 user_project_wrapper_0.IOVSS1 user_project_wrapper_0.sg13g2_IOPadIOVdd_3.sg13g2_RCClampResistor_0.p2 user_project_wrapper_0.IOVSS1 user_project_wrapper_0.IOVSS1 sg13_hv_nmos ad=1.71p pd=9.38u as=0 ps=0 w=9u l=9.5u
X5309 user_project_wrapper_0.IOVSS1 user_project_wrapper_0.sg13g2_IOPadVdd_2.sg13g2_RCClampInverter_noptap_0.out user_project_wrapper_0.VDD1 user_project_wrapper_0.IOVSS1 sg13_hv_nmos ad=1.408p pd=5.04u as=2.596p ps=5.58u w=4.4u l=0.6u
X5310 user_project_wrapper_0.IOVSS1 a_87468_125419# a_88393_125210# user_project_wrapper_0.IOVSS1 sg13_lv_nmos ad=0.2516p pd=2.16u as=0.1406p ps=1.12u w=0.74u l=0.13u
X5311 a_210621_326377# a_210417_326377# user_project_wrapper_0.IOVSS1 user_project_wrapper_0.IOVSS1 sg13_lv_nmos ad=0.19p pd=1.38u as=0.34p ps=2.68u w=1u l=0.13u
X5312 a_297775_364458# user_project_wrapper_0.IOVDD4 user_project_wrapper_0.IOVSS1 rppd l=20u w=1u
X5313 user_project_wrapper_0.analog_io[12] a_176644_41476# user_project_wrapper_0.IOVDD2 user_project_wrapper_0.IOVDD2 sg13_hv_pmos ad=3.9294p pd=7.84u as=2.1312p ps=7.3u w=6.66u l=0.6u
X5314 a_313884_211353# analog_io[23] a_311108_215937# user_project_wrapper_0.IOVSS1 sg13_lv_nmos ad=3.4p pd=20.68u as=1.9p ps=10.38u w=10u l=0.5u
X5315 IOVDD3 user_project_wrapper_0.sg13g2_IOPadIOVdd_3.sg13g2_Clamp_N43N43D4R_0.gate user_project_wrapper_0.IOVSS1 user_project_wrapper_0.IOVSS1 sg13_hv_nmos ad=3.256p pd=10.28u as=1.408p ps=5.04u w=4.4u l=0.6u
X5316 user_project_wrapper_0.analog_io[35] a_213870_324142# user_project_wrapper_0.IOVSS1 user_project_wrapper_0.IOVSS1 sg13_lv_pmos ad=1.824p pd=9.98u as=1.824p ps=9.98u w=9.6u l=0.13u
X5317 a_296732_197880# a_301940_196388# a_296625_189595# VDD3 sg13_lv_pmos ad=1.377p pd=8.78u as=0.7695p ps=4.43u w=4.05u l=0.5u
X5318 user_project_wrapper_0.analog_io[29] a_156244_355624# user_project_wrapper_0.IOVDD4 user_project_wrapper_0.IOVDD4 sg13_hv_pmos ad=3.9294p pd=7.84u as=2.1312p ps=7.3u w=6.66u l=0.6u
X5319 user_project_wrapper_0.analog_io[30] a_194687_324142# user_project_wrapper_0.IOVSS1 user_project_wrapper_0.IOVSS1 sg13_lv_pmos ad=1.824p pd=9.98u as=1.824p ps=9.98u w=9.6u l=0.13u
X5320 VDD3 user_project_wrapper_0.sg13g2_IOPadVdd_0.sg13g2_RCClampInverter_noptap_0.out user_project_wrapper_0.IOVSS1 user_project_wrapper_0.IOVSS1 sg13_hv_nmos ad=2.596p pd=5.58u as=1.408p ps=5.04u w=4.4u l=0.6u
X5321 user_project_wrapper_0.analog_io[10] a_135844_41476# user_project_wrapper_0.IOVDD2 user_project_wrapper_0.IOVDD2 sg13_hv_pmos ad=3.9294p pd=7.84u as=3.1302p ps=14.26u w=6.66u l=0.6u
X5322 user_project_wrapper_0.IOVSS1 user_project_wrapper_0.sg13g2_IOPadIOVdd_1.sg13g2_Clamp_N43N43D4R_0.gate user_project_wrapper_0.IOVDD1 user_project_wrapper_0.IOVSS1 sg13_hv_nmos ad=1.408p pd=5.04u as=2.596p ps=5.58u w=4.4u l=0.6u
X5323 user_project_wrapper_0.IOVSS1 user_project_wrapper_0.IOVSS1 user_project_wrapper_0.IOVSS1 rppd l=0.5u w=0.5u
X5324 analog_io[20] a_369296_176644# user_project_wrapper_0.IOVSS1 user_project_wrapper_0.IOVSS1 sg13_hv_nmos ad=2.596p pd=5.58u as=1.408p ps=5.04u w=4.4u l=0.6u
X5325 VDD3 user_project_wrapper_0.sg13g2_IOPadVdd_0.sg13g2_RCClampResistor_0.p2 user_project_wrapper_0.sg13g2_IOPadVdd_0.sg13g2_RCClampInverter_noptap_0.out VDD3 sg13_hv_pmos ad=1.33p pd=7.38u as=1.33p ps=7.38u w=7u l=0.5u
X5326 user_project_wrapper_0.analog_io[5] a_29676_217444# user_project_wrapper_0.IOVSS1 user_project_wrapper_0.IOVSS1 sg13_hv_nmos ad=2.596p pd=5.58u as=2.068p ps=9.74u w=4.4u l=0.6u
X5327 user_project_wrapper_0.sg13g2_IOPadIOVdd_1.sg13g2_Clamp_N43N43D4R_0.gate user_project_wrapper_0.sg13g2_IOPadIOVdd_1.sg13g2_RCClampResistor_0.p2 user_project_wrapper_0.IOVDD1 user_project_wrapper_0.IOVDD1 sg13_hv_pmos ad=1.33p pd=7.38u as=1.33p ps=7.38u w=7u l=0.5u
X5328 user_project_wrapper_0.IOVSS1 user_project_wrapper_0.sg13g2_IOPadVdd_3.sg13g2_RCClampResistor_0.p2 user_project_wrapper_0.sg13g2_IOPadVdd_3.sg13g2_RCClampInverter_noptap_0.out user_project_wrapper_0.IOVSS1 sg13_hv_pmos ad=1.33p pd=7.38u as=1.33p ps=7.38u w=7u l=0.5u
X5329 user_project_wrapper_0.IOVDD2 a_237844_41476# user_project_wrapper_0.analog_io[15] user_project_wrapper_0.IOVDD2 sg13_hv_pmos ad=2.1312p pd=7.3u as=3.9294p ps=7.84u w=6.66u l=0.6u
X5330 a_182931_326125# a_186202_326221# user_project_wrapper_0.IOVSS1 user_project_wrapper_0.IOVSS1 sg13_lv_nmos ad=0.912p pd=5.18u as=0.912p ps=5.18u w=4.8u l=0.13u
X5331 user_project_wrapper_0.analog_io[34] a_258244_355624# user_project_wrapper_0.IOVDD4 user_project_wrapper_0.IOVDD4 sg13_hv_pmos ad=3.9294p pd=7.84u as=2.1312p ps=7.3u w=6.66u l=0.6u
X5332 user_project_wrapper_0.analog_io[29] a_156244_369296# user_project_wrapper_0.IOVSS1 user_project_wrapper_0.IOVSS1 sg13_hv_nmos ad=2.596p pd=5.58u as=1.408p ps=5.04u w=4.4u l=0.6u
X5333 a_190297_328605# a_189756_328605# user_project_wrapper_0.IOVSS1 user_project_wrapper_0.IOVSS1 sg13_lv_nmos ad=0.34p pd=2.68u as=0.34p ps=2.68u w=1u l=0.13u
X5334 VDD3 a_309516_194555# a_309917_194695# VDD3 sg13_lv_pmos ad=0.19p pd=1.38u as=0.19p ps=1.38u w=1u l=0.7u
X5335 user_project_wrapper_0.analog_io[12] a_176644_41476# user_project_wrapper_0.IOVDD2 user_project_wrapper_0.IOVDD2 sg13_hv_pmos ad=3.9294p pd=7.84u as=2.1312p ps=7.3u w=6.66u l=0.6u
X5336 user_project_wrapper_0.IOVSS1 user_project_wrapper_0.sg13g2_IOPadIOVdd_3.sg13g2_RCClampResistor_0.p2 user_project_wrapper_0.IOVSS1 user_project_wrapper_0.IOVSS1 sg13_hv_nmos ad=1.71p pd=9.38u as=0 ps=0 w=9u l=9.5u
X5337 user_project_wrapper_0.IOVSS1 a_213870_324142# user_project_wrapper_0.analog_io[35] user_project_wrapper_0.IOVSS1 sg13_lv_nmos ad=1.632p pd=10.28u as=0.912p ps=5.18u w=4.8u l=0.13u
X5338 user_project_wrapper_0.IOVSS1 user_project_wrapper_0.sg13g2_IOPadVdd_1.sg13g2_RCClampInverter_noptap_0.out user_project_wrapper_0.VDD2 user_project_wrapper_0.IOVSS1 sg13_hv_nmos ad=1.408p pd=5.04u as=2.596p ps=5.58u w=4.4u l=0.6u
X5339 user_project_wrapper_0.IOVDD4 a_237844_355624# user_project_wrapper_0.analog_io[33] user_project_wrapper_0.IOVDD4 sg13_hv_pmos ad=2.1312p pd=7.3u as=3.9294p ps=7.84u w=6.66u l=0.6u
X5340 user_project_wrapper_0.VDD1 a_78824_126541# a_78824_126541# user_project_wrapper_0.VDD1 sg13_lv_pmos ad=1.7p pd=10.68u as=0.95p ps=5.38u w=5u l=0.15u
X5341 user_project_wrapper_0.analog_io[11] a_156244_29676# user_project_wrapper_0.IOVSS1 user_project_wrapper_0.IOVSS1 sg13_hv_nmos ad=2.596p pd=5.58u as=1.408p ps=5.04u w=4.4u l=0.6u
X5342 VDD3 a_296625_189595# a_296731_189665# VDD3 sg13_lv_pmos ad=0.2603p pd=1.75u as=0.2603p ps=1.75u w=1.37u l=0.35u
X5343 user_project_wrapper_0.IOVSS1 user_project_wrapper_0.sg13g2_IOPadVdd_3.sg13g2_RCClampInverter_noptap_0.out user_project_wrapper_0.IOVSS1 user_project_wrapper_0.IOVSS1 sg13_hv_nmos ad=1.408p pd=5.04u as=0 ps=0 w=4.4u l=0.6u
X5344 user_project_wrapper_0.analog_io[35] a_213870_324142# user_project_wrapper_0.IOVSS1 user_project_wrapper_0.IOVSS1 sg13_lv_pmos ad=1.824p pd=9.98u as=1.824p ps=9.98u w=9.6u l=0.13u
X5345 user_project_wrapper_0.IOVDD2 a_135844_41476# user_project_wrapper_0.analog_io[10] user_project_wrapper_0.IOVDD2 sg13_hv_pmos ad=3.1302p pd=14.26u as=3.9294p ps=7.84u w=6.66u l=0.6u
X5346 user_project_wrapper_0.IOVSS1 user_project_wrapper_0.sg13g2_IOPadAnalog_21.padres a_209041_329327# user_project_wrapper_0.IOVSS1 sg13_lv_nmos ad=0.34p pd=2.68u as=0.19p ps=1.38u w=1u l=0.13u
X5347 analog_io[25] a_369296_258244# user_project_wrapper_0.IOVSS1 user_project_wrapper_0.IOVSS1 sg13_hv_nmos ad=2.596p pd=5.58u as=1.408p ps=5.04u w=4.4u l=0.6u
X5348 a_211928_324776# TOP_ROILIFNEURON_0.MEM user_project_wrapper_0.IOVSS1 user_project_wrapper_0.IOVSS1 sg13_lv_nmos ad=0.19p pd=1.38u as=0.19p ps=1.38u w=1u l=0.13u
X5349 user_project_wrapper_0.IOVSS1 a_369296_197044# analog_io[22] user_project_wrapper_0.IOVSS1 sg13_hv_nmos ad=1.408p pd=5.04u as=2.596p ps=5.58u w=4.4u l=0.6u
X5350 analog_io[20] a_355624_176644# IOVDD3 IOVDD3 sg13_hv_pmos ad=3.9294p pd=7.84u as=2.1312p ps=7.3u w=6.66u l=0.6u
X5351 a_309917_199879# a_309516_194555# VDD3 VDD3 sg13_lv_pmos ad=0.19p pd=1.38u as=0.19p ps=1.38u w=1u l=0.7u
X5352 user_project_wrapper_0.IOVSS1 user_project_wrapper_0.sg13g2_IOPadIOVdd_0.sg13g2_Clamp_N43N43D4R_0.gate user_project_wrapper_0.IOVDD2 user_project_wrapper_0.IOVSS1 sg13_hv_nmos ad=1.408p pd=5.04u as=2.596p ps=5.58u w=4.4u l=0.6u
X5353 user_project_wrapper_0.IOVDD2 a_197044_41476# user_project_wrapper_0.analog_io[13] user_project_wrapper_0.IOVDD2 sg13_hv_pmos ad=2.1312p pd=7.3u as=3.9294p ps=7.84u w=6.66u l=0.6u
X5354 user_project_wrapper_0.IOVSS1 user_project_wrapper_0.sg13g2_IOPadIOVdd_0.sg13g2_Clamp_N43N43D4R_0.gate user_project_wrapper_0.IOVDD2 user_project_wrapper_0.IOVSS1 sg13_hv_nmos ad=1.408p pd=5.04u as=2.596p ps=5.58u w=4.4u l=0.6u
X5355 a_278644_29676# user_project_wrapper_0.IOVSS1 user_project_wrapper_0.IOVSS1 rppd l=3.54u w=0.5u
X5356 VDD3 a_296625_208423# a_296731_208493# VDD3 sg13_lv_pmos ad=0.2603p pd=1.75u as=0.2603p ps=1.75u w=1.37u l=0.35u
X5357 user_project_wrapper_0.VDD1 user_project_wrapper_0.sg13g2_IOPadVdd_2.sg13g2_RCClampInverter_noptap_0.out user_project_wrapper_0.IOVSS1 user_project_wrapper_0.IOVSS1 sg13_hv_nmos ad=2.596p pd=5.58u as=1.408p ps=5.04u w=4.4u l=0.6u
X5358 QDLL_TOP_0.VDD a_190218_98097# a_190490_98199# QDLL_TOP_0.VDD sg13_lv_pmos ad=0.2128p pd=1.5u as=0.3808p ps=2.92u w=1.12u l=0.13u
X5359 VDD3 a_296625_208423# a_296731_208493# VDD3 sg13_lv_pmos ad=0.2603p pd=1.75u as=0.2603p ps=1.75u w=1.37u l=0.35u
X5360 a_191438_325263# TOP_ROILIFNEURON_0.MEM user_project_wrapper_0.IOVSS1 rppd l=0.5u w=0.5u
X5361 user_project_wrapper_0.IOVSS1 user_project_wrapper_0.sg13g2_IOPadIOVdd_2.sg13g2_Clamp_N43N43D4R_0.gate user_project_wrapper_0.IOVDD4 user_project_wrapper_0.IOVSS1 sg13_hv_nmos ad=1.408p pd=5.04u as=2.596p ps=5.58u w=4.4u l=0.6u
X5362 VDD3 a_309516_194555# a_309917_194695# VDD3 sg13_lv_pmos ad=0.19p pd=1.38u as=0.19p ps=1.38u w=1u l=0.7u
X5363 user_project_wrapper_0.IOVSS1 a_307232_196607# a_304995_198817# user_project_wrapper_0.IOVSS1 sg13_lv_nmos ad=0.6327p pd=3.71u as=0.6327p ps=3.71u w=3.33u l=0.2u
X5364 analog_io[26] a_355624_278644# IOVDD3 IOVDD3 sg13_hv_pmos ad=3.9294p pd=7.84u as=2.1312p ps=7.3u w=6.66u l=0.6u
X5365 a_296731_208493# a_301186_192011# user_project_wrapper_0.IOVSS1 user_project_wrapper_0.IOVSS1 sg13_lv_nmos ad=0.912p pd=5.18u as=1.632p ps=10.28u w=4.8u l=1.06u
X5366 VDD3 a_296625_208423# a_296731_208493# VDD3 sg13_lv_pmos ad=0.2603p pd=1.75u as=0.2603p ps=1.75u w=1.37u l=0.35u
X5367 a_296625_208423# a_304090_197941# a_304196_200821# user_project_wrapper_0.IOVSS1 sg13_lv_nmos ad=0.361p pd=2.28u as=0.361p ps=2.28u w=1.9u l=0.16u
X5368 user_project_wrapper_0.VDD1 user_project_wrapper_0.sg13g2_IOPadVdd_2.sg13g2_RCClampInverter_noptap_0.out user_project_wrapper_0.IOVSS1 user_project_wrapper_0.IOVSS1 sg13_hv_nmos ad=2.596p pd=5.58u as=1.408p ps=5.04u w=4.4u l=0.6u
X5369 a_191234_325263# a_190824_325263# user_project_wrapper_0.IOVSS1 user_project_wrapper_0.IOVSS1 sg13_lv_nmos ad=0.34p pd=2.68u as=0.34p ps=2.68u w=1u l=0.13u
X5370 user_project_wrapper_0.IOVSS1 a_369296_176644# analog_io[20] user_project_wrapper_0.IOVSS1 sg13_hv_nmos ad=1.408p pd=5.04u as=2.596p ps=5.58u w=4.4u l=0.6u
X5371 a_301423_202742# a_296625_208423# user_project_wrapper_0.IOVSS1 rppd l=0.55u w=1.5u
X5372 user_project_wrapper_0.IOVSS1 a_189396_324119# a_188988_324119# w_188806_323975# sg13_lv_pmos ad=0.68p pd=4.68u as=0.68p ps=4.68u w=2u l=0.13u
X5373 a_190824_328605# a_189184_328605# a_190722_329327# user_project_wrapper_0.IOVSS1 sg13_lv_nmos ad=0.19p pd=1.38u as=0.19p ps=1.38u w=1u l=0.13u
X5374 user_project_wrapper_0.IOVSS1 a_29676_217444# user_project_wrapper_0.analog_io[5] user_project_wrapper_0.IOVSS1 sg13_hv_nmos ad=1.408p pd=5.04u as=2.596p ps=5.58u w=4.4u l=0.6u
X5375 user_project_wrapper_0.IOVSS1 user_project_wrapper_0.IOVSS1 user_project_wrapper_0.IOVSS1 rppd l=0.5u w=0.5u
X5376 user_project_wrapper_0.IOVSS1 a_278644_369296# user_project_wrapper_0.analog_io[35] user_project_wrapper_0.IOVSS1 sg13_hv_nmos ad=1.408p pd=5.04u as=2.596p ps=5.58u w=4.4u l=0.6u
X5377 user_project_wrapper_0.analog_io[34] a_258244_355624# user_project_wrapper_0.IOVDD4 user_project_wrapper_0.IOVDD4 sg13_hv_pmos ad=3.9294p pd=7.84u as=2.1312p ps=7.3u w=6.66u l=0.6u
X5378 analog_io[25] a_355624_258244# IOVDD3 IOVDD3 sg13_hv_pmos ad=3.9294p pd=7.84u as=2.1312p ps=7.3u w=6.66u l=0.6u
X5379 user_project_wrapper_0.IOVSS1 a_115444_369296# user_project_wrapper_0.analog_io[27] user_project_wrapper_0.IOVSS1 sg13_hv_nmos ad=1.408p pd=5.04u as=2.596p ps=5.58u w=4.4u l=0.6u
X5380 user_project_wrapper_0.analog_io[32] a_202114_326125# user_project_wrapper_0.IOVSS1 user_project_wrapper_0.IOVSS1 sg13_lv_pmos ad=1.824p pd=9.98u as=1.824p ps=9.98u w=9.6u l=0.13u
X5381 user_project_wrapper_0.analog_io[1] a_29676_135844# user_project_wrapper_0.IOVSS1 user_project_wrapper_0.IOVSS1 sg13_hv_nmos ad=2.596p pd=5.58u as=1.408p ps=5.04u w=4.4u l=0.6u
X5382 VDD3 a_309516_194555# a_309917_194695# VDD3 sg13_lv_pmos ad=0.19p pd=1.38u as=0.19p ps=1.38u w=1u l=0.7u
X5383 user_project_wrapper_0.VDD1 user_project_wrapper_0.sg13g2_IOPadVdd_2.sg13g2_RCClampResistor_0.p2 user_project_wrapper_0.sg13g2_IOPadVdd_2.sg13g2_RCClampInverter_noptap_0.out user_project_wrapper_0.VDD1 sg13_hv_pmos ad=1.33p pd=7.38u as=1.33p ps=7.38u w=7u l=0.5u
X5384 user_project_wrapper_0.IOVDD4 user_project_wrapper_0.sg13g2_IOPadIOVdd_2.sg13g2_Clamp_N43N43D4R_0.gate user_project_wrapper_0.IOVSS1 user_project_wrapper_0.IOVSS1 sg13_hv_nmos ad=2.596p pd=5.58u as=1.408p ps=5.04u w=4.4u l=0.6u
X5385 user_project_wrapper_0.IOVDD4 a_237844_355624# user_project_wrapper_0.analog_io[33] user_project_wrapper_0.IOVDD4 sg13_hv_pmos ad=2.1312p pd=7.3u as=3.9294p ps=7.84u w=6.66u l=0.6u
X5386 user_project_wrapper_0.analog_io[0] a_41476_115444# user_project_wrapper_0.IOVDD1 user_project_wrapper_0.IOVDD1 sg13_hv_pmos ad=3.9294p pd=7.84u as=2.1312p ps=7.3u w=6.66u l=0.6u
X5387 user_project_wrapper_0.sg13g2_IOPadAnalog_19.padres user_project_wrapper_0.IOVDD4 dpantenna l=0.64u w=4.98u
X5388 user_project_wrapper_0.analog_io[1] a_41476_135844# user_project_wrapper_0.IOVDD1 user_project_wrapper_0.IOVDD1 sg13_hv_pmos ad=3.9294p pd=7.84u as=2.1312p ps=7.3u w=6.66u l=0.6u
X5389 a_304995_198817# a_307232_196607# user_project_wrapper_0.IOVSS1 user_project_wrapper_0.IOVSS1 sg13_lv_nmos ad=0.6327p pd=3.71u as=0.6327p ps=3.71u w=3.33u l=0.2u
X5390 user_project_wrapper_0.analog_io[12] a_176644_41476# user_project_wrapper_0.IOVDD2 user_project_wrapper_0.IOVDD2 sg13_hv_pmos ad=3.9294p pd=7.84u as=2.1312p ps=7.3u w=6.66u l=0.6u
X5391 user_project_wrapper_0.analog_io[14] a_190389_99046# user_project_wrapper_0.IOVSS1 user_project_wrapper_0.IOVSS1 sg13_lv_nmos ad=0.1406p pd=1.12u as=0.1406p ps=1.12u w=0.74u l=0.13u
X5392 VDD3 a_296625_208423# a_296731_208493# VDD3 sg13_lv_pmos ad=0.2603p pd=1.75u as=0.2603p ps=1.75u w=1.37u l=0.35u
X5393 a_208939_325263# user_project_wrapper_0.IOVSS1 user_project_wrapper_0.IOVSS1 w_207887_326203# sg13_lv_pmos ad=0.38p pd=2.38u as=0.68p ps=4.68u w=2u l=0.13u
X5394 user_project_wrapper_0.VDD2 user_project_wrapper_0.sg13g2_IOPadVdd_1.sg13g2_RCClampInverter_noptap_0.out user_project_wrapper_0.IOVSS1 user_project_wrapper_0.IOVSS1 sg13_hv_nmos ad=2.596p pd=5.58u as=1.408p ps=5.04u w=4.4u l=0.6u
X5395 user_project_wrapper_0.sg13g2_IOPadIOVdd_1.sg13g2_Clamp_N43N43D4R_0.gate user_project_wrapper_0.sg13g2_IOPadIOVdd_1.sg13g2_RCClampResistor_0.p2 user_project_wrapper_0.IOVDD1 user_project_wrapper_0.IOVDD1 sg13_hv_pmos ad=1.33p pd=7.38u as=1.33p ps=7.38u w=7u l=0.5u
X5396 VDD3 user_project_wrapper_0.sg13g2_IOPadVdd_0.sg13g2_RCClampInverter_noptap_0.out user_project_wrapper_0.IOVSS1 user_project_wrapper_0.IOVSS1 sg13_hv_nmos ad=3.256p pd=10.28u as=1.408p ps=5.04u w=4.4u l=0.6u
X5397 user_project_wrapper_0.IOVSS1 user_project_wrapper_0.analog_io[1] dantenna l=27.78u w=1.26u
X5398 user_project_wrapper_0.analog_io[11] a_156244_29676# user_project_wrapper_0.IOVSS1 user_project_wrapper_0.IOVSS1 sg13_hv_nmos ad=2.596p pd=5.58u as=1.408p ps=5.04u w=4.4u l=0.6u
X5399 a_208469_327491# a_208367_328605# a_208367_327491# user_project_wrapper_0.IOVSS1 sg13_lv_nmos ad=0.19p pd=1.38u as=0.19p ps=1.38u w=1u l=0.13u
X5400 user_project_wrapper_0.IOVDD2 a_278644_41476# QDLL_TOP_0.VOUT user_project_wrapper_0.IOVDD2 sg13_hv_pmos ad=2.1312p pd=7.3u as=3.9294p ps=7.84u w=6.66u l=0.6u
X5401 user_project_wrapper_0.IOVDD1 user_project_wrapper_0.sg13g2_IOPadOut4mA$1_0.sg13g2_GateLevelUpInv_noptap$1$1_0.pgate user_project_wrapper_0.uo_PAD[3] user_project_wrapper_0.IOVDD1 sg13_hv_pmos ad=3.1302p pd=14.26u as=3.9294p ps=7.84u w=6.66u l=0.6u
X5402 a_82348_128838# a_79025_131741# user_project_wrapper_0.IOVSS1 user_project_wrapper_0.IOVSS1 sg13_lv_nmos ad=0.2516p pd=2.16u as=0.2516p ps=2.16u w=0.74u l=0.13u
X5403 user_project_wrapper_0.IOVSS1 user_project_wrapper_0.sg13g2_IOPadAnalog_30.padres dantenna l=3.1u w=0.64u
X5404 analog_io[20] a_369296_176644# user_project_wrapper_0.IOVSS1 user_project_wrapper_0.IOVSS1 sg13_hv_nmos ad=2.596p pd=5.58u as=1.408p ps=5.04u w=4.4u l=0.6u
X5405 a_79038_130492# user_project_wrapper_0.sg13g2_IOPadAnalog_9.padres a_79025_131334# user_project_wrapper_0.VDD1 sg13_lv_pmos ad=0.95p pd=5.38u as=1.7p ps=10.68u w=5u l=0.3u
X5406 user_project_wrapper_0.analog_io[32] a_202114_326125# user_project_wrapper_0.IOVSS1 user_project_wrapper_0.IOVSS1 sg13_lv_pmos ad=1.824p pd=9.98u as=1.824p ps=9.98u w=9.6u l=0.13u
X5407 user_project_wrapper_0.IOVSS1 a_213462_327536# a_213870_324142# user_project_wrapper_0.IOVSS1 sg13_lv_nmos ad=0.912p pd=5.18u as=0.912p ps=5.18u w=4.8u l=0.13u
X5408 user_project_wrapper_0.IOVDD4 a_115444_355624# user_project_wrapper_0.analog_io[27] user_project_wrapper_0.IOVDD4 sg13_hv_pmos ad=2.1312p pd=7.3u as=3.9294p ps=7.84u w=6.66u l=0.6u
X5409 user_project_wrapper_0.IOVSS1 user_project_wrapper_0.IOVDD4 dpantenna l=27.78u w=1.26u
X5410 user_project_wrapper_0.IOVSS1 user_project_wrapper_0.IOVSS1 user_project_wrapper_0.IOVSS1 rppd l=0.5u w=0.5u
X5411 IOVDD3 a_355624_278644# analog_io[26] IOVDD3 sg13_hv_pmos ad=2.1312p pd=7.3u as=3.9294p ps=7.84u w=6.66u l=0.6u
X5412 a_79038_126152# user_project_wrapper_0.sg13g2_IOPadAnalog_9.padres a_79025_126994# user_project_wrapper_0.VDD1 sg13_lv_pmos ad=0.95p pd=5.38u as=1.7p ps=10.68u w=5u l=0.3u
X5413 user_project_wrapper_0.IOVSS1 a_301186_192011# a_296731_189665# user_project_wrapper_0.IOVSS1 sg13_lv_nmos ad=0.912p pd=5.18u as=1.632p ps=10.28u w=4.8u l=1.06u
X5414 a_296732_200582# a_296626_197740# VDD3 VDD3 sg13_lv_pmos ad=1.33p pd=7.38u as=1.33p ps=7.38u w=7u l=0.7u
X5415 user_project_wrapper_0.IOVSS1 user_project_wrapper_0.sg13g2_IOPadIOVdd_1.sg13g2_Clamp_N43N43D4R_0.gate user_project_wrapper_0.IOVDD1 user_project_wrapper_0.IOVSS1 sg13_hv_nmos ad=1.408p pd=5.04u as=2.596p ps=5.58u w=4.4u l=0.6u
X5416 user_project_wrapper_0.IOVSS1 user_project_wrapper_0.sg13g2_IOPadIOVdd_2.sg13g2_Clamp_N43N43D4R_0.gate user_project_wrapper_0.IOVDD4 user_project_wrapper_0.IOVSS1 sg13_hv_nmos ad=1.408p pd=5.04u as=2.596p ps=5.58u w=4.4u l=0.6u
X5417 user_project_wrapper_0.IOVSS1 a_213462_327536# a_213870_324142# user_project_wrapper_0.IOVSS1 sg13_lv_nmos ad=0.912p pd=5.18u as=0.912p ps=5.18u w=4.8u l=0.13u
X5418 user_project_wrapper_0.IOVSS1 user_project_wrapper_0.sg13g2_IOPadVdd_0.sg13g2_RCClampInverter_noptap_0.out VDD3 user_project_wrapper_0.IOVSS1 sg13_hv_nmos ad=1.408p pd=5.04u as=2.596p ps=5.58u w=4.4u l=0.6u
X5419 user_project_wrapper_0.IOVSS1 user_project_wrapper_0.sg13g2_IOPadVdd_2.sg13g2_RCClampInverter_noptap_0.out user_project_wrapper_0.VDD1 user_project_wrapper_0.IOVSS1 sg13_hv_nmos ad=1.408p pd=5.04u as=2.596p ps=5.58u w=4.4u l=0.6u
X5420 analog_io[22] a_355624_197044# IOVDD3 IOVDD3 sg13_hv_pmos ad=3.9294p pd=7.84u as=2.1312p ps=7.3u w=6.66u l=0.6u
X5421 a_202114_326125# a_205385_326221# user_project_wrapper_0.IOVSS1 user_project_wrapper_0.IOVSS1 sg13_lv_pmos ad=1.824p pd=9.98u as=1.824p ps=9.98u w=9.6u l=0.13u
X5422 user_project_wrapper_0.IOVDD2 a_156244_41476# user_project_wrapper_0.analog_io[11] user_project_wrapper_0.IOVDD2 sg13_hv_pmos ad=2.1312p pd=7.3u as=3.9294p ps=7.84u w=6.66u l=0.6u
X5423 a_296731_208493# a_296625_208423# VDD3 VDD3 sg13_lv_pmos ad=0.2603p pd=1.75u as=0.2603p ps=1.75u w=1.37u l=0.35u
X5424 user_project_wrapper_0.IOVSS1 a_194687_324142# user_project_wrapper_0.analog_io[30] user_project_wrapper_0.IOVSS1 sg13_lv_nmos ad=0.912p pd=5.18u as=0.912p ps=5.18u w=4.8u l=0.13u
X5425 user_project_wrapper_0.analog_io[30] a_176644_355624# user_project_wrapper_0.IOVDD4 user_project_wrapper_0.IOVDD4 sg13_hv_pmos ad=3.9294p pd=7.84u as=2.1312p ps=7.3u w=6.66u l=0.6u
X5426 a_208367_328605# user_project_wrapper_0.IOVSS1 user_project_wrapper_0.IOVSS1 w_207887_327938# sg13_lv_pmos ad=0.38p pd=2.38u as=0.68p ps=4.68u w=2u l=0.13u
X5427 user_project_wrapper_0.analog_io[6] a_41476_237844# user_project_wrapper_0.IOVDD1 user_project_wrapper_0.IOVDD1 sg13_hv_pmos ad=3.9294p pd=7.84u as=2.1312p ps=7.3u w=6.66u l=0.6u
X5428 a_85257_125209# a_85211_124842# a_85155_125209# user_project_wrapper_0.IOVSS1 sg13_lv_nmos ad=0.1406p pd=1.12u as=0.1406p ps=1.12u w=0.74u l=0.13u
X5429 user_project_wrapper_0.IOVSS1 a_29676_135844# user_project_wrapper_0.analog_io[1] user_project_wrapper_0.IOVSS1 sg13_hv_nmos ad=1.408p pd=5.04u as=2.596p ps=5.58u w=4.4u l=0.6u
X5430 user_project_wrapper_0.IOVSS1 a_197044_29676# user_project_wrapper_0.analog_io[13] user_project_wrapper_0.IOVSS1 sg13_hv_nmos ad=1.408p pd=5.04u as=2.596p ps=5.58u w=4.4u l=0.6u
X5431 user_project_wrapper_0.IOVDD4 a_156244_355624# user_project_wrapper_0.analog_io[29] user_project_wrapper_0.IOVDD4 sg13_hv_pmos ad=2.1312p pd=7.3u as=3.9294p ps=7.84u w=6.66u l=0.6u
X5432 user_project_wrapper_0.IOVSS1 user_project_wrapper_0.sg13g2_IOPadVdd_0.sg13g2_RCClampInverter_noptap_0.out VDD3 user_project_wrapper_0.IOVSS1 sg13_hv_nmos ad=1.408p pd=5.04u as=2.596p ps=5.58u w=4.4u l=0.6u
X5433 user_project_wrapper_0.sg13g2_IOPadOut4mA$1_1.sg13g2_GateLevelUpInv_noptap$1$1_0.pgate user_project_wrapper_0.IOVDD1 dpantenna l=0.48u w=0.48u
X5434 user_project_wrapper_0.sg13g2_IOPadAnalog_26.padres IOVDD3 dpantenna l=4.98u w=0.64u
X5435 user_project_wrapper_0.sg13g2_IOPadIOVdd_1.sg13g2_Clamp_N43N43D4R_0.gate user_project_wrapper_0.sg13g2_IOPadIOVdd_1.sg13g2_RCClampResistor_0.p2 user_project_wrapper_0.IOVDD1 user_project_wrapper_0.IOVDD1 sg13_hv_pmos ad=1.33p pd=7.38u as=1.33p ps=7.38u w=7u l=0.5u
X5436 user_project_wrapper_0.IOVSS1 user_project_wrapper_0.sg13g2_IOPadVdd_1.sg13g2_RCClampInverter_noptap_0.out user_project_wrapper_0.VDD2 user_project_wrapper_0.IOVSS1 sg13_hv_nmos ad=1.408p pd=5.04u as=2.596p ps=5.58u w=4.4u l=0.6u
X5437 analog_io[26] a_355624_278644# IOVDD3 IOVDD3 sg13_hv_pmos ad=3.9294p pd=7.84u as=2.1312p ps=7.3u w=6.66u l=0.6u
X5438 a_35456_305695# a_39542_305365# user_project_wrapper_0.IOVSS1 rppd l=20u w=1u
X5439 a_296731_189665# a_296625_189595# VDD3 VDD3 sg13_lv_pmos ad=0.2603p pd=1.75u as=0.4658p ps=3.42u w=1.37u l=0.35u
X5440 analog_io[26] IOVDD3 dpantenna l=27.78u w=1.26u
X5441 user_project_wrapper_0.IOVSS1 user_project_wrapper_0.IOVDD2 dpantenna l=27.78u w=1.26u
X5442 a_309917_199879# a_309516_194555# VDD3 VDD3 sg13_lv_pmos ad=0.19p pd=1.38u as=0.19p ps=1.38u w=1u l=0.7u
X5443 user_project_wrapper_0.IOVSS1 a_213870_324142# user_project_wrapper_0.analog_io[35] user_project_wrapper_0.IOVSS1 sg13_lv_nmos ad=0.912p pd=5.18u as=0.912p ps=5.18u w=4.8u l=0.13u
X5444 analog_io[19] a_355624_135844# IOVDD3 IOVDD3 sg13_hv_pmos ad=3.9294p pd=7.84u as=2.1312p ps=7.3u w=6.66u l=0.6u
X5445 user_project_wrapper_0.analog_io[27] a_182931_326125# user_project_wrapper_0.IOVSS1 user_project_wrapper_0.IOVSS1 sg13_lv_nmos ad=0.912p pd=5.18u as=0.912p ps=5.18u w=4.8u l=0.13u
X5446 a_88291_125210# a_86507_127725# a_87851_125174# user_project_wrapper_0.IOVSS1 sg13_lv_nmos ad=0.1406p pd=1.12u as=0.1406p ps=1.12u w=0.74u l=0.13u
X5447 a_210417_326377# a_210007_326377# user_project_wrapper_0.IOVSS1 user_project_wrapper_0.IOVSS1 sg13_lv_nmos ad=0.34p pd=2.68u as=0.34p ps=2.68u w=1u l=0.13u
X5448 a_311846_195517# user_project_wrapper_0.sg13g2_IOPadAnalog_29.padres a_309917_194695# VDD3 sg13_lv_pmos ad=0.24415p pd=1.665u as=0.24415p ps=1.665u w=1.285u l=0.35u
X5449 a_296626_197740# a_296626_197740# VDD3 VDD3 sg13_lv_pmos ad=0.266p pd=1.78u as=0.476p ps=3.48u w=1.4u l=0.35u
X5450 user_project_wrapper_0.sg13g2_IOPadIOVdd_1.sg13g2_Clamp_N43N43D4R_0.gate user_project_wrapper_0.sg13g2_IOPadIOVdd_1.sg13g2_RCClampResistor_0.p2 user_project_wrapper_0.IOVDD1 user_project_wrapper_0.IOVDD1 sg13_hv_pmos ad=1.33p pd=7.38u as=1.33p ps=7.38u w=7u l=0.5u
X5451 a_309917_194695# a_309516_194555# VDD3 VDD3 sg13_lv_pmos ad=0.19p pd=1.38u as=0.19p ps=1.38u w=1u l=0.7u
X5452 user_project_wrapper_0.analog_io[30] a_194687_324142# user_project_wrapper_0.IOVSS1 user_project_wrapper_0.IOVSS1 sg13_lv_pmos ad=1.824p pd=9.98u as=1.824p ps=9.98u w=9.6u l=0.13u
X5453 user_project_wrapper_0.analog_io[14] a_190389_99046# user_project_wrapper_0.IOVSS1 user_project_wrapper_0.IOVSS1 sg13_lv_nmos ad=0.1406p pd=1.12u as=0.2516p ps=2.16u w=0.74u l=0.13u
X5454 user_project_wrapper_0.IOVSS1 user_project_wrapper_0.sg13g2_IOPadIOVdd_0.sg13g2_Clamp_N43N43D4R_0.gate user_project_wrapper_0.IOVDD2 user_project_wrapper_0.IOVSS1 sg13_hv_nmos ad=1.408p pd=5.04u as=2.596p ps=5.58u w=4.4u l=0.6u
X5455 user_project_wrapper_0.IOVSS1 user_project_wrapper_0.sg13g2_IOPadIOVdd_1.sg13g2_Clamp_N43N43D4R_0.gate user_project_wrapper_0.IOVDD1 user_project_wrapper_0.IOVSS1 sg13_hv_nmos ad=1.408p pd=5.04u as=2.596p ps=5.58u w=4.4u l=0.6u
X5456 user_project_wrapper_0.IOVSS1 a_301186_192011# a_296731_189665# user_project_wrapper_0.IOVSS1 sg13_lv_nmos ad=1.632p pd=10.28u as=0.912p ps=5.18u w=4.8u l=1.06u
X5457 analog_io[23] a_369296_237844# user_project_wrapper_0.IOVSS1 user_project_wrapper_0.IOVSS1 sg13_hv_nmos ad=2.596p pd=5.58u as=2.068p ps=9.74u w=4.4u l=0.6u
X5458 user_project_wrapper_0.IOVSS1 user_project_wrapper_0.sg13g2_IOPadVdd_0.sg13g2_RCClampResistor_0.p2 user_project_wrapper_0.IOVSS1 user_project_wrapper_0.IOVSS1 sg13_hv_nmos ad=1.71p pd=9.38u as=0 ps=0 w=9u l=9.5u
X5459 user_project_wrapper_0.IOVDD1 a_41476_197044# user_project_wrapper_0.analog_io[4] user_project_wrapper_0.IOVDD1 sg13_hv_pmos ad=2.1312p pd=7.3u as=3.9294p ps=7.84u w=6.66u l=0.6u
X5460 user_project_wrapper_0.analog_io[7] a_41476_258244# user_project_wrapper_0.IOVDD1 user_project_wrapper_0.IOVDD1 sg13_hv_pmos ad=3.9294p pd=7.84u as=2.1312p ps=7.3u w=6.66u l=0.6u
X5461 a_296731_208493# a_296625_208423# VDD3 VDD3 sg13_lv_pmos ad=0.2603p pd=1.75u as=0.2603p ps=1.75u w=1.37u l=0.35u
X5462 a_296732_197880# a_296626_197740# VDD3 VDD3 sg13_lv_pmos ad=1.33p pd=7.38u as=1.33p ps=7.38u w=7u l=0.7u
X5463 VDD3 a_296625_189595# a_296731_189665# VDD3 sg13_lv_pmos ad=0.2603p pd=1.75u as=0.2603p ps=1.75u w=1.37u l=0.35u
X5464 user_project_wrapper_0.IOVDD1 a_41476_237844# user_project_wrapper_0.analog_io[6] user_project_wrapper_0.IOVDD1 sg13_hv_pmos ad=2.1312p pd=7.3u as=3.9294p ps=7.84u w=6.66u l=0.6u
X5465 a_194687_324142# a_194279_327536# user_project_wrapper_0.IOVSS1 user_project_wrapper_0.IOVSS1 sg13_lv_nmos ad=0.912p pd=5.18u as=0.912p ps=5.18u w=4.8u l=0.13u
X5466 user_project_wrapper_0.IOVSS1 user_project_wrapper_0.analog_io[34] dantenna l=1.26u w=27.78u
X5467 a_296732_197880# a_296626_197740# VDD3 VDD3 sg13_lv_pmos ad=1.33p pd=7.38u as=1.33p ps=7.38u w=7u l=0.7u
X5468 user_project_wrapper_0.IOVSS1 a_301186_192011# a_296731_189665# user_project_wrapper_0.IOVSS1 sg13_lv_nmos ad=0.912p pd=5.18u as=0.912p ps=5.18u w=4.8u l=1.06u
X5469 user_project_wrapper_0.VDD2 user_project_wrapper_0.sg13g2_IOPadVdd_1.sg13g2_RCClampResistor_0.p2 user_project_wrapper_0.sg13g2_IOPadVdd_1.sg13g2_RCClampInverter_noptap_0.out user_project_wrapper_0.VDD2 sg13_hv_pmos ad=1.33p pd=7.38u as=1.33p ps=7.38u w=7u l=0.5u
X5470 VDD3 a_296625_208423# a_296731_208493# VDD3 sg13_lv_pmos ad=0.4658p pd=3.42u as=0.2603p ps=1.75u w=1.37u l=0.35u
X5471 user_project_wrapper_0.IOVSS1 a_307232_196607# a_304995_198817# user_project_wrapper_0.IOVSS1 sg13_lv_nmos ad=0.6327p pd=3.71u as=0.6327p ps=3.71u w=3.33u l=0.2u
X5472 user_project_wrapper_0.analog_io[32] a_202114_326125# user_project_wrapper_0.IOVSS1 user_project_wrapper_0.IOVSS1 sg13_lv_nmos ad=0.912p pd=5.18u as=0.912p ps=5.18u w=4.8u l=0.13u
X5473 user_project_wrapper_0.analog_io[35] a_213870_324142# user_project_wrapper_0.IOVSS1 user_project_wrapper_0.IOVSS1 sg13_lv_pmos ad=1.824p pd=9.98u as=1.824p ps=9.98u w=9.6u l=0.13u
X5474 user_project_wrapper_0.IOVSS1 user_project_wrapper_0.sg13g2_IOPadVdd_3.sg13g2_RCClampInverter_noptap_0.out user_project_wrapper_0.IOVSS1 user_project_wrapper_0.IOVSS1 sg13_hv_nmos ad=1.408p pd=5.04u as=0 ps=0 w=4.4u l=0.6u
X5475 user_project_wrapper_0.analog_io[12] a_176644_29676# user_project_wrapper_0.IOVSS1 user_project_wrapper_0.IOVSS1 sg13_hv_nmos ad=2.596p pd=5.58u as=1.408p ps=5.04u w=4.4u l=0.6u
X5476 a_296731_208493# a_301186_192011# user_project_wrapper_0.IOVSS1 user_project_wrapper_0.IOVSS1 sg13_lv_nmos ad=0.912p pd=5.18u as=0.912p ps=5.18u w=4.8u l=1.06u
X5477 a_355624_217444# IOVDD3 IOVDD3 rppd l=12.9u w=0.5u
X5478 analog_io[23] a_355624_237844# IOVDD3 IOVDD3 sg13_hv_pmos ad=3.9294p pd=7.84u as=2.1312p ps=7.3u w=6.66u l=0.6u
X5479 user_project_wrapper_0.IOVSS1 user_project_wrapper_0.ui_PAD[9] dantenna l=27.78u w=1.26u
X5480 user_project_wrapper_0.IOVSS1 user_project_wrapper_0.IOVSS1 user_project_wrapper_0.IOVSS1 rppd l=0.5u w=0.5u
X5481 user_project_wrapper_0.IOVDD2 a_156244_41476# user_project_wrapper_0.analog_io[11] user_project_wrapper_0.IOVDD2 sg13_hv_pmos ad=2.1312p pd=7.3u as=3.9294p ps=7.84u w=6.66u l=0.6u
X5482 user_project_wrapper_0.analog_io[27] a_115444_355624# user_project_wrapper_0.IOVDD4 user_project_wrapper_0.IOVDD4 sg13_hv_pmos ad=3.9294p pd=7.84u as=2.1312p ps=7.3u w=6.66u l=0.6u
X5483 user_project_wrapper_0.VDD1 user_project_wrapper_0.sg13g2_IOPadVdd_2.sg13g2_RCClampInverter_noptap_0.out user_project_wrapper_0.IOVSS1 user_project_wrapper_0.IOVSS1 sg13_hv_nmos ad=2.596p pd=5.58u as=1.408p ps=5.04u w=4.4u l=0.6u
X5484 QDLL_TOP_0.VDD a_269799_100118# a_269931_100182# QDLL_TOP_0.VDD sg13_lv_pmos ad=0.2245p pd=1.53u as=0.445p ps=2.89u w=1u l=0.25u
X5485 user_project_wrapper_0.IOVSS1 user_project_wrapper_0.sg13g2_IOPadVdd_3.sg13g2_RCClampInverter_noptap_0.out user_project_wrapper_0.IOVSS1 user_project_wrapper_0.IOVSS1 sg13_hv_nmos ad=1.408p pd=5.04u as=0 ps=0 w=4.4u l=0.6u
X5486 VDD3 user_project_wrapper_0.sg13g2_IOPadVdd_0.sg13g2_RCClampResistor_0.p2 user_project_wrapper_0.sg13g2_IOPadVdd_0.sg13g2_RCClampInverter_noptap_0.out VDD3 sg13_hv_pmos ad=1.33p pd=7.38u as=1.33p ps=7.38u w=7u l=0.5u
X5487 VDD3 user_project_wrapper_0.sg13g2_IOPadVdd_0.sg13g2_RCClampInverter_noptap_0.out user_project_wrapper_0.IOVSS1 user_project_wrapper_0.IOVSS1 sg13_hv_nmos ad=2.596p pd=5.58u as=1.408p ps=5.04u w=4.4u l=0.6u
X5488 user_project_wrapper_0.VDD1 user_project_wrapper_0.sg13g2_IOPadVdd_2.sg13g2_RCClampInverter_noptap_0.out user_project_wrapper_0.IOVSS1 user_project_wrapper_0.IOVSS1 sg13_hv_nmos ad=2.596p pd=5.58u as=1.408p ps=5.04u w=4.4u l=0.6u
X5489 user_project_wrapper_0.analog_io[0] a_41476_115444# user_project_wrapper_0.IOVDD1 user_project_wrapper_0.IOVDD1 sg13_hv_pmos ad=3.9294p pd=7.84u as=2.1312p ps=7.3u w=6.66u l=0.6u
X5490 user_project_wrapper_0.IOVSS1 a_135844_29676# user_project_wrapper_0.analog_io[10] user_project_wrapper_0.IOVSS1 sg13_hv_nmos ad=2.068p pd=9.74u as=2.596p ps=5.58u w=4.4u l=0.6u
X5491 a_309917_194695# a_309516_194555# VDD3 VDD3 sg13_lv_pmos ad=0.19p pd=1.38u as=0.19p ps=1.38u w=1u l=0.7u
X5492 IOVDD3 user_project_wrapper_0.sg13g2_IOPadIOVdd_3.sg13g2_Clamp_N43N43D4R_0.gate user_project_wrapper_0.IOVSS1 user_project_wrapper_0.IOVSS1 sg13_hv_nmos ad=2.596p pd=5.58u as=1.408p ps=5.04u w=4.4u l=0.6u
X5493 IOVDD3 user_project_wrapper_0.sg13g2_IOPadIOVdd_3.sg13g2_Clamp_N43N43D4R_0.gate user_project_wrapper_0.IOVSS1 user_project_wrapper_0.IOVSS1 sg13_hv_nmos ad=2.596p pd=5.58u as=1.408p ps=5.04u w=4.4u l=0.6u
X5494 user_project_wrapper_0.IOVSS1 user_project_wrapper_0.sg13g2_IOPadIOVdd_2.sg13g2_Clamp_N43N43D4R_0.gate user_project_wrapper_0.IOVDD4 user_project_wrapper_0.IOVSS1 sg13_hv_nmos ad=1.408p pd=5.04u as=2.596p ps=5.58u w=4.4u l=0.6u
X5495 user_project_wrapper_0.IOVDD2 a_135844_41476# user_project_wrapper_0.analog_io[10] user_project_wrapper_0.IOVDD2 sg13_hv_pmos ad=2.1312p pd=7.3u as=3.9294p ps=7.84u w=6.66u l=0.6u
X5496 user_project_wrapper_0.IOVSS1 a_369296_237844# analog_io[23] user_project_wrapper_0.IOVSS1 sg13_hv_nmos ad=1.408p pd=5.04u as=2.596p ps=5.58u w=4.4u l=0.6u
X5497 user_project_wrapper_0.IOVDD1 a_41476_237844# user_project_wrapper_0.analog_io[6] user_project_wrapper_0.IOVDD1 sg13_hv_pmos ad=2.1312p pd=7.3u as=3.9294p ps=7.84u w=6.66u l=0.6u
X5498 user_project_wrapper_0.IOVSS1 user_project_wrapper_0.sg13g2_IOPadVdd_3.sg13g2_RCClampInverter_noptap_0.out user_project_wrapper_0.IOVSS1 user_project_wrapper_0.IOVSS1 sg13_hv_nmos ad=2.596p pd=5.58u as=0 ps=0 w=4.4u l=0.6u
X5499 a_194193_328627# a_189672_324776# user_project_wrapper_0.IOVSS1 user_project_wrapper_0.IOVSS1 sg13_lv_pmos ad=3.264p pd=19.88u as=3.264p ps=19.88u w=9.6u l=0.13u
X5500 user_project_wrapper_0.IOVSS1 user_project_wrapper_0.sg13g2_IOPadVdd_0.sg13g2_RCClampInverter_noptap_0.out VDD3 user_project_wrapper_0.IOVSS1 sg13_hv_nmos ad=1.408p pd=5.04u as=2.596p ps=5.58u w=4.4u l=0.6u
X5501 user_project_wrapper_0.analog_io[13] user_project_wrapper_0.IOVSS1 cap_cmim l=20u w=60u
X5502 a_304196_197873# a_304090_197941# a_296625_189595# user_project_wrapper_0.IOVSS1 sg13_lv_nmos ad=0.361p pd=2.28u as=0.361p ps=2.28u w=1.9u l=0.16u
X5503 analog_io[20] a_311108_179669# VDD3 user_project_wrapper_0.IOVSS1 sg13_lv_nmos ad=3.4p pd=20.68u as=3.4p ps=20.68u w=10u l=0.15u
X5504 user_project_wrapper_0.analog_io[15] a_190389_101343# user_project_wrapper_0.IOVSS1 user_project_wrapper_0.IOVSS1 sg13_lv_nmos ad=0.1406p pd=1.12u as=0.1406p ps=1.12u w=0.74u l=0.13u
X5505 user_project_wrapper_0.IOVSS1 a_188988_324119# a_188920_324155# w_188806_323975# sg13_lv_pmos ad=0.68p pd=4.68u as=0.38p ps=2.38u w=2u l=0.13u
X5506 VDD3 a_296625_208423# a_296731_208493# VDD3 sg13_lv_pmos ad=0.2603p pd=1.75u as=0.2603p ps=1.75u w=1.37u l=0.35u
X5507 analog_io[20] a_369296_156244# user_project_wrapper_0.IOVSS1 user_project_wrapper_0.IOVSS1 sg13_hv_nmos ad=2.596p pd=5.58u as=1.408p ps=5.04u w=4.4u l=0.6u
X5508 a_191438_327491# a_191234_327491# user_project_wrapper_0.IOVSS1 user_project_wrapper_0.IOVSS1 sg13_lv_nmos ad=0.34p pd=2.68u as=0.19p ps=1.38u w=1u l=0.13u
X5509 analog_io[20] a_355624_156244# IOVDD3 IOVDD3 sg13_hv_pmos ad=3.9294p pd=7.84u as=2.1312p ps=7.3u w=6.66u l=0.6u
X5510 user_project_wrapper_0.analog_io[32] a_202114_326125# user_project_wrapper_0.IOVSS1 user_project_wrapper_0.IOVSS1 sg13_lv_pmos ad=1.824p pd=9.98u as=1.824p ps=9.98u w=9.6u l=0.13u
X5511 user_project_wrapper_0.analog_io[29] a_156244_355624# user_project_wrapper_0.IOVDD4 user_project_wrapper_0.IOVDD4 sg13_hv_pmos ad=3.9294p pd=7.84u as=2.1312p ps=7.3u w=6.66u l=0.6u
X5512 user_project_wrapper_0.IOVSS1 user_project_wrapper_0.IOVSS1 dantenna l=27.78u w=1.26u
X5513 user_project_wrapper_0.IOVSS1 user_project_wrapper_0.sg13g2_IOPadVdd_2.sg13g2_RCClampInverter_noptap_0.out user_project_wrapper_0.VDD1 user_project_wrapper_0.IOVSS1 sg13_hv_nmos ad=1.408p pd=5.04u as=2.596p ps=5.58u w=4.4u l=0.6u
X5514 user_project_wrapper_0.sg13g2_IOPadVdd_1.sg13g2_RCClampInverter_noptap_0.out user_project_wrapper_0.sg13g2_IOPadVdd_1.sg13g2_RCClampResistor_0.p2 user_project_wrapper_0.VDD2 user_project_wrapper_0.VDD2 sg13_hv_pmos ad=1.33p pd=7.38u as=1.33p ps=7.38u w=7u l=0.5u
X5515 user_project_wrapper_0.IOVSS1 analog_io[19] dantenna l=27.78u w=1.26u
X5516 a_309917_199879# a_309516_194555# VDD3 VDD3 sg13_lv_pmos ad=0.19p pd=1.38u as=0.19p ps=1.38u w=1u l=0.7u
X5517 user_project_wrapper_0.analog_io[4] a_41476_197044# user_project_wrapper_0.IOVDD1 user_project_wrapper_0.IOVDD1 sg13_hv_pmos ad=3.9294p pd=7.84u as=2.1312p ps=7.3u w=6.66u l=0.6u
X5518 IOVDD3 a_355624_115444# analog_io[18] IOVDD3 sg13_hv_pmos ad=2.1312p pd=7.3u as=3.9294p ps=7.84u w=6.66u l=0.6u
X5519 a_313884_185173# analog_io[20] a_311108_179669# user_project_wrapper_0.IOVSS1 sg13_lv_nmos ad=1.9p pd=10.38u as=1.9p ps=10.38u w=10u l=0.5u
X5520 user_project_wrapper_0.analog_io[34] a_258244_355624# user_project_wrapper_0.IOVDD4 user_project_wrapper_0.IOVDD4 sg13_hv_pmos ad=3.9294p pd=7.84u as=2.1312p ps=7.3u w=6.66u l=0.6u
X5521 a_309917_199879# a_309516_194555# VDD3 VDD3 sg13_lv_pmos ad=0.19p pd=1.38u as=0.19p ps=1.38u w=1u l=0.7u
X5522 a_309917_199879# user_project_wrapper_0.sg13g2_IOPadAnalog_29.padres a_311846_195517# VDD3 sg13_lv_pmos ad=0.24415p pd=1.665u as=0.24415p ps=1.665u w=1.285u l=0.35u
X5523 VDD3 a_296625_208423# a_296731_208493# VDD3 sg13_lv_pmos ad=0.2603p pd=1.75u as=0.2603p ps=1.75u w=1.37u l=0.35u
X5524 a_210109_325263# a_209684_325263# a_210007_325263# user_project_wrapper_0.IOVSS1 sg13_lv_nmos ad=0.19p pd=1.38u as=0.19p ps=1.38u w=1u l=0.13u
X5525 IOVDD3 user_project_wrapper_0.sg13g2_IOPadIOVdd_3.sg13g2_Clamp_N43N43D4R_0.gate user_project_wrapper_0.IOVSS1 user_project_wrapper_0.IOVSS1 sg13_hv_nmos ad=2.596p pd=5.58u as=1.408p ps=5.04u w=4.4u l=0.6u
X5526 user_project_wrapper_0.IOVDD4 a_176644_355624# user_project_wrapper_0.analog_io[30] user_project_wrapper_0.IOVDD4 sg13_hv_pmos ad=2.1312p pd=7.3u as=3.9294p ps=7.84u w=6.66u l=0.6u
X5527 IOVDD3 a_355624_237844# analog_io[23] IOVDD3 sg13_hv_pmos ad=3.1302p pd=14.26u as=3.9294p ps=7.84u w=6.66u l=0.6u
X5528 VDD3 a_309516_194555# a_309516_194555# VDD3 sg13_lv_pmos ad=0.19p pd=1.38u as=0.19p ps=1.38u w=1u l=0.7u
X5529 a_194279_327536# a_194193_328627# user_project_wrapper_0.IOVSS1 user_project_wrapper_0.IOVSS1 sg13_lv_pmos ad=1.824p pd=9.98u as=1.824p ps=9.98u w=9.6u l=0.13u
X5530 a_309917_199879# a_296731_208493# a_307232_196607# VDD3 sg13_lv_pmos ad=0.24415p pd=1.665u as=0.24415p ps=1.665u w=1.285u l=0.35u
X5531 user_project_wrapper_0.IOVDD4 a_237844_355624# user_project_wrapper_0.analog_io[33] user_project_wrapper_0.IOVDD4 sg13_hv_pmos ad=2.1312p pd=7.3u as=3.9294p ps=7.84u w=6.66u l=0.6u
X5532 user_project_wrapper_0.IOVSS1 user_project_wrapper_0.sg13g2_IOPadVdd_3.sg13g2_RCClampInverter_noptap_0.out user_project_wrapper_0.IOVSS1 user_project_wrapper_0.IOVSS1 sg13_hv_nmos ad=1.408p pd=5.04u as=0 ps=0 w=4.4u l=0.6u
X5533 user_project_wrapper_0.sg13g2_IOPadVdd_2.sg13g2_RCClampInverter_noptap_0.out user_project_wrapper_0.sg13g2_IOPadVdd_2.sg13g2_RCClampResistor_0.p2 user_project_wrapper_0.VDD1 user_project_wrapper_0.VDD1 sg13_hv_pmos ad=1.33p pd=7.38u as=1.33p ps=7.38u w=7u l=0.5u
X5534 user_project_wrapper_0.IOVSS1 user_project_wrapper_0.sg13g2_IOPadAnalog_6.padres dantenna l=3.1u w=0.64u
X5535 user_project_wrapper_0.IOVSS1 user_project_wrapper_0.sg13g2_IOPadVdd_2.sg13g2_RCClampInverter_noptap_0.out user_project_wrapper_0.VDD1 user_project_wrapper_0.IOVSS1 sg13_hv_nmos ad=1.408p pd=5.04u as=2.596p ps=5.58u w=4.4u l=0.6u
X5536 user_project_wrapper_0.IOVSS1 a_191234_328605# a_191438_328605# w_188704_327938# sg13_lv_pmos ad=0.38p pd=2.38u as=0.38p ps=2.38u w=2u l=0.13u
X5537 a_35456_73375# user_project_wrapper_0.VDD1 user_project_wrapper_0.IOVSS1 rppd l=20u w=1u
X5538 user_project_wrapper_0.analog_io[12] a_176644_29676# user_project_wrapper_0.IOVSS1 user_project_wrapper_0.IOVSS1 sg13_hv_nmos ad=2.596p pd=5.58u as=1.408p ps=5.04u w=4.4u l=0.6u
X5539 user_project_wrapper_0.IOVSS1 user_project_wrapper_0.sg13g2_IOPadVdd_3.sg13g2_RCClampInverter_noptap_0.out user_project_wrapper_0.IOVSS1 user_project_wrapper_0.IOVSS1 sg13_hv_nmos ad=1.408p pd=5.04u as=0 ps=0 w=4.4u l=0.6u
X5540 user_project_wrapper_0.IOVSS1 user_project_wrapper_0.sg13g2_IOPadVdd_3.sg13g2_RCClampInverter_noptap_0.out user_project_wrapper_0.IOVSS1 user_project_wrapper_0.IOVSS1 sg13_hv_nmos ad=1.408p pd=5.04u as=0 ps=0 w=4.4u l=0.6u
X5541 user_project_wrapper_0.analog_io[12] a_176644_41476# user_project_wrapper_0.IOVDD2 user_project_wrapper_0.IOVDD2 sg13_hv_pmos ad=3.9294p pd=7.84u as=2.1312p ps=7.3u w=6.66u l=0.6u
X5542 user_project_wrapper_0.IOVDD1 user_project_wrapper_0.sg13g2_IOPadIOVdd_1.sg13g2_Clamp_N43N43D4R_0.gate user_project_wrapper_0.IOVSS1 user_project_wrapper_0.IOVSS1 sg13_hv_nmos ad=2.596p pd=5.58u as=1.408p ps=5.04u w=4.4u l=0.6u
X5543 user_project_wrapper_0.analog_io[32] a_202114_326125# user_project_wrapper_0.IOVSS1 user_project_wrapper_0.IOVSS1 sg13_lv_pmos ad=1.824p pd=9.98u as=1.824p ps=9.98u w=9.6u l=0.13u
X5544 user_project_wrapper_0.IOVSS1 user_project_wrapper_0.sg13g2_IOPadVdd_0.sg13g2_RCClampInverter_noptap_0.out VDD3 user_project_wrapper_0.IOVSS1 sg13_hv_nmos ad=1.408p pd=5.04u as=2.596p ps=5.58u w=4.4u l=0.6u
X5545 a_82527_127455# a_79025_136081# user_project_wrapper_0.IOVSS1 user_project_wrapper_0.IOVSS1 sg13_lv_nmos ad=0.2516p pd=2.16u as=0.2516p ps=2.16u w=0.74u l=0.13u
X5546 user_project_wrapper_0.IOVDD1 a_41476_115444# user_project_wrapper_0.analog_io[0] user_project_wrapper_0.IOVDD1 sg13_hv_pmos ad=2.1312p pd=7.3u as=3.9294p ps=7.84u w=6.66u l=0.6u
X5547 a_188834_326341# user_project_wrapper_0.sg13g2_IOPadAnalog_19.padres user_project_wrapper_0.IOVSS1 user_project_wrapper_0.IOVSS1 sg13_lv_nmos ad=0.34p pd=2.68u as=0.34p ps=2.68u w=1u l=0.13u
X5548 user_project_wrapper_0.analog_io[32] a_217444_369296# user_project_wrapper_0.IOVSS1 user_project_wrapper_0.IOVSS1 sg13_hv_nmos ad=2.596p pd=5.58u as=1.408p ps=5.04u w=4.4u l=0.6u
X5549 user_project_wrapper_0.analog_io[30] a_194687_324142# user_project_wrapper_0.IOVSS1 user_project_wrapper_0.IOVSS1 sg13_lv_pmos ad=1.824p pd=9.98u as=1.824p ps=9.98u w=9.6u l=0.13u
X5550 user_project_wrapper_0.IOVSS1 a_213462_327536# a_213870_324142# user_project_wrapper_0.IOVSS1 sg13_lv_nmos ad=0.912p pd=5.18u as=0.912p ps=5.18u w=4.8u l=0.13u
X5551 user_project_wrapper_0.IOVSS1 user_project_wrapper_0.sg13g2_IOPadAnalog_17.padres a_189286_329327# user_project_wrapper_0.IOVSS1 sg13_lv_nmos ad=0.34p pd=2.68u as=0.19p ps=1.38u w=1u l=0.13u
X5552 user_project_wrapper_0.IOVSS1 a_278644_29676# QDLL_TOP_0.VOUT user_project_wrapper_0.IOVSS1 sg13_hv_nmos ad=1.408p pd=5.04u as=2.596p ps=5.58u w=4.4u l=0.6u
X5553 a_189395_99046# a_189148_99070# QDLL_TOP_0.VDD QDLL_TOP_0.VDD sg13_lv_pmos ad=0.3808p pd=2.92u as=0.2245p ps=1.53u w=1.12u l=0.13u
X5554 user_project_wrapper_0.IOVSS1 user_project_wrapper_0.uo_PAD[3] dantenna l=27.78u w=1.26u
X5555 user_project_wrapper_0.analog_io[7] a_29676_258244# user_project_wrapper_0.IOVSS1 user_project_wrapper_0.IOVSS1 sg13_hv_nmos ad=2.596p pd=5.58u as=1.408p ps=5.04u w=4.4u l=0.6u
X5556 user_project_wrapper_0.IOVSS1 a_213376_328627# a_213462_327536# user_project_wrapper_0.IOVSS1 sg13_lv_nmos ad=0.912p pd=5.18u as=0.912p ps=5.18u w=4.8u l=0.13u
X5557 user_project_wrapper_0.analog_io[10] a_135844_41476# user_project_wrapper_0.IOVDD2 user_project_wrapper_0.IOVDD2 sg13_hv_pmos ad=3.9294p pd=7.84u as=2.1312p ps=7.3u w=6.66u l=0.6u
X5558 VDD3 a_309516_194555# a_309917_199879# VDD3 sg13_lv_pmos ad=0.19p pd=1.38u as=0.19p ps=1.38u w=1u l=0.7u
X5559 a_88274_127896# a_86507_127725# a_88274_127531# user_project_wrapper_0.IOVSS1 sg13_lv_nmos ad=0.2516p pd=2.16u as=0.1406p ps=1.12u w=0.74u l=0.13u
X5560 analog_io[25] a_355624_258244# IOVDD3 IOVDD3 sg13_hv_pmos ad=3.9294p pd=7.84u as=2.1312p ps=7.3u w=6.66u l=0.6u
X5561 user_project_wrapper_0.sg13g2_IOPadIOVdd_2.sg13g2_Clamp_N43N43D4R_0.gate user_project_wrapper_0.sg13g2_IOPadIOVdd_2.sg13g2_RCClampResistor_0.p2 user_project_wrapper_0.IOVDD4 user_project_wrapper_0.IOVDD4 sg13_hv_pmos ad=1.33p pd=7.38u as=1.33p ps=7.38u w=7u l=0.5u
X5562 a_202114_326125# a_205385_326221# user_project_wrapper_0.IOVSS1 user_project_wrapper_0.IOVSS1 sg13_lv_pmos ad=1.824p pd=9.98u as=1.824p ps=9.98u w=9.6u l=0.13u
X5563 user_project_wrapper_0.IOVSS1 user_project_wrapper_0.sg13g2_IOPadVdd_2.sg13g2_RCClampInverter_noptap_0.out user_project_wrapper_0.VDD1 user_project_wrapper_0.IOVSS1 sg13_hv_nmos ad=1.408p pd=5.04u as=2.596p ps=5.58u w=4.4u l=0.6u
X5564 user_project_wrapper_0.IOVSS1 a_307232_196607# a_304995_198817# user_project_wrapper_0.IOVSS1 sg13_lv_nmos ad=0.6327p pd=3.71u as=0.6327p ps=3.71u w=3.33u l=0.2u
X5565 user_project_wrapper_0.IOVSS1 a_189609_324119# a_189396_324119# w_188806_323975# sg13_lv_pmos ad=0.38p pd=2.38u as=0.68p ps=4.68u w=2u l=0.13u
X5566 a_296731_189665# a_296625_189595# VDD3 VDD3 sg13_lv_pmos ad=0.2603p pd=1.75u as=0.2603p ps=1.75u w=1.37u l=0.35u
X5567 user_project_wrapper_0.IOVSS1 a_194687_324142# user_project_wrapper_0.analog_io[30] user_project_wrapper_0.IOVSS1 sg13_lv_nmos ad=0.912p pd=5.18u as=0.912p ps=5.18u w=4.8u l=0.13u
X5568 user_project_wrapper_0.IOVSS1 user_project_wrapper_0.sg13g2_IOPadIOVdd_2.sg13g2_Clamp_N43N43D4R_0.gate user_project_wrapper_0.IOVDD4 user_project_wrapper_0.IOVSS1 sg13_hv_nmos ad=1.408p pd=5.04u as=2.596p ps=5.58u w=4.4u l=0.6u
X5569 user_project_wrapper_0.IOVSS1 a_369296_135844# analog_io[19] user_project_wrapper_0.IOVSS1 sg13_hv_nmos ad=1.408p pd=5.04u as=2.596p ps=5.58u w=4.4u l=0.6u
X5570 user_project_wrapper_0.IOVSS1 a_369296_156244# analog_io[20] user_project_wrapper_0.IOVSS1 sg13_hv_nmos ad=1.408p pd=5.04u as=2.596p ps=5.58u w=4.4u l=0.6u
X5571 VDD3 a_296625_208423# a_296731_208493# VDD3 sg13_lv_pmos ad=0.2603p pd=1.75u as=0.2603p ps=1.75u w=1.37u l=0.35u
X5572 user_project_wrapper_0.IOVSS1 user_project_wrapper_0.sg13g2_IOPadIOVdd_3.sg13g2_Clamp_N43N43D4R_0.gate IOVDD3 user_project_wrapper_0.IOVSS1 sg13_hv_nmos ad=1.408p pd=5.04u as=2.596p ps=5.58u w=4.4u l=0.6u
X5573 user_project_wrapper_0.IOVSS1 user_project_wrapper_0.sg13g2_IOPadIOVdd_3.sg13g2_Clamp_N43N43D4R_0.gate IOVDD3 user_project_wrapper_0.IOVSS1 sg13_hv_nmos ad=1.408p pd=5.04u as=2.596p ps=5.58u w=4.4u l=0.6u
X5574 analog_io[18] a_355624_115444# IOVDD3 IOVDD3 sg13_hv_pmos ad=3.9294p pd=7.84u as=2.1312p ps=7.3u w=6.66u l=0.6u
X5575 VDD3 a_309516_194555# a_309917_199879# VDD3 sg13_lv_pmos ad=0.19p pd=1.38u as=0.19p ps=1.38u w=1u l=0.7u
X5576 user_project_wrapper_0.IOVSS1 user_project_wrapper_0.IOVSS1 dantenna l=27.78u w=1.26u
X5577 user_project_wrapper_0.IOVSS1 user_project_wrapper_0.sg13g2_IOPadIOVdd_1.sg13g2_Clamp_N43N43D4R_0.gate user_project_wrapper_0.IOVDD1 user_project_wrapper_0.IOVSS1 sg13_hv_nmos ad=1.408p pd=5.04u as=2.596p ps=5.58u w=4.4u l=0.6u
X5578 user_project_wrapper_0.IOVDD2 a_156244_41476# user_project_wrapper_0.analog_io[11] user_project_wrapper_0.IOVDD2 sg13_hv_pmos ad=2.1312p pd=7.3u as=3.9294p ps=7.84u w=6.66u l=0.6u
X5579 user_project_wrapper_0.IOVSS1 user_project_wrapper_0.sg13g2_IOPadIOVdd_0.sg13g2_Clamp_N43N43D4R_0.gate user_project_wrapper_0.IOVDD2 user_project_wrapper_0.IOVSS1 sg13_hv_nmos ad=1.408p pd=5.04u as=2.596p ps=5.58u w=4.4u l=0.6u
X5580 a_296731_189665# a_296625_189595# VDD3 VDD3 sg13_lv_pmos ad=0.2603p pd=1.75u as=0.2603p ps=1.75u w=1.37u l=0.35u
X5581 a_210621_327491# a_210417_327491# user_project_wrapper_0.IOVSS1 user_project_wrapper_0.IOVSS1 sg13_lv_nmos ad=0.34p pd=2.68u as=0.19p ps=1.38u w=1u l=0.13u
X5582 a_296731_189665# a_296625_189595# VDD3 VDD3 sg13_lv_pmos ad=0.2603p pd=1.75u as=0.2603p ps=1.75u w=1.37u l=0.35u
X5583 user_project_wrapper_0.IOVSS1 user_project_wrapper_0.IOVSS1 user_project_wrapper_0.IOVSS1 rhigh l=4u w=0.5u
X5584 a_202114_326125# a_205385_326221# user_project_wrapper_0.IOVSS1 user_project_wrapper_0.IOVSS1 sg13_lv_pmos ad=1.824p pd=9.98u as=1.824p ps=9.98u w=9.6u l=0.13u
X5585 a_208469_326377# a_208367_327491# a_208367_326377# w_207887_326203# sg13_lv_pmos ad=0.38p pd=2.38u as=0.38p ps=2.38u w=2u l=0.13u
X5586 analog_io[22] a_355624_197044# IOVDD3 IOVDD3 sg13_hv_pmos ad=3.9294p pd=7.84u as=2.1312p ps=7.3u w=6.66u l=0.6u
X5587 a_296731_189665# a_296625_189595# VDD3 VDD3 sg13_lv_pmos ad=0.2603p pd=1.75u as=0.2603p ps=1.75u w=1.37u l=0.35u
X5588 IOVDD3 a_355624_135844# analog_io[19] IOVDD3 sg13_hv_pmos ad=2.1312p pd=7.3u as=3.9294p ps=7.84u w=6.66u l=0.6u
X5589 user_project_wrapper_0.IOVSS1 a_213870_324142# user_project_wrapper_0.analog_io[35] user_project_wrapper_0.IOVSS1 sg13_lv_nmos ad=0.912p pd=5.18u as=0.912p ps=5.18u w=4.8u l=0.13u
X5590 user_project_wrapper_0.analog_io[27] a_182931_326125# user_project_wrapper_0.IOVSS1 user_project_wrapper_0.IOVSS1 sg13_lv_nmos ad=0.912p pd=5.18u as=0.912p ps=5.18u w=4.8u l=0.13u
X5591 a_304196_197873# a_304889_198885# a_304995_198817# user_project_wrapper_0.IOVSS1 sg13_lv_nmos ad=0.209p pd=1.48u as=0.374p ps=2.88u w=1.1u l=0.15u
X5592 user_project_wrapper_0.sg13g2_IOPadIn$1_2.sg13g2_LevelDown_noptap$1_0.sg13g2_SecondaryProtection$1$1_0.core user_project_wrapper_0.IOVDD4 dpantenna l=0.64u w=4.98u
X5593 user_project_wrapper_0.IOVSS1 user_project_wrapper_0.sg13g2_IOPadIOVdd_1.sg13g2_Clamp_N43N43D4R_0.gate user_project_wrapper_0.IOVDD1 user_project_wrapper_0.IOVSS1 sg13_hv_nmos ad=1.408p pd=5.04u as=2.596p ps=5.58u w=4.4u l=0.6u
X5594 user_project_wrapper_0.IOVSS1 a_213870_324142# user_project_wrapper_0.analog_io[35] user_project_wrapper_0.IOVSS1 sg13_lv_nmos ad=0.912p pd=5.18u as=0.912p ps=5.18u w=4.8u l=0.13u
X5595 user_project_wrapper_0.IOVSS1 user_project_wrapper_0.sg13g2_IOPadVdd_2.sg13g2_RCClampInverter_noptap_0.out user_project_wrapper_0.VDD1 user_project_wrapper_0.IOVSS1 sg13_hv_nmos ad=1.408p pd=5.04u as=2.596p ps=5.58u w=4.4u l=0.6u
X5596 VDD3 a_296625_189595# a_296731_189665# VDD3 sg13_lv_pmos ad=0.4658p pd=3.42u as=0.2603p ps=1.75u w=1.37u l=0.35u
X5597 user_project_wrapper_0.IOVSS1 user_project_wrapper_0.IOVSS1 user_project_wrapper_0.IOVSS1 rhigh l=0.96u w=0.5u
X5598 user_project_wrapper_0.IOVSS1 user_project_wrapper_0.sg13g2_IOPadIOVdd_0.sg13g2_Clamp_N43N43D4R_0.gate user_project_wrapper_0.IOVDD2 user_project_wrapper_0.IOVSS1 sg13_hv_nmos ad=1.408p pd=5.04u as=2.596p ps=5.58u w=4.4u l=0.6u
X5599 IOVDD3 user_project_wrapper_0.sg13g2_IOPadIOVdd_3.sg13g2_RCClampResistor_0.p2 user_project_wrapper_0.sg13g2_IOPadIOVdd_3.sg13g2_Clamp_N43N43D4R_0.gate IOVDD3 sg13_hv_pmos ad=1.33p pd=7.38u as=1.33p ps=7.38u w=7u l=0.5u
X5600 user_project_wrapper_0.IOVSS1 a_194687_324142# user_project_wrapper_0.analog_io[30] user_project_wrapper_0.IOVSS1 sg13_lv_nmos ad=1.632p pd=10.28u as=0.912p ps=5.18u w=4.8u l=0.13u
X5601 user_project_wrapper_0.IOVSS1 a_301186_192011# a_296731_189665# user_project_wrapper_0.IOVSS1 sg13_lv_nmos ad=0.912p pd=5.18u as=0.912p ps=5.18u w=4.8u l=1.06u
X5602 user_project_wrapper_0.IOVSS1 user_project_wrapper_0.sg13g2_IOPadIOVdd_0.sg13g2_Clamp_N43N43D4R_0.gate user_project_wrapper_0.IOVDD2 user_project_wrapper_0.IOVSS1 sg13_hv_nmos ad=1.408p pd=5.04u as=2.596p ps=5.58u w=4.4u l=0.6u
X5603 IOVDD3 a_355624_237844# analog_io[23] IOVDD3 sg13_hv_pmos ad=2.1312p pd=7.3u as=3.9294p ps=7.84u w=6.66u l=0.6u
X5604 IOVDD3 a_355624_258244# analog_io[25] IOVDD3 sg13_hv_pmos ad=2.1312p pd=7.3u as=3.9294p ps=7.84u w=6.66u l=0.6u
X5605 user_project_wrapper_0.analog_io[34] a_258244_355624# user_project_wrapper_0.IOVDD4 user_project_wrapper_0.IOVDD4 sg13_hv_pmos ad=3.9294p pd=7.84u as=3.1302p ps=14.26u w=6.66u l=0.6u
X5606 a_296731_189665# a_296625_189595# VDD3 VDD3 sg13_lv_pmos ad=0.2603p pd=1.75u as=0.2603p ps=1.75u w=1.37u l=0.35u
X5607 VDD3 user_project_wrapper_0.sg13g2_IOPadVdd_0.sg13g2_RCClampInverter_noptap_0.out user_project_wrapper_0.IOVSS1 user_project_wrapper_0.IOVSS1 sg13_hv_nmos ad=2.596p pd=5.58u as=1.408p ps=5.04u w=4.4u l=0.6u
X5608 a_296731_189665# a_301186_192011# user_project_wrapper_0.IOVSS1 user_project_wrapper_0.IOVSS1 sg13_lv_nmos ad=0.912p pd=5.18u as=0.912p ps=5.18u w=4.8u l=1.06u
X5609 a_82846_242854# a_82645_242401# user_project_wrapper_0.VDD1 user_project_wrapper_0.VDD1 sg13_lv_pmos ad=0.95p pd=5.38u as=1.7p ps=10.68u w=5u l=0.15u
X5610 user_project_wrapper_0.IOVDD4 a_115444_355624# user_project_wrapper_0.analog_io[27] user_project_wrapper_0.IOVDD4 sg13_hv_pmos ad=2.1312p pd=7.3u as=3.9294p ps=7.84u w=6.66u l=0.6u
X5611 user_project_wrapper_0.IOVSS1 a_210417_328605# a_210621_328605# w_207887_327938# sg13_lv_pmos ad=0.38p pd=2.38u as=0.38p ps=2.38u w=2u l=0.13u
X5612 a_190389_101343# a_189729_101343# user_project_wrapper_0.IOVSS1 user_project_wrapper_0.IOVSS1 sg13_lv_nmos ad=0.1406p pd=1.12u as=0.1406p ps=1.12u w=0.74u l=0.13u
X5613 user_project_wrapper_0.IOVSS1 a_258244_369296# user_project_wrapper_0.IOVSS1 rppd l=3.54u w=0.5u
X5614 a_309917_194695# a_309516_194555# VDD3 VDD3 sg13_lv_pmos ad=0.19p pd=1.38u as=0.19p ps=1.38u w=1u l=0.7u
X5615 VDD3 a_309516_194555# a_309917_199879# VDD3 sg13_lv_pmos ad=0.19p pd=1.38u as=0.19p ps=1.38u w=1u l=0.7u
X5616 user_project_wrapper_0.sg13g2_IOPadAnalog_22.padres a_208871_330987# user_project_wrapper_0.IOVSS1 rhigh l=4u w=0.5u
X5617 a_296731_208493# a_296625_208423# VDD3 VDD3 sg13_lv_pmos ad=0.2603p pd=1.75u as=0.4658p ps=3.42u w=1.37u l=0.35u
X5618 user_project_wrapper_0.IOVDD2 a_237844_41476# user_project_wrapper_0.analog_io[15] user_project_wrapper_0.IOVDD2 sg13_hv_pmos ad=2.1312p pd=7.3u as=3.9294p ps=7.84u w=6.66u l=0.6u
X5619 a_209684_329719# a_208367_329719# user_project_wrapper_0.IOVSS1 user_project_wrapper_0.IOVSS1 sg13_lv_nmos ad=0.34p pd=2.68u as=0.34p ps=2.68u w=1u l=0.13u
X5620 user_project_wrapper_0.analog_io[30] a_176644_355624# user_project_wrapper_0.IOVDD4 user_project_wrapper_0.IOVDD4 sg13_hv_pmos ad=3.9294p pd=7.84u as=2.1312p ps=7.3u w=6.66u l=0.6u
X5621 user_project_wrapper_0.IOVDD1 a_41476_217444# user_project_wrapper_0.analog_io[5] user_project_wrapper_0.IOVDD1 sg13_hv_pmos ad=2.1312p pd=7.3u as=3.9294p ps=7.84u w=6.66u l=0.6u
X5622 user_project_wrapper_0.sg13g2_IOPadIOVdd_2.sg13g2_Clamp_N43N43D4R_0.gate user_project_wrapper_0.sg13g2_IOPadIOVdd_2.sg13g2_RCClampResistor_0.p2 user_project_wrapper_0.IOVDD4 user_project_wrapper_0.IOVDD4 sg13_hv_pmos ad=1.33p pd=7.38u as=1.33p ps=7.38u w=7u l=0.5u
X5623 user_project_wrapper_0.IOVSS1 user_project_wrapper_0.sg13g2_IOPadVdd_3.sg13g2_RCClampResistor_0.p2 user_project_wrapper_0.IOVSS1 user_project_wrapper_0.IOVSS1 sg13_hv_nmos ad=1.71p pd=9.38u as=0 ps=0 w=9u l=9.5u
X5624 IOVDD3 user_project_wrapper_0.sg13g2_IOPadIOVdd_3.sg13g2_Clamp_N43N43D4R_0.gate user_project_wrapper_0.IOVSS1 user_project_wrapper_0.IOVSS1 sg13_hv_nmos ad=3.256p pd=10.28u as=1.408p ps=5.04u w=4.4u l=0.6u
X5625 user_project_wrapper_0.analog_io[1] a_29676_135844# user_project_wrapper_0.IOVSS1 user_project_wrapper_0.IOVSS1 sg13_hv_nmos ad=2.596p pd=5.58u as=1.408p ps=5.04u w=4.4u l=0.6u
X5626 user_project_wrapper_0.IOVSS1 a_213870_324142# user_project_wrapper_0.analog_io[35] user_project_wrapper_0.IOVSS1 sg13_lv_nmos ad=0.912p pd=5.18u as=0.912p ps=5.18u w=4.8u l=0.13u
X5627 user_project_wrapper_0.analog_io[12] a_176644_41476# user_project_wrapper_0.IOVDD2 user_project_wrapper_0.IOVDD2 sg13_hv_pmos ad=3.9294p pd=7.84u as=2.1312p ps=7.3u w=6.66u l=0.6u
X5628 user_project_wrapper_0.IOVDD4 a_156244_355624# user_project_wrapper_0.analog_io[29] user_project_wrapper_0.IOVDD4 sg13_hv_pmos ad=2.1312p pd=7.3u as=3.9294p ps=7.84u w=6.66u l=0.6u
X5629 a_296731_208493# a_296625_208423# VDD3 VDD3 sg13_lv_pmos ad=0.2603p pd=1.75u as=0.2603p ps=1.75u w=1.37u l=0.35u
X5630 user_project_wrapper_0.IOVDD2 user_project_wrapper_0.sg13g2_IOPadIOVdd_0.sg13g2_Clamp_N43N43D4R_0.gate user_project_wrapper_0.IOVSS1 user_project_wrapper_0.IOVSS1 sg13_hv_nmos ad=2.596p pd=5.58u as=1.408p ps=5.04u w=4.4u l=0.6u
X5631 user_project_wrapper_0.analog_io[10] a_135844_41476# user_project_wrapper_0.IOVDD2 user_project_wrapper_0.IOVDD2 sg13_hv_pmos ad=3.9294p pd=7.84u as=2.1312p ps=7.3u w=6.66u l=0.6u
X5632 user_project_wrapper_0.IOVDD1 user_project_wrapper_0.sg13g2_IOPadIOVdd_1.sg13g2_Clamp_N43N43D4R_0.gate user_project_wrapper_0.IOVSS1 user_project_wrapper_0.IOVSS1 sg13_hv_nmos ad=2.596p pd=5.58u as=1.408p ps=5.04u w=4.4u l=0.6u
X5633 user_project_wrapper_0.analog_io[28] a_135844_369296# user_project_wrapper_0.IOVSS1 user_project_wrapper_0.IOVSS1 sg13_hv_nmos ad=2.596p pd=5.58u as=1.408p ps=5.04u w=4.4u l=0.6u
X5634 analog_io[18] a_355624_115444# IOVDD3 IOVDD3 sg13_hv_pmos ad=3.9294p pd=7.84u as=2.1312p ps=7.3u w=6.66u l=0.6u
X5635 a_296731_208493# a_296625_208423# VDD3 VDD3 sg13_lv_pmos ad=0.2603p pd=1.75u as=0.4658p ps=3.42u w=1.37u l=0.35u
X5636 user_project_wrapper_0.IOVSS1 user_project_wrapper_0.IOVSS1 user_project_wrapper_0.IOVSS1 rppd l=0.5u w=0.5u
X5637 VDD3 a_309516_194555# a_309917_194695# VDD3 sg13_lv_pmos ad=0.19p pd=1.38u as=0.19p ps=1.38u w=1u l=0.7u
X5638 a_360372_298105# a_364458_298435# user_project_wrapper_0.IOVSS1 rppd l=20u w=1u
X5639 user_project_wrapper_0.IOVSS1 a_156244_29676# user_project_wrapper_0.analog_io[11] user_project_wrapper_0.IOVSS1 sg13_hv_nmos ad=1.408p pd=5.04u as=2.596p ps=5.58u w=4.4u l=0.6u
X5640 user_project_wrapper_0.IOVDD2 user_project_wrapper_0.sg13g2_IOPadIOVdd_0.sg13g2_Clamp_N43N43D4R_0.gate user_project_wrapper_0.IOVSS1 user_project_wrapper_0.IOVSS1 sg13_hv_nmos ad=2.596p pd=5.58u as=1.408p ps=5.04u w=4.4u l=0.6u
X5641 user_project_wrapper_0.VDD2 user_project_wrapper_0.sg13g2_IOPadVdd_1.sg13g2_RCClampInverter_noptap_0.out user_project_wrapper_0.IOVSS1 user_project_wrapper_0.IOVSS1 sg13_hv_nmos ad=2.596p pd=5.58u as=1.408p ps=5.04u w=4.4u l=0.6u
X5642 a_79025_129164# a_78220_128106# a_79038_127856# user_project_wrapper_0.VDD1 sg13_lv_pmos ad=1.7p pd=10.68u as=0.95p ps=5.38u w=5u l=0.3u
X5643 VDD3 a_309516_194555# a_309917_199879# VDD3 sg13_lv_pmos ad=0.19p pd=1.38u as=0.19p ps=1.38u w=1u l=0.7u
X5644 a_209041_327099# a_208939_327491# a_208939_326377# user_project_wrapper_0.IOVSS1 sg13_lv_nmos ad=0.19p pd=1.38u as=0.19p ps=1.38u w=1u l=0.13u
X5645 user_project_wrapper_0.analog_io[30] a_194687_324142# user_project_wrapper_0.IOVSS1 user_project_wrapper_0.IOVSS1 sg13_lv_nmos ad=0.912p pd=5.18u as=0.912p ps=5.18u w=4.8u l=0.13u
X5646 user_project_wrapper_0.IOVSS1 user_project_wrapper_0.sg13g2_IOPadVdd_0.sg13g2_RCClampInverter_noptap_0.out VDD3 user_project_wrapper_0.IOVSS1 sg13_hv_nmos ad=1.408p pd=5.04u as=2.596p ps=5.58u w=4.4u l=0.6u
X5647 user_project_wrapper_0.analog_io[15] a_190389_101343# user_project_wrapper_0.IOVSS1 user_project_wrapper_0.IOVSS1 sg13_lv_nmos ad=0.1406p pd=1.12u as=0.1406p ps=1.12u w=0.74u l=0.13u
X5648 user_project_wrapper_0.IOVSS1 user_project_wrapper_0.sg13g2_IOPadVdd_3.sg13g2_RCClampInverter_noptap_0.out user_project_wrapper_0.IOVSS1 user_project_wrapper_0.IOVSS1 sg13_hv_nmos ad=2.596p pd=5.58u as=0 ps=0 w=4.4u l=0.6u
X5649 user_project_wrapper_0.IOVSS1 user_project_wrapper_0.sg13g2_IOPadVdd_3.sg13g2_RCClampInverter_noptap_0.out user_project_wrapper_0.IOVSS1 user_project_wrapper_0.IOVSS1 sg13_hv_nmos ad=2.596p pd=5.58u as=0 ps=0 w=4.4u l=0.6u
X5650 IOVDD3 a_355624_156244# analog_io[20] IOVDD3 sg13_hv_pmos ad=2.1312p pd=7.3u as=3.9294p ps=7.84u w=6.66u l=0.6u
X5651 analog_io[23] a_355624_217444# IOVDD3 IOVDD3 sg13_hv_pmos ad=3.9294p pd=7.84u as=2.1312p ps=7.3u w=6.66u l=0.6u
X5652 a_191438_327491# a_191234_327491# user_project_wrapper_0.IOVSS1 user_project_wrapper_0.IOVSS1 sg13_lv_nmos ad=0.19p pd=1.38u as=0.34p ps=2.68u w=1u l=0.13u
X5653 user_project_wrapper_0.IOVDD4 a_135844_355624# user_project_wrapper_0.analog_io[28] user_project_wrapper_0.IOVDD4 sg13_hv_pmos ad=2.1312p pd=7.3u as=3.9294p ps=7.84u w=6.66u l=0.6u
X5654 a_89114_127896# a_88274_127896# user_project_wrapper_0.VDD1 user_project_wrapper_0.VDD1 sg13_lv_pmos ad=0.2128p pd=1.5u as=0.3808p ps=2.92u w=1.12u l=0.13u
X5655 user_project_wrapper_0.IOVSS1 a_217444_369296# user_project_wrapper_0.analog_io[32] user_project_wrapper_0.IOVSS1 sg13_hv_nmos ad=1.408p pd=5.04u as=2.596p ps=5.58u w=4.4u l=0.6u
X5656 a_202114_326125# a_205385_326221# user_project_wrapper_0.IOVSS1 user_project_wrapper_0.IOVSS1 sg13_lv_nmos ad=0.912p pd=5.18u as=0.912p ps=5.18u w=4.8u l=0.13u
X5657 user_project_wrapper_0.IOVSS1 a_135844_29676# user_project_wrapper_0.analog_io[10] user_project_wrapper_0.IOVSS1 sg13_hv_nmos ad=1.408p pd=5.04u as=2.596p ps=5.58u w=4.4u l=0.6u
X5658 user_project_wrapper_0.analog_io[4] a_41476_197044# user_project_wrapper_0.IOVDD1 user_project_wrapper_0.IOVDD1 sg13_hv_pmos ad=3.9294p pd=7.84u as=2.1312p ps=7.3u w=6.66u l=0.6u
X5659 a_360372_77005# a_364458_77335# user_project_wrapper_0.IOVSS1 rppd l=20u w=1u
X5660 IOVDD3 a_355624_278644# analog_io[26] IOVDD3 sg13_hv_pmos ad=2.1312p pd=7.3u as=3.9294p ps=7.84u w=6.66u l=0.6u
X5661 user_project_wrapper_0.analog_io[6] a_29676_237844# user_project_wrapper_0.IOVSS1 user_project_wrapper_0.IOVSS1 sg13_hv_nmos ad=2.596p pd=5.58u as=1.408p ps=5.04u w=4.4u l=0.6u
X5662 user_project_wrapper_0.VDD2 user_project_wrapper_0.sg13g2_IOPadVdd_1.sg13g2_RCClampResistor_0.p2 user_project_wrapper_0.sg13g2_IOPadVdd_1.sg13g2_RCClampInverter_noptap_0.out user_project_wrapper_0.VDD2 sg13_hv_pmos ad=1.33p pd=7.38u as=1.33p ps=7.38u w=7u l=0.5u
X5663 user_project_wrapper_0.IOVDD2 user_project_wrapper_0.sg13g2_IOPadIOVdd_0.sg13g2_Clamp_N43N43D4R_0.gate user_project_wrapper_0.IOVSS1 user_project_wrapper_0.IOVSS1 sg13_hv_nmos ad=2.596p pd=5.58u as=1.408p ps=5.04u w=4.4u l=0.6u
X5664 user_project_wrapper_0.IOVSS1 user_project_wrapper_0.sg13g2_IOPadVdd_0.sg13g2_RCClampInverter_noptap_0.out VDD3 user_project_wrapper_0.IOVSS1 sg13_hv_nmos ad=1.408p pd=5.04u as=2.596p ps=5.58u w=4.4u l=0.6u
X5665 VDD3 a_296625_208423# a_296731_208493# VDD3 sg13_lv_pmos ad=0.2603p pd=1.75u as=0.2603p ps=1.75u w=1.37u l=0.35u
X5666 user_project_wrapper_0.analog_io[6] a_41476_237844# user_project_wrapper_0.IOVDD1 user_project_wrapper_0.IOVDD1 sg13_hv_pmos ad=3.9294p pd=7.84u as=2.1312p ps=7.3u w=6.66u l=0.6u
X5667 user_project_wrapper_0.IOVDD1 a_41476_135844# user_project_wrapper_0.analog_io[1] user_project_wrapper_0.IOVDD1 sg13_hv_pmos ad=2.1312p pd=7.3u as=3.9294p ps=7.84u w=6.66u l=0.6u
X5668 IOVDD3 user_project_wrapper_0.sg13g2_IOPadIOVdd_3.sg13g2_RCClampResistor_0.p2 user_project_wrapper_0.sg13g2_IOPadIOVdd_3.sg13g2_Clamp_N43N43D4R_0.gate IOVDD3 sg13_hv_pmos ad=1.33p pd=7.38u as=1.33p ps=7.38u w=7u l=0.5u
X5669 VDD3 a_309516_194555# a_309917_199879# VDD3 sg13_lv_pmos ad=0.34p pd=2.68u as=0.19p ps=1.38u w=1u l=0.7u
X5670 a_190722_327099# a_189756_326377# user_project_wrapper_0.IOVSS1 user_project_wrapper_0.IOVSS1 sg13_lv_nmos ad=0.19p pd=1.38u as=0.34p ps=2.68u w=1u l=0.13u
X5671 a_194279_327536# a_194193_328627# user_project_wrapper_0.IOVSS1 user_project_wrapper_0.IOVSS1 sg13_lv_pmos ad=1.824p pd=9.98u as=3.264p ps=19.88u w=9.6u l=0.13u
X5672 user_project_wrapper_0.analog_io[28] a_135844_355624# user_project_wrapper_0.IOVDD4 user_project_wrapper_0.IOVDD4 sg13_hv_pmos ad=3.9294p pd=7.84u as=2.1312p ps=7.3u w=6.66u l=0.6u
X5673 a_82527_127455# a_79025_136081# user_project_wrapper_0.VDD1 user_project_wrapper_0.VDD1 sg13_lv_pmos ad=0.3808p pd=2.92u as=0.3808p ps=2.92u w=1.12u l=0.13u
X5674 a_360372_303385# a_364458_303715# user_project_wrapper_0.IOVSS1 rppd l=20u w=1u
X5675 user_project_wrapper_0.IOVDD2 user_project_wrapper_0.sg13g2_IOPadIOVdd_0.sg13g2_Clamp_N43N43D4R_0.gate user_project_wrapper_0.IOVSS1 user_project_wrapper_0.IOVSS1 sg13_hv_nmos ad=2.596p pd=5.58u as=1.408p ps=5.04u w=4.4u l=0.6u
X5676 user_project_wrapper_0.analog_io[32] a_202114_326125# user_project_wrapper_0.IOVSS1 user_project_wrapper_0.IOVSS1 sg13_lv_pmos ad=1.824p pd=9.98u as=1.824p ps=9.98u w=9.6u l=0.13u
X5677 analog_io[26] a_369296_278644# user_project_wrapper_0.IOVSS1 user_project_wrapper_0.IOVSS1 sg13_hv_nmos ad=2.596p pd=5.58u as=1.408p ps=5.04u w=4.4u l=0.6u
X5678 user_project_wrapper_0.IOVSS1 user_project_wrapper_0.sg13g2_IOPadVdd_3.sg13g2_RCClampInverter_noptap_0.out user_project_wrapper_0.IOVSS1 user_project_wrapper_0.IOVSS1 sg13_hv_nmos ad=1.408p pd=5.04u as=0 ps=0 w=4.4u l=0.6u
X5679 a_194687_324142# a_194279_327536# user_project_wrapper_0.IOVSS1 user_project_wrapper_0.IOVSS1 sg13_lv_pmos ad=1.824p pd=9.98u as=1.824p ps=9.98u w=9.6u l=0.13u
X5680 user_project_wrapper_0.IOVDD2 a_258244_41476# user_project_wrapper_0.analog_io[16] user_project_wrapper_0.IOVDD2 sg13_hv_pmos ad=2.1312p pd=7.3u as=3.9294p ps=7.84u w=6.66u l=0.6u
X5681 user_project_wrapper_0.IOVSS1 a_79038_127856# a_79038_127856# user_project_wrapper_0.IOVSS1 sg13_lv_nmos ad=0.1428p pd=1.52u as=0.1428p ps=1.52u w=0.42u l=0.56u
X5682 user_project_wrapper_0.analog_io[13] a_197044_41476# user_project_wrapper_0.IOVDD2 user_project_wrapper_0.IOVDD2 sg13_hv_pmos ad=3.9294p pd=7.84u as=2.1312p ps=7.3u w=6.66u l=0.6u
X5683 a_85052_125418# a_85875_125209# user_project_wrapper_0.VDD1 user_project_wrapper_0.VDD1 sg13_lv_pmos ad=0.3808p pd=2.92u as=0.3808p ps=2.92u w=1.12u l=0.13u
X5684 a_309516_194555# a_309516_194555# VDD3 VDD3 sg13_lv_pmos ad=0.19p pd=1.38u as=0.19p ps=1.38u w=1u l=0.7u
X5685 user_project_wrapper_0.analog_io[32] a_202114_326125# user_project_wrapper_0.IOVSS1 user_project_wrapper_0.IOVSS1 sg13_lv_pmos ad=1.824p pd=9.98u as=1.824p ps=9.98u w=9.6u l=0.13u
X5686 user_project_wrapper_0.IOVSS1 user_project_wrapper_0.sg13g2_IOPadVdd_3.sg13g2_RCClampInverter_noptap_0.out user_project_wrapper_0.IOVSS1 user_project_wrapper_0.IOVSS1 sg13_hv_nmos ad=1.408p pd=5.04u as=0 ps=0 w=4.4u l=0.6u
X5687 user_project_wrapper_0.IOVDD1 a_41476_217444# user_project_wrapper_0.analog_io[5] user_project_wrapper_0.IOVDD1 sg13_hv_pmos ad=2.1312p pd=7.3u as=3.9294p ps=7.84u w=6.66u l=0.6u
X5688 user_project_wrapper_0.IOVSS1 analog_io[25] dantenna l=27.78u w=1.26u
X5689 user_project_wrapper_0.IOVSS1 a_194687_324142# user_project_wrapper_0.analog_io[30] user_project_wrapper_0.IOVSS1 sg13_lv_nmos ad=0.912p pd=5.18u as=0.912p ps=5.18u w=4.8u l=0.13u
X5690 user_project_wrapper_0.analog_io[12] a_176644_29676# user_project_wrapper_0.IOVSS1 user_project_wrapper_0.IOVSS1 sg13_hv_nmos ad=2.596p pd=5.58u as=1.408p ps=5.04u w=4.4u l=0.6u
X5691 a_309917_194695# user_project_wrapper_0.sg13g2_IOPadAnalog_29.padres a_311846_195517# VDD3 sg13_lv_pmos ad=0.24415p pd=1.665u as=0.24415p ps=1.665u w=1.285u l=0.35u
X5692 user_project_wrapper_0.VDD2 user_project_wrapper_0.sg13g2_IOPadVdd_1.sg13g2_RCClampInverter_noptap_0.out user_project_wrapper_0.IOVSS1 user_project_wrapper_0.IOVSS1 sg13_hv_nmos ad=2.596p pd=5.58u as=1.408p ps=5.04u w=4.4u l=0.6u
X5693 user_project_wrapper_0.IOVDD4 user_project_wrapper_0.sg13g2_IOPadIOVdd_2.sg13g2_Clamp_N43N43D4R_0.gate user_project_wrapper_0.IOVSS1 user_project_wrapper_0.IOVSS1 sg13_hv_nmos ad=3.256p pd=10.28u as=1.408p ps=5.04u w=4.4u l=0.6u
X5694 user_project_wrapper_0.IOVSS1 a_194687_324142# user_project_wrapper_0.analog_io[30] user_project_wrapper_0.IOVSS1 sg13_lv_nmos ad=0.912p pd=5.18u as=0.912p ps=5.18u w=4.8u l=0.13u
X5695 user_project_wrapper_0.sg13g2_IOPadAnalog_0.padres IOVDD3 dpantenna l=4.98u w=0.64u
X5696 a_191438_326377# a_191234_326377# user_project_wrapper_0.IOVSS1 w_188704_326203# sg13_lv_pmos ad=0.68p pd=4.68u as=0.38p ps=2.38u w=2u l=0.13u
X5697 user_project_wrapper_0.analog_io[12] a_176644_41476# user_project_wrapper_0.IOVDD2 user_project_wrapper_0.IOVDD2 sg13_hv_pmos ad=3.9294p pd=7.84u as=2.1312p ps=7.3u w=6.66u l=0.6u
X5698 user_project_wrapper_0.IOVSS1 user_project_wrapper_0.sg13g2_IOPadVdd_3.sg13g2_RCClampInverter_noptap_0.out user_project_wrapper_0.IOVSS1 user_project_wrapper_0.IOVSS1 sg13_hv_nmos ad=2.596p pd=5.58u as=0 ps=0 w=4.4u l=0.6u
X5699 user_project_wrapper_0.analog_io[10] a_135844_29676# user_project_wrapper_0.IOVSS1 user_project_wrapper_0.IOVSS1 sg13_hv_nmos ad=2.596p pd=5.58u as=1.408p ps=5.04u w=4.4u l=0.6u
X5700 user_project_wrapper_0.IOVSS1 user_project_wrapper_0.sg13g2_IOPadVdd_2.sg13g2_RCClampResistor_0.p2 user_project_wrapper_0.IOVSS1 user_project_wrapper_0.IOVSS1 sg13_hv_nmos ad=1.71p pd=9.38u as=0 ps=0 w=9u l=9.5u
X5701 VDD3 user_project_wrapper_0.sg13g2_IOPadVdd_0.sg13g2_RCClampInverter_noptap_0.out user_project_wrapper_0.IOVSS1 user_project_wrapper_0.IOVSS1 sg13_hv_nmos ad=2.596p pd=5.58u as=1.408p ps=5.04u w=4.4u l=0.6u
X5702 user_project_wrapper_0.sg13g2_IOPadVdd_1.sg13g2_RCClampInverter_noptap_0.out user_project_wrapper_0.sg13g2_IOPadVdd_1.sg13g2_RCClampResistor_0.p2 user_project_wrapper_0.VDD2 user_project_wrapper_0.VDD2 sg13_hv_pmos ad=1.33p pd=7.38u as=1.33p ps=7.38u w=7u l=0.5u
X5703 user_project_wrapper_0.IOVSS1 a_29676_237844# user_project_wrapper_0.analog_io[6] user_project_wrapper_0.IOVSS1 sg13_hv_nmos ad=2.068p pd=9.74u as=2.596p ps=5.58u w=4.4u l=0.6u
X5704 a_35456_302395# a_39542_302065# user_project_wrapper_0.IOVSS1 rppd l=20u w=1u
X5705 user_project_wrapper_0.IOVSS1 user_project_wrapper_0.sg13g2_IOPadVdd_1.sg13g2_RCClampInverter_noptap_0.out user_project_wrapper_0.VDD2 user_project_wrapper_0.IOVSS1 sg13_hv_nmos ad=1.408p pd=5.04u as=2.596p ps=5.58u w=4.4u l=0.6u
X5706 user_project_wrapper_0.analog_io[30] a_194687_324142# user_project_wrapper_0.IOVSS1 user_project_wrapper_0.IOVSS1 sg13_lv_pmos ad=1.824p pd=9.98u as=1.824p ps=9.98u w=9.6u l=0.13u
X5707 user_project_wrapper_0.IOVSS1 user_project_wrapper_0.sg13g2_IOPadVdd_1.sg13g2_RCClampInverter_noptap_0.out user_project_wrapper_0.VDD2 user_project_wrapper_0.IOVSS1 sg13_hv_nmos ad=1.408p pd=5.04u as=2.596p ps=5.58u w=4.4u l=0.6u
X5708 VDD3 a_296625_208423# a_296731_208493# VDD3 sg13_lv_pmos ad=0.2603p pd=1.75u as=0.2603p ps=1.75u w=1.37u l=0.35u
X5709 user_project_wrapper_0.IOVSS1 user_project_wrapper_0.analog_io[30] dantenna l=1.26u w=27.78u
X5710 user_project_wrapper_0.IOVSS1 user_project_wrapper_0.sg13g2_IOPadVdd_3.sg13g2_RCClampResistor_0.p2 user_project_wrapper_0.IOVSS1 user_project_wrapper_0.IOVSS1 sg13_hv_nmos ad=1.71p pd=9.38u as=0 ps=0 w=9u l=9.5u
X5711 a_210621_327491# a_210417_327491# user_project_wrapper_0.IOVSS1 user_project_wrapper_0.IOVSS1 sg13_lv_nmos ad=0.19p pd=1.38u as=0.34p ps=2.68u w=1u l=0.13u
X5712 user_project_wrapper_0.VDD1 user_project_wrapper_0.sg13g2_IOPadVdd_2.sg13g2_RCClampInverter_noptap_0.out user_project_wrapper_0.IOVSS1 user_project_wrapper_0.IOVSS1 sg13_hv_nmos ad=2.596p pd=5.58u as=1.408p ps=5.04u w=4.4u l=0.6u
X5713 a_202114_326125# a_205385_326221# user_project_wrapper_0.IOVSS1 user_project_wrapper_0.IOVSS1 sg13_lv_pmos ad=1.824p pd=9.98u as=1.824p ps=9.98u w=9.6u l=0.13u
X5714 a_296731_189665# a_296625_189595# VDD3 VDD3 sg13_lv_pmos ad=0.2603p pd=1.75u as=0.2603p ps=1.75u w=1.37u l=0.35u
X5715 user_project_wrapper_0.VDD1 user_project_wrapper_0.analog_io[4] user_project_wrapper_0.IOVSS1 rppd l=2u w=0.5u
X5716 user_project_wrapper_0.analog_io[30] a_194687_324142# user_project_wrapper_0.IOVSS1 user_project_wrapper_0.IOVSS1 sg13_lv_pmos ad=1.824p pd=9.98u as=1.824p ps=9.98u w=9.6u l=0.13u
X5717 user_project_wrapper_0.IOVSS1 user_project_wrapper_0.sg13g2_IOPadVdd_2.sg13g2_RCClampInverter_noptap_0.out user_project_wrapper_0.VDD1 user_project_wrapper_0.IOVSS1 sg13_hv_nmos ad=1.408p pd=5.04u as=2.596p ps=5.58u w=4.4u l=0.6u
X5718 a_296731_189665# a_301186_192011# user_project_wrapper_0.IOVSS1 user_project_wrapper_0.IOVSS1 sg13_lv_nmos ad=0.912p pd=5.18u as=0.912p ps=5.18u w=4.8u l=1.06u
X5719 user_project_wrapper_0.IOVSS1 a_213870_324142# user_project_wrapper_0.analog_io[35] user_project_wrapper_0.IOVSS1 sg13_lv_nmos ad=0.912p pd=5.18u as=0.912p ps=5.18u w=4.8u l=0.13u
X5720 user_project_wrapper_0.analog_io[27] a_182931_326125# user_project_wrapper_0.IOVSS1 user_project_wrapper_0.IOVSS1 sg13_lv_nmos ad=0.912p pd=5.18u as=0.912p ps=5.18u w=4.8u l=0.13u
X5721 user_project_wrapper_0.IOVSS1 user_project_wrapper_0.sg13g2_IOPadVdd_3.sg13g2_RCClampInverter_noptap_0.out user_project_wrapper_0.IOVSS1 user_project_wrapper_0.IOVSS1 sg13_hv_nmos ad=2.596p pd=5.58u as=0 ps=0 w=4.4u l=0.6u
X5722 user_project_wrapper_0.IOVSS1 a_213870_324142# user_project_wrapper_0.analog_io[35] user_project_wrapper_0.IOVSS1 sg13_lv_nmos ad=0.912p pd=5.18u as=0.912p ps=5.18u w=4.8u l=0.13u
X5723 a_309917_199879# a_309516_194555# VDD3 VDD3 sg13_lv_pmos ad=0.19p pd=1.38u as=0.19p ps=1.38u w=1u l=0.7u
X5724 user_project_wrapper_0.IOVDD4 a_176644_355624# user_project_wrapper_0.analog_io[30] user_project_wrapper_0.IOVDD4 sg13_hv_pmos ad=2.1312p pd=7.3u as=3.9294p ps=7.84u w=6.66u l=0.6u
X5725 user_project_wrapper_0.IOVDD2 a_156244_41476# user_project_wrapper_0.analog_io[11] user_project_wrapper_0.IOVDD2 sg13_hv_pmos ad=3.1302p pd=14.26u as=3.9294p ps=7.84u w=6.66u l=0.6u
X5726 a_311846_195517# a_311846_195517# user_project_wrapper_0.IOVSS1 user_project_wrapper_0.IOVSS1 sg13_lv_nmos ad=0.6327p pd=3.71u as=0.6327p ps=3.71u w=3.33u l=0.2u
X5727 a_79025_133504# user_project_wrapper_0.sg13g2_IOPadAnalog_9.padres a_79038_132662# user_project_wrapper_0.VDD1 sg13_lv_pmos ad=1.7p pd=10.68u as=0.95p ps=5.38u w=5u l=0.3u
X5728 user_project_wrapper_0.IOVSS1 a_194687_324142# user_project_wrapper_0.analog_io[30] user_project_wrapper_0.IOVSS1 sg13_lv_nmos ad=0.912p pd=5.18u as=0.912p ps=5.18u w=4.8u l=0.13u
X5729 user_project_wrapper_0.analog_io[0] a_29676_115444# user_project_wrapper_0.IOVSS1 user_project_wrapper_0.IOVSS1 sg13_hv_nmos ad=2.596p pd=5.58u as=1.408p ps=5.04u w=4.4u l=0.6u
X5730 a_83592_125209# a_82826_124842# a_83490_125209# user_project_wrapper_0.IOVSS1 sg13_lv_nmos ad=0.1406p pd=1.12u as=0.1406p ps=1.12u w=0.74u l=0.13u
X5731 user_project_wrapper_0.VDD1 a_78824_130881# a_78824_130881# user_project_wrapper_0.VDD1 sg13_lv_pmos ad=1.7p pd=10.68u as=0.95p ps=5.38u w=5u l=0.15u
X5732 a_79315_364458# a_78985_360372# user_project_wrapper_0.IOVSS1 rppd l=20u w=1u
X5733 user_project_wrapper_0.analog_io[32] a_217444_369296# user_project_wrapper_0.IOVSS1 user_project_wrapper_0.IOVSS1 sg13_hv_nmos ad=2.596p pd=5.58u as=1.408p ps=5.04u w=4.4u l=0.6u
X5734 a_79025_129164# user_project_wrapper_0.sg13g2_IOPadAnalog_9.padres a_79038_128322# user_project_wrapper_0.VDD1 sg13_lv_pmos ad=1.7p pd=10.68u as=0.95p ps=5.38u w=5u l=0.3u
X5735 user_project_wrapper_0.IOVDD4 user_project_wrapper_0.sg13g2_IOPadIOVdd_2.sg13g2_RCClampResistor_0.p2 user_project_wrapper_0.sg13g2_IOPadIOVdd_2.sg13g2_Clamp_N43N43D4R_0.gate user_project_wrapper_0.IOVDD4 sg13_hv_pmos ad=1.33p pd=7.38u as=1.33p ps=7.38u w=7u l=0.5u
X5736 a_190389_101343# a_189729_101343# user_project_wrapper_0.IOVSS1 user_project_wrapper_0.IOVSS1 sg13_lv_nmos ad=0.1406p pd=1.12u as=0.2516p ps=2.16u w=0.74u l=0.13u
X5737 a_314793_201808# a_314697_196700# a_314697_196700# user_project_wrapper_0.IOVSS1 sg13_lv_nmos ad=0.68p pd=4.68u as=0.68p ps=4.68u w=2u l=1u
X5738 user_project_wrapper_0.IOVSS1 a_135844_369296# user_project_wrapper_0.analog_io[28] user_project_wrapper_0.IOVSS1 sg13_hv_nmos ad=1.408p pd=5.04u as=2.596p ps=5.58u w=4.4u l=0.6u
X5739 user_project_wrapper_0.IOVSS1 a_211321_324119# a_210983_324119# user_project_wrapper_0.IOVSS1 sg13_lv_nmos ad=0.34p pd=2.68u as=0.34p ps=2.68u w=1u l=0.65u
X5740 user_project_wrapper_0.IOVSS1 user_project_wrapper_0.sg13g2_IOPadVdd_1.sg13g2_RCClampInverter_noptap_0.out user_project_wrapper_0.VDD2 user_project_wrapper_0.IOVSS1 sg13_hv_nmos ad=1.408p pd=5.04u as=2.596p ps=5.58u w=4.4u l=0.6u
X5741 user_project_wrapper_0.VDD2 user_project_wrapper_0.sg13g2_IOPadVdd_1.sg13g2_RCClampInverter_noptap_0.out user_project_wrapper_0.IOVSS1 user_project_wrapper_0.IOVSS1 sg13_hv_nmos ad=2.596p pd=5.58u as=1.408p ps=5.04u w=4.4u l=0.6u
X5742 a_209480_329719# a_208939_329719# user_project_wrapper_0.IOVSS1 user_project_wrapper_0.IOVSS1 sg13_lv_nmos ad=0.34p pd=2.68u as=0.34p ps=2.68u w=1u l=0.13u
X5743 user_project_wrapper_0.IOVSS1 user_project_wrapper_0.sg13g2_IOPadAnalog_4.padres dantenna l=3.1u w=0.64u
X5744 user_project_wrapper_0.IOVSS1 user_project_wrapper_0.sg13g2_IOPadAnalog_3.padres dantenna l=0.64u w=3.1u
X5745 a_296731_189665# a_296625_189595# VDD3 VDD3 sg13_lv_pmos ad=0.2603p pd=1.75u as=0.4658p ps=3.42u w=1.37u l=0.35u
X5746 analog_io[20] a_369296_156244# user_project_wrapper_0.IOVSS1 user_project_wrapper_0.IOVSS1 sg13_hv_nmos ad=2.596p pd=5.58u as=1.408p ps=5.04u w=4.4u l=0.6u
X5747 VDD3 a_309516_194555# a_309917_194695# VDD3 sg13_lv_pmos ad=0.19p pd=1.38u as=0.19p ps=1.38u w=1u l=0.7u
X5748 user_project_wrapper_0.analog_io[4] a_29676_197044# user_project_wrapper_0.IOVSS1 user_project_wrapper_0.IOVSS1 sg13_hv_nmos ad=2.596p pd=5.58u as=1.408p ps=5.04u w=4.4u l=0.6u
X5749 user_project_wrapper_0.IOVSS1 a_29676_135844# user_project_wrapper_0.analog_io[1] user_project_wrapper_0.IOVSS1 sg13_hv_nmos ad=1.408p pd=5.04u as=2.596p ps=5.58u w=4.4u l=0.6u
X5750 user_project_wrapper_0.analog_io[10] a_135844_41476# user_project_wrapper_0.IOVDD2 user_project_wrapper_0.IOVDD2 sg13_hv_pmos ad=3.9294p pd=7.84u as=2.1312p ps=7.3u w=6.66u l=0.6u
X5751 a_296731_208493# a_296625_208423# VDD3 VDD3 sg13_lv_pmos ad=0.2603p pd=1.75u as=0.2603p ps=1.75u w=1.37u l=0.35u
X5752 user_project_wrapper_0.IOVSS1 user_project_wrapper_0.sg13g2_IOPadIOVdd_1.sg13g2_Clamp_N43N43D4R_0.gate user_project_wrapper_0.IOVDD1 user_project_wrapper_0.IOVSS1 sg13_hv_nmos ad=1.408p pd=5.04u as=2.596p ps=5.58u w=4.4u l=0.6u
X5753 QDLL_TOP_0.VDD a_270512_100118# a_271172_100118# QDLL_TOP_0.VDD sg13_lv_pmos ad=0.2128p pd=1.5u as=0.2128p ps=1.5u w=1.12u l=0.13u
X5754 user_project_wrapper_0.IOVSS1 a_213870_324142# user_project_wrapper_0.analog_io[35] user_project_wrapper_0.IOVSS1 sg13_lv_nmos ad=0.912p pd=5.18u as=0.912p ps=5.18u w=4.8u l=0.13u
X5755 a_189858_325263# a_189756_326377# a_189756_325263# user_project_wrapper_0.IOVSS1 sg13_lv_nmos ad=0.19p pd=1.38u as=0.19p ps=1.38u w=1u l=0.13u
X5756 user_project_wrapper_0.IOVSS1 a_237844_29676# user_project_wrapper_0.analog_io[15] user_project_wrapper_0.IOVSS1 sg13_hv_nmos ad=1.408p pd=5.04u as=2.596p ps=5.58u w=4.4u l=0.6u
X5757 user_project_wrapper_0.IOVSS1 a_213870_324142# user_project_wrapper_0.analog_io[35] user_project_wrapper_0.IOVSS1 sg13_lv_nmos ad=0.912p pd=5.18u as=0.912p ps=5.18u w=4.8u l=0.13u
X5758 user_project_wrapper_0.IOVSS1 user_project_wrapper_0.sg13g2_IOPadVdd_1.sg13g2_RCClampInverter_noptap_0.out user_project_wrapper_0.VDD2 user_project_wrapper_0.IOVSS1 sg13_hv_nmos ad=1.408p pd=5.04u as=2.596p ps=5.58u w=4.4u l=0.6u
X5759 a_210621_326377# a_210417_326377# user_project_wrapper_0.IOVSS1 w_207887_326203# sg13_lv_pmos ad=0.68p pd=4.68u as=0.38p ps=2.38u w=2u l=0.13u
X5760 user_project_wrapper_0.analog_io[13] a_197044_41476# user_project_wrapper_0.IOVDD2 user_project_wrapper_0.IOVDD2 sg13_hv_pmos ad=3.9294p pd=7.84u as=2.1312p ps=7.3u w=6.66u l=0.6u
X5761 IOVDD3 a_355624_115444# analog_io[18] IOVDD3 sg13_hv_pmos ad=2.1312p pd=7.3u as=3.9294p ps=7.84u w=6.66u l=0.6u
X5762 a_311846_195517# user_project_wrapper_0.sg13g2_IOPadAnalog_29.padres a_309917_199879# VDD3 sg13_lv_pmos ad=0.4369p pd=3.25u as=0.24415p ps=1.665u w=1.285u l=0.35u
X5763 a_309917_194695# a_309516_194555# VDD3 VDD3 sg13_lv_pmos ad=0.19p pd=1.38u as=0.19p ps=1.38u w=1u l=0.7u
X5764 a_206547_324106# a_209230_324119# user_project_wrapper_0.IOVSS1 user_project_wrapper_0.IOVSS1 sg13_lv_nmos ad=0.19p pd=1.38u as=0.19p ps=1.38u w=1u l=0.13u
X5765 user_project_wrapper_0.VDD1 user_project_wrapper_0.sg13g2_IOPadVdd_2.sg13g2_RCClampInverter_noptap_0.out user_project_wrapper_0.IOVSS1 user_project_wrapper_0.IOVSS1 sg13_hv_nmos ad=2.596p pd=5.58u as=1.408p ps=5.04u w=4.4u l=0.6u
X5766 a_296731_208493# a_296625_208423# VDD3 VDD3 sg13_lv_pmos ad=0.2603p pd=1.75u as=0.4658p ps=3.42u w=1.37u l=0.35u
X5767 user_project_wrapper_0.analog_io[5] a_41476_217444# user_project_wrapper_0.IOVDD1 user_project_wrapper_0.IOVDD1 sg13_hv_pmos ad=3.9294p pd=7.84u as=2.1312p ps=7.3u w=6.66u l=0.6u
X5768 user_project_wrapper_0.IOVSS1 user_project_wrapper_0.sg13g2_IOPadVdd_3.sg13g2_RCClampInverter_noptap_0.out user_project_wrapper_0.IOVSS1 user_project_wrapper_0.IOVSS1 sg13_hv_nmos ad=1.408p pd=5.04u as=0 ps=0 w=4.4u l=0.6u
X5769 a_307232_196607# a_296731_208493# a_309917_199879# VDD3 sg13_lv_pmos ad=0.24415p pd=1.665u as=0.24415p ps=1.665u w=1.285u l=0.35u
X5770 user_project_wrapper_0.IOVSS1 user_project_wrapper_0.sg13g2_IOPadIOVdd_0.sg13g2_Clamp_N43N43D4R_0.gate user_project_wrapper_0.IOVDD2 user_project_wrapper_0.IOVSS1 sg13_hv_nmos ad=1.408p pd=5.04u as=2.596p ps=5.58u w=4.4u l=0.6u
X5771 user_project_wrapper_0.IOVSS1 user_project_wrapper_0.IOVSS1 user_project_wrapper_0.IOVSS1 rppd l=0.5u w=0.5u
X5772 a_307232_196607# a_296731_189665# a_309917_194695# VDD3 sg13_lv_pmos ad=0.24415p pd=1.665u as=0.24415p ps=1.665u w=1.285u l=0.35u
X5773 user_project_wrapper_0.sg13g2_IOPadIOVdd_2.sg13g2_Clamp_N43N43D4R_0.gate user_project_wrapper_0.sg13g2_IOPadIOVdd_2.sg13g2_RCClampResistor_0.p2 user_project_wrapper_0.IOVSS1 user_project_wrapper_0.IOVSS1 sg13_hv_nmos ad=1.71p pd=9.38u as=1.71p ps=9.38u w=9u l=0.5u
X5774 a_190501_328605# a_189184_328605# user_project_wrapper_0.IOVSS1 w_188704_327938# sg13_lv_pmos ad=0.68p pd=4.68u as=0.68p ps=4.68u w=2u l=0.13u
X5775 user_project_wrapper_0.IOVSS1 user_project_wrapper_0.sg13g2_IOPadIOVdd_0.sg13g2_Clamp_N43N43D4R_0.gate user_project_wrapper_0.IOVDD2 user_project_wrapper_0.IOVSS1 sg13_hv_nmos ad=1.408p pd=5.04u as=2.596p ps=5.58u w=4.4u l=0.6u
X5776 a_309917_194695# a_296731_189665# a_307232_196607# VDD3 sg13_lv_pmos ad=0.24415p pd=1.665u as=0.24415p ps=1.665u w=1.285u l=0.35u
X5777 user_project_wrapper_0.IOVSS1 user_project_wrapper_0.IOVSS1 user_project_wrapper_0.IOVSS1 rppd l=0.5u w=0.5u
X5778 a_304196_197873# a_304090_197941# a_296625_189595# user_project_wrapper_0.IOVSS1 sg13_lv_nmos ad=0.361p pd=2.28u as=0.361p ps=2.28u w=1.9u l=0.16u
X5779 a_82872_125209# user_project_wrapper_0.sg13g2_IOPadIn$1_0.p2c a_82770_125209# user_project_wrapper_0.VDD1 sg13_lv_pmos ad=0.2128p pd=1.5u as=0.2128p ps=1.5u w=1.12u l=0.13u
X5780 analog_io[18] a_369296_115444# user_project_wrapper_0.IOVSS1 user_project_wrapper_0.IOVSS1 sg13_hv_nmos ad=2.596p pd=5.58u as=1.408p ps=5.04u w=4.4u l=0.6u
X5781 user_project_wrapper_0.analog_io[7] a_41476_258244# user_project_wrapper_0.IOVDD1 user_project_wrapper_0.IOVDD1 sg13_hv_pmos ad=3.9294p pd=7.84u as=2.1312p ps=7.3u w=6.66u l=0.6u
X5782 a_304196_200821# a_304090_197941# a_296625_208423# user_project_wrapper_0.IOVSS1 sg13_lv_nmos ad=0.361p pd=2.28u as=0.361p ps=2.28u w=1.9u l=0.16u
X5783 user_project_wrapper_0.analog_io[34] a_258244_355624# user_project_wrapper_0.IOVDD4 user_project_wrapper_0.IOVDD4 sg13_hv_pmos ad=3.9294p pd=7.84u as=2.1312p ps=7.3u w=6.66u l=0.6u
X5784 analog_io[25] a_355624_258244# IOVDD3 IOVDD3 sg13_hv_pmos ad=3.9294p pd=7.84u as=2.1312p ps=7.3u w=6.66u l=0.6u
X5785 QDLL_TOP_0.VOUT a_271172_100118# user_project_wrapper_0.IOVSS1 user_project_wrapper_0.IOVSS1 sg13_lv_nmos ad=0.1406p pd=1.12u as=0.1406p ps=1.12u w=0.74u l=0.13u
X5786 user_project_wrapper_0.VDD2 user_project_wrapper_0.sg13g2_IOPadVdd_1.sg13g2_RCClampInverter_noptap_0.out user_project_wrapper_0.IOVSS1 user_project_wrapper_0.IOVSS1 sg13_hv_nmos ad=2.596p pd=5.58u as=1.408p ps=5.04u w=4.4u l=0.6u
X5787 user_project_wrapper_0.IOVSS1 user_project_wrapper_0.sg13g2_IOPadVdd_1.sg13g2_RCClampInverter_noptap_0.out user_project_wrapper_0.VDD2 user_project_wrapper_0.IOVSS1 sg13_hv_nmos ad=1.408p pd=5.04u as=2.596p ps=5.58u w=4.4u l=0.6u
X5788 user_project_wrapper_0.IOVSS1 user_project_wrapper_0.sg13g2_IOPadIOVdd_1.sg13g2_Clamp_N43N43D4R_0.gate user_project_wrapper_0.IOVDD1 user_project_wrapper_0.IOVSS1 sg13_hv_nmos ad=1.408p pd=5.04u as=2.596p ps=5.58u w=4.4u l=0.6u
X5789 a_304995_198817# a_304889_198885# a_304196_197873# user_project_wrapper_0.IOVSS1 sg13_lv_nmos ad=0.209p pd=1.48u as=0.209p ps=1.48u w=1.1u l=0.15u
X5790 user_project_wrapper_0.IOVSS1 user_project_wrapper_0.sg13g2_IOPadVdd_0.sg13g2_RCClampInverter_noptap_0.out VDD3 user_project_wrapper_0.IOVSS1 sg13_hv_nmos ad=1.408p pd=5.04u as=2.596p ps=5.58u w=4.4u l=0.6u
X5791 user_project_wrapper_0.IOVDD2 a_156244_41476# user_project_wrapper_0.analog_io[11] user_project_wrapper_0.IOVDD2 sg13_hv_pmos ad=2.1312p pd=7.3u as=3.9294p ps=7.84u w=6.66u l=0.6u
X5792 user_project_wrapper_0.IOVSS1 a_190297_325263# a_190926_325785# w_188704_326203# sg13_lv_pmos ad=0.68p pd=4.68u as=0.38p ps=2.38u w=2u l=0.13u
X5793 user_project_wrapper_0.IOVSS1 user_project_wrapper_0.sg13g2_IOPadIOVdd_3.sg13g2_RCClampResistor_0.p2 user_project_wrapper_0.IOVSS1 user_project_wrapper_0.IOVSS1 sg13_hv_nmos ad=3.06p pd=18.68u as=0 ps=0 w=9u l=9.5u
X5794 QDLL_TOP_0.VOUT a_278644_41476# user_project_wrapper_0.IOVDD2 user_project_wrapper_0.IOVDD2 sg13_hv_pmos ad=3.9294p pd=7.84u as=2.1312p ps=7.3u w=6.66u l=0.6u
X5795 user_project_wrapper_0.analog_io[32] a_202114_326125# user_project_wrapper_0.IOVSS1 user_project_wrapper_0.IOVSS1 sg13_lv_pmos ad=1.824p pd=9.98u as=1.824p ps=9.98u w=9.6u l=0.13u
X5796 user_project_wrapper_0.IOVSS1 user_project_wrapper_0.sg13g2_IOPadIOVdd_2.sg13g2_Clamp_N43N43D4R_0.gate user_project_wrapper_0.IOVDD4 user_project_wrapper_0.IOVSS1 sg13_hv_nmos ad=1.408p pd=5.04u as=2.596p ps=5.58u w=4.4u l=0.6u
X5797 user_project_wrapper_0.analog_io[0] a_29676_115444# user_project_wrapper_0.IOVSS1 user_project_wrapper_0.IOVSS1 sg13_hv_nmos ad=2.596p pd=5.58u as=1.408p ps=5.04u w=4.4u l=0.6u
X5798 a_296731_189665# a_301186_192011# user_project_wrapper_0.IOVSS1 user_project_wrapper_0.IOVSS1 sg13_lv_nmos ad=0.912p pd=5.18u as=0.912p ps=5.18u w=4.8u l=1.06u
X5799 user_project_wrapper_0.IOVSS1 a_77638_59490# user_project_wrapper_0.sg13g2_IOPadIn$1_1.p2c user_project_wrapper_0.IOVSS1 sg13_lv_nmos ad=0.935p pd=6.18u as=0.935p ps=6.18u w=2.75u l=0.13u
X5800 a_311189_185546# a_311189_185546# VDD3 VDD3 sg13_lv_pmos ad=1.9p pd=10.38u as=1.9p ps=10.38u w=10u l=1u
X5801 user_project_wrapper_0.VDD1 a_82645_242401# a_82846_242854# user_project_wrapper_0.VDD1 sg13_lv_pmos ad=1.7p pd=10.68u as=0.95p ps=5.38u w=5u l=0.15u
X5802 a_210007_325263# a_209684_325263# a_209905_325785# w_207887_326203# sg13_lv_pmos ad=0.38p pd=2.38u as=0.38p ps=2.38u w=2u l=0.13u
X5803 user_project_wrapper_0.IOVSS1 a_202114_326125# user_project_wrapper_0.analog_io[32] user_project_wrapper_0.IOVSS1 sg13_lv_nmos ad=0.912p pd=5.18u as=0.912p ps=5.18u w=4.8u l=0.13u
X5804 user_project_wrapper_0.sg13g2_IOPadVdd_3.sg13g2_RCClampInverter_noptap_0.out user_project_wrapper_0.sg13g2_IOPadVdd_3.sg13g2_RCClampResistor_0.p2 user_project_wrapper_0.IOVSS1 user_project_wrapper_0.IOVSS1 sg13_hv_pmos ad=1.33p pd=7.38u as=1.33p ps=7.38u w=7u l=0.5u
X5805 user_project_wrapper_0.IOVSS1 user_project_wrapper_0.sg13g2_IOPadIOVdd_0.sg13g2_Clamp_N43N43D4R_0.gate user_project_wrapper_0.IOVDD2 user_project_wrapper_0.IOVSS1 sg13_hv_nmos ad=1.408p pd=5.04u as=2.596p ps=5.58u w=4.4u l=0.6u
X5806 user_project_wrapper_0.IOVSS1 user_project_wrapper_0.sg13g2_IOPadVdd_1.sg13g2_RCClampResistor_0.p2 user_project_wrapper_0.IOVSS1 user_project_wrapper_0.IOVSS1 sg13_hv_nmos ad=1.71p pd=9.38u as=0 ps=0 w=9u l=9.5u
X5807 user_project_wrapper_0.sg13g2_IOPadVdd_0.sg13g2_RCClampInverter_noptap_0.out user_project_wrapper_0.sg13g2_IOPadVdd_0.sg13g2_RCClampResistor_0.p2 VDD3 VDD3 sg13_hv_pmos ad=1.33p pd=7.38u as=1.33p ps=7.38u w=7u l=0.5u
X5808 user_project_wrapper_0.IOVDD2 a_197044_41476# user_project_wrapper_0.analog_io[13] user_project_wrapper_0.IOVDD2 sg13_hv_pmos ad=2.1312p pd=7.3u as=3.9294p ps=7.84u w=6.66u l=0.6u
X5809 user_project_wrapper_0.analog_io[1] a_41476_135844# user_project_wrapper_0.IOVDD1 user_project_wrapper_0.IOVDD1 sg13_hv_pmos ad=3.9294p pd=7.84u as=2.1312p ps=7.3u w=6.66u l=0.6u
X5810 user_project_wrapper_0.IOVSS1 user_project_wrapper_0.sg13g2_IOPadVdd_3.sg13g2_RCClampInverter_noptap_0.out user_project_wrapper_0.IOVSS1 user_project_wrapper_0.IOVSS1 sg13_hv_nmos ad=1.408p pd=5.04u as=0 ps=0 w=4.4u l=0.6u
X5811 user_project_wrapper_0.IOVSS1 user_project_wrapper_0.sg13g2_IOPadIOVdd_3.sg13g2_RCClampResistor_0.p2 user_project_wrapper_0.IOVSS1 user_project_wrapper_0.IOVSS1 sg13_hv_nmos ad=3.06p pd=18.68u as=0 ps=0 w=9u l=9.5u
X5812 user_project_wrapper_0.analog_io[28] a_135844_369296# user_project_wrapper_0.IOVSS1 user_project_wrapper_0.IOVSS1 sg13_hv_nmos ad=2.596p pd=5.58u as=1.408p ps=5.04u w=4.4u l=0.6u
X5813 user_project_wrapper_0.IOVSS1 user_project_wrapper_0.sg13g2_IOPadVdd_2.sg13g2_RCClampInverter_noptap_0.out user_project_wrapper_0.VDD1 user_project_wrapper_0.IOVSS1 sg13_hv_nmos ad=1.408p pd=5.04u as=2.596p ps=5.58u w=4.4u l=0.6u
X5814 VDD3 a_296625_189595# a_296731_189665# VDD3 sg13_lv_pmos ad=0.2603p pd=1.75u as=0.2603p ps=1.75u w=1.37u l=0.35u
X5815 user_project_wrapper_0.sg13g2_IOPadVdd_2.sg13g2_RCClampInverter_noptap_0.out user_project_wrapper_0.sg13g2_IOPadVdd_2.sg13g2_RCClampResistor_0.p2 user_project_wrapper_0.VDD1 user_project_wrapper_0.VDD1 sg13_hv_pmos ad=1.33p pd=7.38u as=2.38p ps=14.68u w=7u l=0.5u
X5816 a_191438_326377# a_191234_326377# user_project_wrapper_0.IOVSS1 w_188704_326203# sg13_lv_pmos ad=0.38p pd=2.38u as=0.68p ps=4.68u w=2u l=0.13u
X5817 VDD3 a_296625_189595# a_296731_189665# VDD3 sg13_lv_pmos ad=0.2603p pd=1.75u as=0.2603p ps=1.75u w=1.37u l=0.35u
X5818 IOVDD3 user_project_wrapper_0.sg13g2_IOPadIOVdd_3.sg13g2_Clamp_N43N43D4R_0.gate user_project_wrapper_0.IOVSS1 user_project_wrapper_0.IOVSS1 sg13_hv_nmos ad=2.596p pd=5.58u as=1.408p ps=5.04u w=4.4u l=0.6u
X5819 IOVDD3 user_project_wrapper_0.sg13g2_IOPadIOVdd_3.sg13g2_Clamp_N43N43D4R_0.gate user_project_wrapper_0.IOVSS1 user_project_wrapper_0.IOVSS1 sg13_hv_nmos ad=2.596p pd=5.58u as=1.408p ps=5.04u w=4.4u l=0.6u
X5820 user_project_wrapper_0.analog_io[13] a_197044_29676# user_project_wrapper_0.IOVSS1 user_project_wrapper_0.IOVSS1 sg13_hv_nmos ad=2.596p pd=5.58u as=1.408p ps=5.04u w=4.4u l=0.6u
X5821 user_project_wrapper_0.IOVDD1 a_41476_258244# user_project_wrapper_0.analog_io[7] user_project_wrapper_0.IOVDD1 sg13_hv_pmos ad=2.1312p pd=7.3u as=3.9294p ps=7.84u w=6.66u l=0.6u
X5822 user_project_wrapper_0.IOVDD4 user_project_wrapper_0.sg13g2_IOPadIOVdd_2.sg13g2_Clamp_N43N43D4R_0.gate user_project_wrapper_0.IOVSS1 user_project_wrapper_0.IOVSS1 sg13_hv_nmos ad=2.596p pd=5.58u as=1.408p ps=5.04u w=4.4u l=0.6u
X5823 user_project_wrapper_0.analog_io[30] a_176644_355624# user_project_wrapper_0.IOVDD4 user_project_wrapper_0.IOVDD4 sg13_hv_pmos ad=3.9294p pd=7.84u as=3.1302p ps=14.26u w=6.66u l=0.6u
X5824 user_project_wrapper_0.analog_io[10] a_135844_41476# user_project_wrapper_0.IOVDD2 user_project_wrapper_0.IOVDD2 sg13_hv_pmos ad=3.9294p pd=7.84u as=2.1312p ps=7.3u w=6.66u l=0.6u
X5825 a_369296_176644# user_project_wrapper_0.IOVSS1 user_project_wrapper_0.IOVSS1 rppd l=3.54u w=0.5u
X5826 user_project_wrapper_0.sg13g2_IOPadIn$1_1.sg13g2_LevelDown_noptap$1_0.sg13g2_SecondaryProtection$1$1_0.core user_project_wrapper_0.ui_PAD[9] user_project_wrapper_0.IOVSS1 rppd l=2u w=1u
X5827 user_project_wrapper_0.IOVSS1 user_project_wrapper_0.IOVSS1 dantenna l=27.78u w=1.26u
X5828 user_project_wrapper_0.IOVDD4 user_project_wrapper_0.sg13g2_IOPadIOVdd_2.sg13g2_Clamp_N43N43D4R_0.gate user_project_wrapper_0.IOVSS1 user_project_wrapper_0.IOVSS1 sg13_hv_nmos ad=2.596p pd=5.58u as=1.408p ps=5.04u w=4.4u l=0.6u
X5829 VDD3 user_project_wrapper_0.sg13g2_IOPadVdd_0.sg13g2_RCClampInverter_noptap_0.out user_project_wrapper_0.IOVSS1 user_project_wrapper_0.IOVSS1 sg13_hv_nmos ad=2.596p pd=5.58u as=1.408p ps=5.04u w=4.4u l=0.6u
X5830 a_309917_194695# a_296731_189665# a_307232_196607# VDD3 sg13_lv_pmos ad=0.24415p pd=1.665u as=0.4369p ps=3.25u w=1.285u l=0.35u
X5831 a_189286_327099# a_189184_327491# a_189184_326377# user_project_wrapper_0.IOVSS1 sg13_lv_nmos ad=0.19p pd=1.38u as=0.19p ps=1.38u w=1u l=0.13u
X5832 a_190490_98199# user_project_wrapper_0.analog_io[14] QDLL_TOP_0.VDD QDLL_TOP_0.VDD sg13_lv_pmos ad=0.2128p pd=1.5u as=0.2128p ps=1.5u w=1.12u l=0.13u
X5833 user_project_wrapper_0.IOVSS1 a_176644_369296# user_project_wrapper_0.IOVSS1 rppd l=3.54u w=0.5u
X5834 user_project_wrapper_0.IOVSS1 user_project_wrapper_0.IOVSS1 user_project_wrapper_0.IOVSS1 rppd l=0.5u w=0.5u
X5835 a_194687_324142# a_194279_327536# user_project_wrapper_0.IOVSS1 user_project_wrapper_0.IOVSS1 sg13_lv_pmos ad=1.824p pd=9.98u as=1.824p ps=9.98u w=9.6u l=0.13u
X5836 user_project_wrapper_0.IOVDD1 user_project_wrapper_0.sg13g2_IOPadIOVdd_1.sg13g2_Clamp_N43N43D4R_0.gate user_project_wrapper_0.IOVSS1 user_project_wrapper_0.IOVSS1 sg13_hv_nmos ad=2.596p pd=5.58u as=1.408p ps=5.04u w=4.4u l=0.6u
X5837 a_314697_196700# a_314697_196700# VDD3 VDD3 sg13_lv_pmos ad=1.14p pd=6.38u as=1.14p ps=6.38u w=6u l=2.5u
X5838 user_project_wrapper_0.IOVDD1 user_project_wrapper_0.sg13g2_IOPadIOVdd_1.sg13g2_Clamp_N43N43D4R_0.gate user_project_wrapper_0.IOVSS1 user_project_wrapper_0.IOVSS1 sg13_hv_nmos ad=2.596p pd=5.58u as=1.408p ps=5.04u w=4.4u l=0.6u
X5839 user_project_wrapper_0.analog_io[12] a_176644_29676# user_project_wrapper_0.IOVSS1 user_project_wrapper_0.IOVSS1 sg13_hv_nmos ad=2.596p pd=5.58u as=1.408p ps=5.04u w=4.4u l=0.6u
X5840 user_project_wrapper_0.IOVSS1 a_217444_369296# user_project_wrapper_0.analog_io[32] user_project_wrapper_0.IOVSS1 sg13_hv_nmos ad=1.408p pd=5.04u as=2.596p ps=5.58u w=4.4u l=0.6u
X5841 user_project_wrapper_0.VDD2 user_project_wrapper_0.sg13g2_IOPadVdd_1.sg13g2_RCClampInverter_noptap_0.out user_project_wrapper_0.IOVSS1 user_project_wrapper_0.IOVSS1 sg13_hv_nmos ad=2.596p pd=5.58u as=1.408p ps=5.04u w=4.4u l=0.6u
X5842 a_210417_327491# a_210007_327491# user_project_wrapper_0.IOVSS1 user_project_wrapper_0.IOVSS1 sg13_lv_nmos ad=0.34p pd=2.68u as=0.34p ps=2.68u w=1u l=0.13u
X5843 user_project_wrapper_0.analog_io[5] a_41476_217444# user_project_wrapper_0.IOVDD1 user_project_wrapper_0.IOVDD1 sg13_hv_pmos ad=3.9294p pd=7.84u as=2.1312p ps=7.3u w=6.66u l=0.6u
X5844 user_project_wrapper_0.IOVDD2 a_156244_41476# user_project_wrapper_0.analog_io[11] user_project_wrapper_0.IOVDD2 sg13_hv_pmos ad=2.1312p pd=7.3u as=3.9294p ps=7.84u w=6.66u l=0.6u
X5845 VDD3 a_296625_208423# a_296731_208493# VDD3 sg13_lv_pmos ad=0.2603p pd=1.75u as=0.2603p ps=1.75u w=1.37u l=0.35u
X5846 user_project_wrapper_0.analog_io[32] a_202114_326125# user_project_wrapper_0.IOVSS1 user_project_wrapper_0.IOVSS1 sg13_lv_pmos ad=1.824p pd=9.98u as=1.824p ps=9.98u w=9.6u l=0.13u
X5847 user_project_wrapper_0.analog_io[30] a_194687_324142# user_project_wrapper_0.IOVSS1 user_project_wrapper_0.IOVSS1 sg13_lv_pmos ad=1.824p pd=9.98u as=1.824p ps=9.98u w=9.6u l=0.13u
X5848 VDD3 a_309516_194555# a_309917_194695# VDD3 sg13_lv_pmos ad=0.19p pd=1.38u as=0.19p ps=1.38u w=1u l=0.7u
X5849 user_project_wrapper_0.IOVSS1 a_268967_100118# a_269079_100182# user_project_wrapper_0.IOVSS1 sg13_lv_nmos ad=0.1426p pd=1.16u as=0.1428p ps=1.52u w=0.42u l=0.5u
X5850 VDD3 a_296625_189595# a_296731_189665# VDD3 sg13_lv_pmos ad=0.2603p pd=1.75u as=0.2603p ps=1.75u w=1.37u l=0.35u
X5851 user_project_wrapper_0.IOVSS1 user_project_wrapper_0.sg13g2_IOPadVdd_3.sg13g2_RCClampInverter_noptap_0.out user_project_wrapper_0.IOVSS1 user_project_wrapper_0.IOVSS1 sg13_hv_nmos ad=2.596p pd=5.58u as=0 ps=0 w=4.4u l=0.6u
X5852 user_project_wrapper_0.IOVSS1 a_209480_325263# a_210109_325785# w_207887_326203# sg13_lv_pmos ad=0.68p pd=4.68u as=0.38p ps=2.38u w=2u l=0.13u
X5853 user_project_wrapper_0.IOVSS1 a_194687_324142# user_project_wrapper_0.analog_io[30] user_project_wrapper_0.IOVSS1 sg13_lv_nmos ad=0.912p pd=5.18u as=0.912p ps=5.18u w=4.8u l=0.13u
X5854 a_83050_125173# a_82872_125209# user_project_wrapper_0.IOVSS1 user_project_wrapper_0.IOVSS1 sg13_lv_nmos ad=0.1406p pd=1.12u as=0.2516p ps=2.16u w=0.74u l=0.13u
X5855 user_project_wrapper_0.IOVSS1 user_project_wrapper_0.sg13g2_IOPadVdd_0.sg13g2_RCClampInverter_noptap_0.out VDD3 user_project_wrapper_0.IOVSS1 sg13_hv_nmos ad=1.408p pd=5.04u as=2.596p ps=5.58u w=4.4u l=0.6u
X5856 user_project_wrapper_0.IOVDD2 a_176644_41476# user_project_wrapper_0.analog_io[12] user_project_wrapper_0.IOVDD2 sg13_hv_pmos ad=2.1312p pd=7.3u as=3.9294p ps=7.84u w=6.66u l=0.6u
X5857 a_190287_102497# a_190218_102763# QDLL_TOP_0.VDD QDLL_TOP_0.VDD sg13_lv_pmos ad=0.1225p pd=1.245u as=0.36p ps=2.72u w=1u l=0.13u
X5858 user_project_wrapper_0.analog_io[33] a_237844_355624# user_project_wrapper_0.IOVDD4 user_project_wrapper_0.IOVDD4 sg13_hv_pmos ad=3.9294p pd=7.84u as=2.1312p ps=7.3u w=6.66u l=0.6u
X5859 user_project_wrapper_0.IOVSS1 a_194687_324142# user_project_wrapper_0.analog_io[30] user_project_wrapper_0.IOVSS1 sg13_lv_nmos ad=0.912p pd=5.18u as=0.912p ps=5.18u w=4.8u l=0.13u
X5860 user_project_wrapper_0.IOVSS1 user_project_wrapper_0.sg13g2_IOPadIOVdd_1.sg13g2_Clamp_N43N43D4R_0.gate user_project_wrapper_0.IOVDD1 user_project_wrapper_0.IOVSS1 sg13_hv_nmos ad=1.408p pd=5.04u as=2.596p ps=5.58u w=4.4u l=0.6u
X5861 VDD3 a_296625_208423# a_296731_208493# VDD3 sg13_lv_pmos ad=0.2603p pd=1.75u as=0.2603p ps=1.75u w=1.37u l=0.35u
X5862 user_project_wrapper_0.sg13g2_IOPadAnalog_3.padres analog_io[20] user_project_wrapper_0.IOVSS1 rppd l=2u w=1u
X5863 VDD3 a_296625_208423# a_296731_208493# VDD3 sg13_lv_pmos ad=0.2603p pd=1.75u as=0.2603p ps=1.75u w=1.37u l=0.35u
X5864 user_project_wrapper_0.sg13g2_IOPadIOVdd_2.sg13g2_Clamp_N43N43D4R_0.gate user_project_wrapper_0.sg13g2_IOPadIOVdd_2.sg13g2_RCClampResistor_0.p2 user_project_wrapper_0.IOVSS1 user_project_wrapper_0.IOVSS1 sg13_hv_nmos ad=1.71p pd=9.38u as=1.71p ps=9.38u w=9u l=0.5u
X5865 user_project_wrapper_0.analog_io[30] a_194687_324142# user_project_wrapper_0.IOVSS1 user_project_wrapper_0.IOVSS1 sg13_lv_pmos ad=1.824p pd=9.98u as=1.824p ps=9.98u w=9.6u l=0.13u
X5866 VDD3 a_311108_179669# analog_io[20] user_project_wrapper_0.IOVSS1 sg13_lv_nmos ad=3.4p pd=20.68u as=3.4p ps=20.68u w=10u l=0.15u
X5867 user_project_wrapper_0.IOVSS1 a_369296_156244# analog_io[20] user_project_wrapper_0.IOVSS1 sg13_hv_nmos ad=1.408p pd=5.04u as=2.596p ps=5.58u w=4.4u l=0.6u
X5868 analog_io[23] a_369296_217444# user_project_wrapper_0.IOVSS1 user_project_wrapper_0.IOVSS1 sg13_hv_nmos ad=2.596p pd=5.58u as=1.408p ps=5.04u w=4.4u l=0.6u
X5869 user_project_wrapper_0.IOVSS1 user_project_wrapper_0.sg13g2_IOPadVdd_2.sg13g2_RCClampResistor_0.p2 user_project_wrapper_0.IOVSS1 user_project_wrapper_0.IOVSS1 sg13_hv_nmos ad=3.06p pd=18.68u as=0 ps=0 w=9u l=9.5u
X5870 user_project_wrapper_0.sg13g2_IOPadVdd_0.sg13g2_RCClampInverter_noptap_0.out user_project_wrapper_0.sg13g2_IOPadVdd_0.sg13g2_RCClampResistor_0.p2 VDD3 VDD3 sg13_hv_pmos ad=1.33p pd=7.38u as=1.33p ps=7.38u w=7u l=0.5u
X5871 IOVDD3 user_project_wrapper_0.sg13g2_IOPadIOVdd_3.sg13g2_Clamp_N43N43D4R_0.gate user_project_wrapper_0.IOVSS1 user_project_wrapper_0.IOVSS1 sg13_hv_nmos ad=2.596p pd=5.58u as=2.068p ps=9.74u w=4.4u l=0.6u
X5872 user_project_wrapper_0.IOVSS1 user_project_wrapper_0.sg13g2_IOPadIOVdd_1.sg13g2_Clamp_N43N43D4R_0.gate user_project_wrapper_0.IOVDD1 user_project_wrapper_0.IOVSS1 sg13_hv_nmos ad=1.408p pd=5.04u as=2.596p ps=5.58u w=4.4u l=0.6u
X5873 a_205385_326221# a_206201_328627# user_project_wrapper_0.IOVSS1 user_project_wrapper_0.IOVSS1 sg13_lv_pmos ad=1.824p pd=9.98u as=1.824p ps=9.98u w=9.6u l=0.13u
X5874 VDD3 a_296625_208423# a_296731_208493# VDD3 sg13_lv_pmos ad=0.2603p pd=1.75u as=0.2603p ps=1.75u w=1.37u l=0.35u
X5875 user_project_wrapper_0.IOVSS1 a_135844_369296# user_project_wrapper_0.analog_io[28] user_project_wrapper_0.IOVSS1 sg13_hv_nmos ad=1.408p pd=5.04u as=2.596p ps=5.58u w=4.4u l=0.6u
X5876 user_project_wrapper_0.analog_io[27] a_115444_355624# user_project_wrapper_0.IOVDD4 user_project_wrapper_0.IOVDD4 sg13_hv_pmos ad=3.9294p pd=7.84u as=2.1312p ps=7.3u w=6.66u l=0.6u
X5877 user_project_wrapper_0.IOVSS1 user_project_wrapper_0.sg13g2_IOPadVdd_0.sg13g2_RCClampInverter_noptap_0.out VDD3 user_project_wrapper_0.IOVSS1 sg13_hv_nmos ad=1.408p pd=5.04u as=2.596p ps=5.58u w=4.4u l=0.6u
X5878 user_project_wrapper_0.IOVSS1 a_213870_324142# user_project_wrapper_0.analog_io[35] user_project_wrapper_0.IOVSS1 sg13_lv_nmos ad=0.912p pd=5.18u as=0.912p ps=5.18u w=4.8u l=0.13u
X5879 VDD3 a_309516_194555# a_309917_194695# VDD3 sg13_lv_pmos ad=0.19p pd=1.38u as=0.19p ps=1.38u w=1u l=0.7u
X5880 user_project_wrapper_0.IOVSS1 user_project_wrapper_0.sg13g2_IOPadVdd_3.sg13g2_RCClampInverter_noptap_0.out user_project_wrapper_0.IOVSS1 user_project_wrapper_0.IOVSS1 sg13_hv_nmos ad=1.408p pd=5.04u as=0 ps=0 w=4.4u l=0.6u
X5881 a_210621_326377# a_210417_326377# user_project_wrapper_0.IOVSS1 w_207887_326203# sg13_lv_pmos ad=0.38p pd=2.38u as=0.68p ps=4.68u w=2u l=0.13u
X5882 user_project_wrapper_0.IOVSS1 a_213870_324142# user_project_wrapper_0.analog_io[35] user_project_wrapper_0.IOVSS1 sg13_lv_nmos ad=0.912p pd=5.18u as=0.912p ps=5.18u w=4.8u l=0.13u
X5883 user_project_wrapper_0.analog_io[11] a_156244_41476# user_project_wrapper_0.IOVDD2 user_project_wrapper_0.IOVDD2 sg13_hv_pmos ad=3.9294p pd=7.84u as=2.1312p ps=7.3u w=6.66u l=0.6u
X5884 analog_io[25] IOVDD3 dpantenna l=27.78u w=1.26u
X5885 user_project_wrapper_0.IOVDD4 a_258244_355624# user_project_wrapper_0.analog_io[34] user_project_wrapper_0.IOVDD4 sg13_hv_pmos ad=2.1312p pd=7.3u as=3.9294p ps=7.84u w=6.66u l=0.6u
X5886 a_304995_198817# a_307232_196607# user_project_wrapper_0.IOVSS1 user_project_wrapper_0.IOVSS1 sg13_lv_nmos ad=0.6327p pd=3.71u as=0.6327p ps=3.71u w=3.33u l=0.2u
X5887 IOVDD3 user_project_wrapper_0.sg13g2_IOPadIOVdd_3.sg13g2_RCClampResistor_0.p2 user_project_wrapper_0.sg13g2_IOPadIOVdd_3.sg13g2_Clamp_N43N43D4R_0.gate IOVDD3 sg13_hv_pmos ad=1.33p pd=7.38u as=1.33p ps=7.38u w=7u l=0.5u
X5888 user_project_wrapper_0.IOVSS1 a_210307_324119# a_209940_324686# w_207989_323975# sg13_lv_pmos ad=0.68p pd=4.68u as=0.68p ps=4.68u w=2u l=0.65u
X5889 user_project_wrapper_0.VDD1 user_project_wrapper_0.sg13g2_IOPadVdd_2.sg13g2_RCClampInverter_noptap_0.out user_project_wrapper_0.IOVSS1 user_project_wrapper_0.IOVSS1 sg13_hv_nmos ad=2.596p pd=5.58u as=1.408p ps=5.04u w=4.4u l=0.6u
X5890 user_project_wrapper_0.analog_io[10] a_135844_29676# user_project_wrapper_0.IOVSS1 user_project_wrapper_0.IOVSS1 sg13_hv_nmos ad=2.596p pd=5.58u as=1.408p ps=5.04u w=4.4u l=0.6u
X5891 user_project_wrapper_0.IOVDD2 a_258244_41476# user_project_wrapper_0.analog_io[16] user_project_wrapper_0.IOVDD2 sg13_hv_pmos ad=2.1312p pd=7.3u as=3.9294p ps=7.84u w=6.66u l=0.6u
X5892 user_project_wrapper_0.VDD2 user_project_wrapper_0.sg13g2_IOPadVdd_1.sg13g2_RCClampInverter_noptap_0.out user_project_wrapper_0.IOVSS1 user_project_wrapper_0.IOVSS1 sg13_hv_nmos ad=2.596p pd=5.58u as=1.408p ps=5.04u w=4.4u l=0.6u
X5893 user_project_wrapper_0.analog_io[10] a_135844_41476# user_project_wrapper_0.IOVDD2 user_project_wrapper_0.IOVDD2 sg13_hv_pmos ad=3.9294p pd=7.84u as=2.1312p ps=7.3u w=6.66u l=0.6u
X5894 user_project_wrapper_0.VDD2 user_project_wrapper_0.sg13g2_IOPadVdd_1.sg13g2_RCClampResistor_0.p2 user_project_wrapper_0.sg13g2_IOPadVdd_1.sg13g2_RCClampInverter_noptap_0.out user_project_wrapper_0.VDD2 sg13_hv_pmos ad=1.33p pd=7.38u as=1.33p ps=7.38u w=7u l=0.5u
X5895 user_project_wrapper_0.IOVSS1 user_project_wrapper_0.sg13g2_IOPadVdd_3.sg13g2_RCClampResistor_0.p2 user_project_wrapper_0.sg13g2_IOPadVdd_3.sg13g2_RCClampInverter_noptap_0.out user_project_wrapper_0.IOVSS1 sg13_hv_pmos ad=1.33p pd=7.38u as=1.33p ps=7.38u w=7u l=0.5u
X5896 user_project_wrapper_0.analog_io[27] a_182931_326125# user_project_wrapper_0.IOVSS1 user_project_wrapper_0.IOVSS1 sg13_lv_pmos ad=1.824p pd=9.98u as=1.824p ps=9.98u w=9.6u l=0.13u
X5897 a_190319_97955# user_project_wrapper_0.analog_io[14] a_190287_98223# QDLL_TOP_0.VDD sg13_lv_pmos ad=0.34p pd=2.68u as=0.1225p ps=1.245u w=1u l=0.13u
X5898 user_project_wrapper_0.IOVSS1 user_project_wrapper_0.sg13g2_IOPadVdd_1.sg13g2_RCClampResistor_0.p2 user_project_wrapper_0.IOVSS1 user_project_wrapper_0.IOVSS1 sg13_hv_nmos ad=1.71p pd=9.38u as=0 ps=0 w=9u l=9.5u
X5899 user_project_wrapper_0.analog_io[29] a_156244_355624# user_project_wrapper_0.IOVDD4 user_project_wrapper_0.IOVDD4 sg13_hv_pmos ad=3.9294p pd=7.84u as=2.1312p ps=7.3u w=6.66u l=0.6u
X5900 a_190297_328605# a_189756_328605# user_project_wrapper_0.IOVSS1 w_188704_327938# sg13_lv_pmos ad=0.68p pd=4.68u as=0.68p ps=4.68u w=2u l=0.13u
X5901 a_360372_73705# a_364458_74035# user_project_wrapper_0.IOVSS1 rppd l=20u w=1u
X5902 user_project_wrapper_0.analog_io[15] a_190389_101343# QDLL_TOP_0.VDD QDLL_TOP_0.VDD sg13_lv_pmos ad=0.2128p pd=1.5u as=0.2128p ps=1.5u w=1.12u l=0.13u
X5903 user_project_wrapper_0.IOVSS1 user_project_wrapper_0.IOVSS1 user_project_wrapper_0.IOVSS1 rppd l=0.5u w=0.5u
X5904 user_project_wrapper_0.IOVDD4 user_project_wrapper_0.sg13g2_IOPadIOVdd_2.sg13g2_RCClampResistor_0.p2 user_project_wrapper_0.sg13g2_IOPadIOVdd_2.sg13g2_Clamp_N43N43D4R_0.gate user_project_wrapper_0.IOVDD4 sg13_hv_pmos ad=2.38p pd=14.68u as=1.33p ps=7.38u w=7u l=0.5u
X5905 user_project_wrapper_0.IOVDD2 a_176644_41476# user_project_wrapper_0.analog_io[12] user_project_wrapper_0.IOVDD2 sg13_hv_pmos ad=2.1312p pd=7.3u as=3.9294p ps=7.84u w=6.66u l=0.6u
X5906 a_35456_297775# a_39542_298105# user_project_wrapper_0.IOVSS1 rppd l=20u w=1u
X5907 IOVDD3 user_project_wrapper_0.sg13g2_IOPadIOVdd_3.sg13g2_Clamp_N43N43D4R_0.gate user_project_wrapper_0.IOVSS1 user_project_wrapper_0.IOVSS1 sg13_hv_nmos ad=3.256p pd=10.28u as=1.408p ps=5.04u w=4.4u l=0.6u
X5908 IOVDD3 user_project_wrapper_0.sg13g2_IOPadIOVdd_3.sg13g2_Clamp_N43N43D4R_0.gate user_project_wrapper_0.IOVSS1 user_project_wrapper_0.IOVSS1 sg13_hv_nmos ad=3.256p pd=10.28u as=1.408p ps=5.04u w=4.4u l=0.6u
X5909 a_296731_189665# a_301186_192011# user_project_wrapper_0.IOVSS1 user_project_wrapper_0.IOVSS1 sg13_lv_nmos ad=0.912p pd=5.18u as=0.912p ps=5.18u w=4.8u l=1.06u
X5910 QDLL_TOP_0.VOUT a_271172_100118# user_project_wrapper_0.IOVSS1 user_project_wrapper_0.IOVSS1 sg13_lv_nmos ad=0.1406p pd=1.12u as=0.1406p ps=1.12u w=0.74u l=0.13u
X5911 a_304995_198817# a_307232_196607# user_project_wrapper_0.IOVSS1 user_project_wrapper_0.IOVSS1 sg13_lv_nmos ad=0.6327p pd=3.71u as=0.6327p ps=3.71u w=3.33u l=0.2u
X5912 user_project_wrapper_0.IOVSS1 a_301186_192011# a_296731_189665# user_project_wrapper_0.IOVSS1 sg13_lv_nmos ad=0.912p pd=5.18u as=0.912p ps=5.18u w=4.8u l=1.06u
X5913 user_project_wrapper_0.IOVSS1 a_208017_326341# a_209041_328605# w_207887_327938# sg13_lv_pmos ad=0.68p pd=4.68u as=0.38p ps=2.38u w=2u l=0.13u
X5914 a_296731_189665# a_296625_189595# VDD3 VDD3 sg13_lv_pmos ad=0.2603p pd=1.75u as=0.2603p ps=1.75u w=1.37u l=0.35u
X5915 a_311846_195517# user_project_wrapper_0.sg13g2_IOPadAnalog_29.padres a_309917_199879# VDD3 sg13_lv_pmos ad=0.24415p pd=1.665u as=0.24415p ps=1.665u w=1.285u l=0.35u
X5916 user_project_wrapper_0.IOVDD1 user_project_wrapper_0.sg13g2_IOPadIOVdd_1.sg13g2_Clamp_N43N43D4R_0.gate user_project_wrapper_0.IOVSS1 user_project_wrapper_0.IOVSS1 sg13_hv_nmos ad=2.596p pd=5.58u as=1.408p ps=5.04u w=4.4u l=0.6u
X5917 a_82348_128838# a_79025_131741# user_project_wrapper_0.VDD1 user_project_wrapper_0.VDD1 sg13_lv_pmos ad=0.3808p pd=2.92u as=0.3808p ps=2.92u w=1.12u l=0.13u
X5918 a_309516_194555# a_309516_194555# VDD3 VDD3 sg13_lv_pmos ad=0.19p pd=1.38u as=0.19p ps=1.38u w=1u l=0.7u
X5919 a_304196_197873# a_304889_198885# a_304995_198817# user_project_wrapper_0.IOVSS1 sg13_lv_nmos ad=0.209p pd=1.48u as=0.209p ps=1.48u w=1.1u l=0.15u
X5920 user_project_wrapper_0.IOVSS1 user_project_wrapper_0.sg13g2_IOPadVdd_3.sg13g2_RCClampInverter_noptap_0.out user_project_wrapper_0.IOVSS1 user_project_wrapper_0.IOVSS1 sg13_hv_nmos ad=2.596p pd=5.58u as=0 ps=0 w=4.4u l=0.6u
X5921 user_project_wrapper_0.IOVDD4 a_237844_355624# user_project_wrapper_0.analog_io[33] user_project_wrapper_0.IOVDD4 sg13_hv_pmos ad=2.1312p pd=7.3u as=3.9294p ps=7.84u w=6.66u l=0.6u
X5922 analog_io[19] a_369296_135844# user_project_wrapper_0.IOVSS1 user_project_wrapper_0.IOVSS1 sg13_hv_nmos ad=2.596p pd=5.58u as=1.408p ps=5.04u w=4.4u l=0.6u
X5923 user_project_wrapper_0.analog_io[1] a_41476_135844# user_project_wrapper_0.IOVDD1 user_project_wrapper_0.IOVDD1 sg13_hv_pmos ad=3.9294p pd=7.84u as=2.1312p ps=7.3u w=6.66u l=0.6u
X5924 user_project_wrapper_0.IOVSS1 a_135844_369296# user_project_wrapper_0.analog_io[28] user_project_wrapper_0.IOVSS1 sg13_hv_nmos ad=1.408p pd=5.04u as=2.596p ps=5.58u w=4.4u l=0.6u
X5925 IOVDD3 user_project_wrapper_0.sg13g2_IOPadIOVdd_3.sg13g2_RCClampResistor_0.p2 user_project_wrapper_0.sg13g2_IOPadIOVdd_3.sg13g2_Clamp_N43N43D4R_0.gate IOVDD3 sg13_hv_pmos ad=1.33p pd=7.38u as=1.33p ps=7.38u w=7u l=0.5u
X5926 user_project_wrapper_0.IOVSS1 a_29676_115444# user_project_wrapper_0.analog_io[0] user_project_wrapper_0.IOVSS1 sg13_hv_nmos ad=1.408p pd=5.04u as=2.596p ps=5.58u w=4.4u l=0.6u
X5927 a_311846_195517# user_project_wrapper_0.sg13g2_IOPadAnalog_29.padres a_309917_194695# VDD3 sg13_lv_pmos ad=0.24415p pd=1.665u as=0.24415p ps=1.665u w=1.285u l=0.35u
X5928 a_360372_300085# a_364458_300415# user_project_wrapper_0.IOVSS1 rppd l=20u w=1u
X5929 a_78655_364458# a_78985_360372# user_project_wrapper_0.IOVSS1 rppd l=20u w=1u
X5930 user_project_wrapper_0.analog_io[32] a_202114_326125# user_project_wrapper_0.IOVSS1 user_project_wrapper_0.IOVSS1 sg13_lv_pmos ad=1.824p pd=9.98u as=1.824p ps=9.98u w=9.6u l=0.13u
X5931 a_188834_327918# user_project_wrapper_0.sg13g2_IOPadAnalog_17.padres user_project_wrapper_0.IOVSS1 user_project_wrapper_0.IOVSS1 sg13_lv_nmos ad=0.34p pd=2.68u as=0.34p ps=2.68u w=1u l=0.13u
X5932 user_project_wrapper_0.IOVDD1 a_41476_258244# user_project_wrapper_0.analog_io[7] user_project_wrapper_0.IOVDD1 sg13_hv_pmos ad=2.1312p pd=7.3u as=3.9294p ps=7.84u w=6.66u l=0.6u
X5933 user_project_wrapper_0.IOVSS1 user_project_wrapper_0.analog_io[13] a_185968_102197# user_project_wrapper_0.IOVSS1 sg13_lv_nmos ad=0.68p pd=4.68u as=0.68p ps=4.68u w=2u l=0.25u
X5934 user_project_wrapper_0.IOVSS1 analog_io[18] dantenna l=27.78u w=1.26u
X5935 user_project_wrapper_0.IOVSS1 a_156244_29676# user_project_wrapper_0.analog_io[11] user_project_wrapper_0.IOVSS1 sg13_hv_nmos ad=1.408p pd=5.04u as=2.596p ps=5.58u w=4.4u l=0.6u
X5936 user_project_wrapper_0.IOVSS1 a_200038_338690# user_project_wrapper_0.sg13g2_IOPadIn$1_2.p2c user_project_wrapper_0.IOVSS1 sg13_lv_nmos ad=0.935p pd=6.18u as=0.935p ps=6.18u w=2.75u l=0.13u
X5937 user_project_wrapper_0.sg13g2_IOPadVdd_1.sg13g2_RCClampInverter_noptap_0.out user_project_wrapper_0.sg13g2_IOPadVdd_1.sg13g2_RCClampResistor_0.p2 user_project_wrapper_0.VDD2 user_project_wrapper_0.VDD2 sg13_hv_pmos ad=1.33p pd=7.38u as=1.33p ps=7.38u w=7u l=0.5u
X5938 user_project_wrapper_0.IOVSS1 a_202114_326125# user_project_wrapper_0.analog_io[32] user_project_wrapper_0.IOVSS1 sg13_lv_nmos ad=0.912p pd=5.18u as=0.912p ps=5.18u w=4.8u l=0.13u
X5939 a_296731_189665# a_296625_189595# VDD3 VDD3 sg13_lv_pmos ad=0.2603p pd=1.75u as=0.2603p ps=1.75u w=1.37u l=0.35u
X5940 VDD3 a_296625_189595# a_296731_189665# VDD3 sg13_lv_pmos ad=0.4658p pd=3.42u as=0.2603p ps=1.75u w=1.37u l=0.35u
X5941 user_project_wrapper_0.sg13g2_IOPadOut4mA$1_1.c2p a_86970_241383# user_project_wrapper_0.IOVSS1 user_project_wrapper_0.IOVSS1 sg13_lv_nmos ad=0.2516p pd=2.16u as=0.2516p ps=2.16u w=0.74u l=0.13u
X5942 a_191234_327491# a_190824_327491# user_project_wrapper_0.IOVSS1 w_188704_327938# sg13_lv_pmos ad=0.68p pd=4.68u as=0.68p ps=4.68u w=2u l=0.13u
X5943 QDLL_TOP_0.VOUT a_278644_29676# user_project_wrapper_0.IOVSS1 user_project_wrapper_0.IOVSS1 sg13_hv_nmos ad=2.596p pd=5.58u as=1.408p ps=5.04u w=4.4u l=0.6u
X5944 a_190824_328605# a_190501_328605# a_190722_328605# w_188704_327938# sg13_lv_pmos ad=0.38p pd=2.38u as=0.38p ps=2.38u w=2u l=0.13u
X5945 IOVDD3 user_project_wrapper_0.sg13g2_IOPadIOVdd_3.sg13g2_Clamp_N43N43D4R_0.gate user_project_wrapper_0.IOVSS1 user_project_wrapper_0.IOVSS1 sg13_hv_nmos ad=2.596p pd=5.58u as=1.408p ps=5.04u w=4.4u l=0.6u
X5946 user_project_wrapper_0.IOVDD2 a_258244_41476# user_project_wrapper_0.analog_io[16] user_project_wrapper_0.IOVDD2 sg13_hv_pmos ad=2.1312p pd=7.3u as=3.9294p ps=7.84u w=6.66u l=0.6u
X5947 user_project_wrapper_0.IOVSS1 user_project_wrapper_0.sg13g2_IOPadVdd_2.sg13g2_RCClampInverter_noptap_0.out user_project_wrapper_0.VDD1 user_project_wrapper_0.IOVSS1 sg13_hv_nmos ad=1.408p pd=5.04u as=2.596p ps=5.58u w=4.4u l=0.6u
X5948 VDD3 a_311189_185546# a_311108_179669# VDD3 sg13_lv_pmos ad=1.9p pd=10.38u as=1.9p ps=10.38u w=10u l=1u
X5949 user_project_wrapper_0.VDD2 user_project_wrapper_0.sg13g2_IOPadVdd_1.sg13g2_RCClampInverter_noptap_0.out user_project_wrapper_0.IOVSS1 user_project_wrapper_0.IOVSS1 sg13_hv_nmos ad=2.596p pd=5.58u as=1.408p ps=5.04u w=4.4u l=0.6u
X5950 a_296731_189665# a_296625_189595# VDD3 VDD3 sg13_lv_pmos ad=0.2603p pd=1.75u as=0.2603p ps=1.75u w=1.37u l=0.35u
X5951 a_304196_200821# a_304090_197941# a_296625_208423# user_project_wrapper_0.IOVSS1 sg13_lv_nmos ad=0.361p pd=2.28u as=0.361p ps=2.28u w=1.9u l=0.16u
X5952 a_296731_208493# a_296625_208423# VDD3 VDD3 sg13_lv_pmos ad=0.2603p pd=1.75u as=0.2603p ps=1.75u w=1.37u l=0.35u
X5953 user_project_wrapper_0.IOVSS1 user_project_wrapper_0.sg13g2_IOPadOut4mA$1_0.sg13g2_GateLevelUpInv_noptap$1$1_0.ngate dantenna l=0.78u w=0.78u
X5954 user_project_wrapper_0.sg13g2_IOPadVdd_1.sg13g2_RCClampInverter_noptap_0.out user_project_wrapper_0.sg13g2_IOPadVdd_1.sg13g2_RCClampResistor_0.p2 user_project_wrapper_0.VDD2 user_project_wrapper_0.VDD2 sg13_hv_pmos ad=1.33p pd=7.38u as=1.33p ps=7.38u w=7u l=0.5u
X5955 user_project_wrapper_0.IOVSS1 user_project_wrapper_0.analog_io[15] dantenna l=1.26u w=27.78u
X5956 user_project_wrapper_0.analog_io[32] a_202114_326125# user_project_wrapper_0.IOVSS1 user_project_wrapper_0.IOVSS1 sg13_lv_pmos ad=1.824p pd=9.98u as=1.824p ps=9.98u w=9.6u l=0.13u
X5957 user_project_wrapper_0.IOVSS1 user_project_wrapper_0.sg13g2_IOPadVdd_2.sg13g2_RCClampInverter_noptap_0.out user_project_wrapper_0.VDD1 user_project_wrapper_0.IOVSS1 sg13_hv_nmos ad=1.408p pd=5.04u as=2.596p ps=5.58u w=4.4u l=0.6u
X5958 a_309917_194695# a_309516_194555# VDD3 VDD3 sg13_lv_pmos ad=0.19p pd=1.38u as=0.19p ps=1.38u w=1u l=0.7u
X5959 user_project_wrapper_0.analog_io[6] a_41476_237844# user_project_wrapper_0.IOVDD1 user_project_wrapper_0.IOVDD1 sg13_hv_pmos ad=3.9294p pd=7.84u as=2.1312p ps=7.3u w=6.66u l=0.6u
X5960 user_project_wrapper_0.IOVDD4 user_project_wrapper_0.sg13g2_IOPadIOVdd_2.sg13g2_Clamp_N43N43D4R_0.gate user_project_wrapper_0.IOVSS1 user_project_wrapper_0.IOVSS1 sg13_hv_nmos ad=2.596p pd=5.58u as=1.408p ps=5.04u w=4.4u l=0.6u
X5961 user_project_wrapper_0.IOVSS1 a_197044_29676# user_project_wrapper_0.analog_io[13] user_project_wrapper_0.IOVSS1 sg13_hv_nmos ad=1.408p pd=5.04u as=2.596p ps=5.58u w=4.4u l=0.6u
X5962 user_project_wrapper_0.analog_io[7] a_41476_258244# user_project_wrapper_0.IOVDD1 user_project_wrapper_0.IOVDD1 sg13_hv_pmos ad=3.9294p pd=7.84u as=2.1312p ps=7.3u w=6.66u l=0.6u
X5963 IOVDD3 a_355624_176644# analog_io[20] IOVDD3 sg13_hv_pmos ad=2.1312p pd=7.3u as=3.9294p ps=7.84u w=6.66u l=0.6u
X5964 analog_io[23] a_355624_237844# IOVDD3 IOVDD3 sg13_hv_pmos ad=3.9294p pd=7.84u as=2.1312p ps=7.3u w=6.66u l=0.6u
X5965 IOVDD3 user_project_wrapper_0.sg13g2_IOPadIOVdd_3.sg13g2_Clamp_N43N43D4R_0.gate user_project_wrapper_0.IOVSS1 user_project_wrapper_0.IOVSS1 sg13_hv_nmos ad=2.596p pd=5.58u as=1.408p ps=5.04u w=4.4u l=0.6u
X5966 user_project_wrapper_0.IOVDD2 a_278644_41476# QDLL_TOP_0.VOUT user_project_wrapper_0.IOVDD2 sg13_hv_pmos ad=2.1312p pd=7.3u as=3.9294p ps=7.84u w=6.66u l=0.6u
X5967 a_191417_110495# a_190862_108410# user_project_wrapper_0.IOVSS1 rppd l=10u w=1u
X5968 user_project_wrapper_0.IOVDD4 user_project_wrapper_0.sg13g2_IOPadIOVdd_2.sg13g2_Clamp_N43N43D4R_0.gate user_project_wrapper_0.IOVSS1 user_project_wrapper_0.IOVSS1 sg13_hv_nmos ad=2.596p pd=5.58u as=1.408p ps=5.04u w=4.4u l=0.6u
X5969 user_project_wrapper_0.analog_io[32] a_202114_326125# user_project_wrapper_0.IOVSS1 user_project_wrapper_0.IOVSS1 sg13_lv_pmos ad=1.824p pd=9.98u as=1.824p ps=9.98u w=9.6u l=0.13u
X5970 user_project_wrapper_0.IOVDD4 a_237844_355624# user_project_wrapper_0.analog_io[33] user_project_wrapper_0.IOVDD4 sg13_hv_pmos ad=2.1312p pd=7.3u as=3.9294p ps=7.84u w=6.66u l=0.6u
X5971 user_project_wrapper_0.analog_io[11] a_156244_41476# user_project_wrapper_0.IOVDD2 user_project_wrapper_0.IOVDD2 sg13_hv_pmos ad=3.9294p pd=7.84u as=2.1312p ps=7.3u w=6.66u l=0.6u
X5972 a_304196_197873# a_304889_198885# a_304995_198817# user_project_wrapper_0.IOVSS1 sg13_lv_nmos ad=0.209p pd=1.48u as=0.374p ps=2.88u w=1.1u l=0.15u
X5973 user_project_wrapper_0.IOVDD2 user_project_wrapper_0.sg13g2_IOPadIOVdd_0.sg13g2_Clamp_N43N43D4R_0.gate user_project_wrapper_0.IOVSS1 user_project_wrapper_0.IOVSS1 sg13_hv_nmos ad=2.596p pd=5.58u as=1.408p ps=5.04u w=4.4u l=0.6u
X5974 user_project_wrapper_0.IOVDD1 a_41476_217444# user_project_wrapper_0.analog_io[5] user_project_wrapper_0.IOVDD1 sg13_hv_pmos ad=2.1312p pd=7.3u as=3.9294p ps=7.84u w=6.66u l=0.6u
X5975 user_project_wrapper_0.IOVSS1 a_194687_324142# user_project_wrapper_0.analog_io[30] user_project_wrapper_0.IOVSS1 sg13_lv_nmos ad=0.912p pd=5.18u as=0.912p ps=5.18u w=4.8u l=0.13u
X5976 user_project_wrapper_0.analog_io[27] a_115444_369296# user_project_wrapper_0.IOVSS1 user_project_wrapper_0.IOVSS1 sg13_hv_nmos ad=2.596p pd=5.58u as=1.408p ps=5.04u w=4.4u l=0.6u
X5977 a_296625_208423# a_301940_196388# a_296732_200582# VDD3 sg13_lv_pmos ad=0.7695p pd=4.43u as=1.377p ps=8.78u w=4.05u l=0.5u
X5978 a_89114_127531# a_88274_127896# user_project_wrapper_0.IOVSS1 user_project_wrapper_0.IOVSS1 sg13_lv_nmos ad=0.1406p pd=1.12u as=0.2516p ps=2.16u w=0.74u l=0.13u
X5979 IOVDD3 a_355624_278644# analog_io[26] IOVDD3 sg13_hv_pmos ad=2.1312p pd=7.3u as=3.9294p ps=7.84u w=6.66u l=0.6u
X5980 a_57810_179517# a_58798_179249# user_project_wrapper_0.IOVSS1 user_project_wrapper_0.IOVSS1 sg13_hv_nmos ad=0.646p pd=4.48u as=0.361p ps=2.28u w=1.9u l=0.45u
X5981 user_project_wrapper_0.IOVDD4 user_project_wrapper_0.sg13g2_IOPadIOVdd_2.sg13g2_Clamp_N43N43D4R_0.gate user_project_wrapper_0.IOVSS1 user_project_wrapper_0.IOVSS1 sg13_hv_nmos ad=2.596p pd=5.58u as=1.408p ps=5.04u w=4.4u l=0.6u
X5982 user_project_wrapper_0.IOVSS1 user_project_wrapper_0.sg13g2_IOPadVdd_2.sg13g2_RCClampResistor_0.p2 user_project_wrapper_0.IOVSS1 user_project_wrapper_0.IOVSS1 sg13_hv_nmos ad=1.71p pd=9.38u as=0 ps=0 w=9u l=9.5u
X5983 a_311189_185546# a_296731_189665# a_313884_185173# user_project_wrapper_0.IOVSS1 sg13_lv_nmos ad=1.9p pd=10.38u as=1.9p ps=10.38u w=10u l=0.5u
X5984 user_project_wrapper_0.IOVSS1 a_205385_326221# a_202114_326125# user_project_wrapper_0.IOVSS1 sg13_lv_nmos ad=0.912p pd=5.18u as=0.912p ps=5.18u w=4.8u l=0.13u
X5985 user_project_wrapper_0.IOVSS1 user_project_wrapper_0.sg13g2_IOPadVdd_2.sg13g2_RCClampInverter_noptap_0.out user_project_wrapper_0.VDD1 user_project_wrapper_0.IOVSS1 sg13_hv_nmos ad=1.408p pd=5.04u as=2.596p ps=5.58u w=4.4u l=0.6u
X5986 user_project_wrapper_0.IOVSS1 user_project_wrapper_0.sg13g2_IOPadIOVdd_0.sg13g2_RCClampResistor_0.p2 user_project_wrapper_0.IOVSS1 user_project_wrapper_0.IOVSS1 sg13_hv_nmos ad=1.71p pd=9.38u as=0 ps=0 w=9u l=9.5u
X5987 user_project_wrapper_0.IOVSS1 a_188184_101343# a_188296_101407# user_project_wrapper_0.IOVSS1 sg13_lv_nmos ad=0.1426p pd=1.16u as=0.1428p ps=1.52u w=0.42u l=0.5u
X5988 VDD3 a_296625_208423# a_296731_208493# VDD3 sg13_lv_pmos ad=0.4658p pd=3.42u as=0.2603p ps=1.75u w=1.37u l=0.35u
X5989 user_project_wrapper_0.IOVDD2 user_project_wrapper_0.sg13g2_IOPadIOVdd_0.sg13g2_Clamp_N43N43D4R_0.gate user_project_wrapper_0.IOVSS1 user_project_wrapper_0.IOVSS1 sg13_hv_nmos ad=2.596p pd=5.58u as=2.068p ps=9.74u w=4.4u l=0.6u
X5990 a_309917_199879# a_309516_194555# VDD3 VDD3 sg13_lv_pmos ad=0.19p pd=1.38u as=0.19p ps=1.38u w=1u l=0.7u
X5991 user_project_wrapper_0.IOVSS1 a_156244_29676# user_project_wrapper_0.analog_io[11] user_project_wrapper_0.IOVSS1 sg13_hv_nmos ad=1.408p pd=5.04u as=2.596p ps=5.58u w=4.4u l=0.6u
X5992 VDD3 a_311189_211724# a_311189_211724# VDD3 sg13_lv_pmos ad=1.9p pd=10.38u as=1.9p ps=10.38u w=10u l=1u
X5993 user_project_wrapper_0.IOVDD2 user_project_wrapper_0.sg13g2_IOPadIOVdd_0.sg13g2_Clamp_N43N43D4R_0.gate user_project_wrapper_0.IOVSS1 user_project_wrapper_0.IOVSS1 sg13_hv_nmos ad=2.596p pd=5.58u as=1.408p ps=5.04u w=4.4u l=0.6u
X5994 user_project_wrapper_0.IOVSS1 a_301186_192011# a_296731_208493# user_project_wrapper_0.IOVSS1 sg13_lv_nmos ad=0.912p pd=5.18u as=0.912p ps=5.18u w=4.8u l=1.06u
X5995 user_project_wrapper_0.IOVSS1 a_190047_324119# a_187364_324106# w_188806_323975# sg13_lv_pmos ad=0.38p pd=2.38u as=0.68p ps=4.68u w=2u l=0.13u
X5996 user_project_wrapper_0.IOVDD4 a_115444_355624# user_project_wrapper_0.analog_io[27] user_project_wrapper_0.IOVDD4 sg13_hv_pmos ad=2.1312p pd=7.3u as=3.9294p ps=7.84u w=6.66u l=0.6u
X5997 user_project_wrapper_0.IOVDD1 a_41476_197044# user_project_wrapper_0.analog_io[4] user_project_wrapper_0.IOVDD1 sg13_hv_pmos ad=3.1302p pd=14.26u as=3.9294p ps=7.84u w=6.66u l=0.6u
X5998 user_project_wrapper_0.IOVSS1 user_project_wrapper_0.sg13g2_IOPadVdd_3.sg13g2_RCClampInverter_noptap_0.out user_project_wrapper_0.IOVSS1 user_project_wrapper_0.IOVSS1 sg13_hv_nmos ad=2.596p pd=5.58u as=0 ps=0 w=4.4u l=0.6u
X5999 a_304375_364458# a_304705_360372# user_project_wrapper_0.IOVSS1 rppd l=20u w=1u
X6000 analog_io[20] a_355624_176644# IOVDD3 IOVDD3 sg13_hv_pmos ad=3.9294p pd=7.84u as=2.1312p ps=7.3u w=6.66u l=0.6u
X6001 VDD3 a_296625_208423# a_296731_208493# VDD3 sg13_lv_pmos ad=0.2603p pd=1.75u as=0.2603p ps=1.75u w=1.37u l=0.35u
X6002 user_project_wrapper_0.analog_io[27] a_182931_326125# user_project_wrapper_0.IOVSS1 user_project_wrapper_0.IOVSS1 sg13_lv_nmos ad=0.912p pd=5.18u as=0.912p ps=5.18u w=4.8u l=0.13u
X6003 user_project_wrapper_0.IOVSS1 a_188572_101637# a_188760_101343# user_project_wrapper_0.IOVSS1 sg13_lv_nmos ad=0.1323p pd=1.05u as=0.1428p ps=1.52u w=0.42u l=0.13u
X6004 QDLL_TOP_0.VDD a_188572_101637# a_188760_101343# QDLL_TOP_0.VDD sg13_lv_pmos ad=0.2481p pd=1.56u as=0.1428p ps=1.52u w=0.42u l=0.13u
X6005 user_project_wrapper_0.IOVSS1 a_369296_217444# analog_io[23] user_project_wrapper_0.IOVSS1 sg13_hv_nmos ad=1.408p pd=5.04u as=2.596p ps=5.58u w=4.4u l=0.6u
X6006 user_project_wrapper_0.analog_io[30] a_194687_324142# user_project_wrapper_0.IOVSS1 user_project_wrapper_0.IOVSS1 sg13_lv_pmos ad=1.824p pd=9.98u as=1.824p ps=9.98u w=9.6u l=0.13u
X6007 user_project_wrapper_0.analog_io[15] a_237844_41476# user_project_wrapper_0.IOVDD2 user_project_wrapper_0.IOVDD2 sg13_hv_pmos ad=3.9294p pd=7.84u as=2.1312p ps=7.3u w=6.66u l=0.6u
X6008 user_project_wrapper_0.IOVSS1 a_301186_192011# a_296731_208493# user_project_wrapper_0.IOVSS1 sg13_lv_nmos ad=0.912p pd=5.18u as=0.912p ps=5.18u w=4.8u l=1.06u
X6009 user_project_wrapper_0.IOVDD1 a_41476_237844# user_project_wrapper_0.analog_io[6] user_project_wrapper_0.IOVDD1 sg13_hv_pmos ad=2.1312p pd=7.3u as=3.9294p ps=7.84u w=6.66u l=0.6u
X6010 a_309917_199879# a_296731_208493# a_307232_196607# VDD3 sg13_lv_pmos ad=0.24415p pd=1.665u as=0.24415p ps=1.665u w=1.285u l=0.35u
X6011 a_307232_196607# a_296731_208493# a_309917_199879# VDD3 sg13_lv_pmos ad=0.24415p pd=1.665u as=0.24415p ps=1.665u w=1.285u l=0.35u
X6012 user_project_wrapper_0.IOVSS1 user_project_wrapper_0.sg13g2_IOPadIOVdd_1.sg13g2_Clamp_N43N43D4R_0.gate user_project_wrapper_0.IOVDD1 user_project_wrapper_0.IOVSS1 sg13_hv_nmos ad=1.408p pd=5.04u as=2.596p ps=5.58u w=4.4u l=0.6u
X6013 user_project_wrapper_0.IOVDD4 a_156244_355624# user_project_wrapper_0.analog_io[29] user_project_wrapper_0.IOVDD4 sg13_hv_pmos ad=2.1312p pd=7.3u as=3.9294p ps=7.84u w=6.66u l=0.6u
X6014 a_205385_326221# a_206201_328627# user_project_wrapper_0.IOVSS1 user_project_wrapper_0.IOVSS1 sg13_lv_pmos ad=1.824p pd=9.98u as=1.824p ps=9.98u w=9.6u l=0.13u
X6015 user_project_wrapper_0.sg13g2_IOPadIOVdd_0.sg13g2_Clamp_N43N43D4R_0.gate user_project_wrapper_0.sg13g2_IOPadIOVdd_0.sg13g2_RCClampResistor_0.p2 user_project_wrapper_0.IOVDD2 user_project_wrapper_0.IOVDD2 sg13_hv_pmos ad=1.33p pd=7.38u as=1.33p ps=7.38u w=7u l=0.5u
X6016 analog_io[19] a_355624_135844# IOVDD3 IOVDD3 sg13_hv_pmos ad=3.9294p pd=7.84u as=2.1312p ps=7.3u w=6.66u l=0.6u
X6017 VDD3 a_309516_194555# a_309917_194695# VDD3 sg13_lv_pmos ad=0.19p pd=1.38u as=0.19p ps=1.38u w=1u l=0.7u
X6018 user_project_wrapper_0.IOVDD2 a_278644_41476# QDLL_TOP_0.VOUT user_project_wrapper_0.IOVDD2 sg13_hv_pmos ad=2.1312p pd=7.3u as=3.9294p ps=7.84u w=6.66u l=0.6u
X6019 user_project_wrapper_0.VDD1 user_project_wrapper_0.sg13g2_IOPadVdd_2.sg13g2_RCClampInverter_noptap_0.out user_project_wrapper_0.IOVSS1 user_project_wrapper_0.IOVSS1 sg13_hv_nmos ad=2.596p pd=5.58u as=1.408p ps=5.04u w=4.4u l=0.6u
X6020 user_project_wrapper_0.IOVDD1 user_project_wrapper_0.sg13g2_IOPadIOVdd_1.sg13g2_Clamp_N43N43D4R_0.gate user_project_wrapper_0.IOVSS1 user_project_wrapper_0.IOVSS1 sg13_hv_nmos ad=2.596p pd=5.58u as=1.408p ps=5.04u w=4.4u l=0.6u
X6021 a_210417_326377# a_210007_326377# user_project_wrapper_0.IOVSS1 w_207887_326203# sg13_lv_pmos ad=0.68p pd=4.68u as=0.68p ps=4.68u w=2u l=0.13u
X6022 IOVDD3 a_355624_197044# analog_io[22] IOVDD3 sg13_hv_pmos ad=2.1312p pd=7.3u as=3.9294p ps=7.84u w=6.66u l=0.6u
X6023 analog_io[25] a_355624_258244# IOVDD3 IOVDD3 sg13_hv_pmos ad=3.9294p pd=7.84u as=2.1312p ps=7.3u w=6.66u l=0.6u
X6024 a_190082_92557# a_190638_90472# user_project_wrapper_0.IOVSS1 rppd l=10u w=1u
X6025 user_project_wrapper_0.IOVDD1 user_project_wrapper_0.sg13g2_IOPadIOVdd_1.sg13g2_RCClampResistor_0.p2 user_project_wrapper_0.sg13g2_IOPadIOVdd_1.sg13g2_Clamp_N43N43D4R_0.gate user_project_wrapper_0.IOVDD1 sg13_hv_pmos ad=1.33p pd=7.38u as=1.33p ps=7.38u w=7u l=0.5u
X6026 user_project_wrapper_0.IOVSS1 a_278644_369296# user_project_wrapper_0.analog_io[35] user_project_wrapper_0.IOVSS1 sg13_hv_nmos ad=1.408p pd=5.04u as=2.596p ps=5.58u w=4.4u l=0.6u
X6027 user_project_wrapper_0.sg13g2_IOPadIOVdd_2.sg13g2_Clamp_N43N43D4R_0.gate user_project_wrapper_0.sg13g2_IOPadIOVdd_2.sg13g2_RCClampResistor_0.p2 user_project_wrapper_0.IOVDD4 user_project_wrapper_0.IOVDD4 sg13_hv_pmos ad=1.33p pd=7.38u as=1.33p ps=7.38u w=7u l=0.5u
X6028 a_209041_327491# a_208939_328605# a_208939_327491# user_project_wrapper_0.IOVSS1 sg13_lv_nmos ad=0.19p pd=1.38u as=0.19p ps=1.38u w=1u l=0.13u
X6029 a_309917_194695# a_309516_194555# VDD3 VDD3 sg13_lv_pmos ad=0.19p pd=1.38u as=0.34p ps=2.68u w=1u l=0.7u
X6030 VDD3 user_project_wrapper_0.sg13g2_IOPadVdd_0.sg13g2_RCClampInverter_noptap_0.out user_project_wrapper_0.IOVSS1 user_project_wrapper_0.IOVSS1 sg13_hv_nmos ad=2.596p pd=5.58u as=2.068p ps=9.74u w=4.4u l=0.6u
X6031 user_project_wrapper_0.analog_io[13] a_197044_41476# user_project_wrapper_0.IOVDD2 user_project_wrapper_0.IOVDD2 sg13_hv_pmos ad=3.9294p pd=7.84u as=2.1312p ps=7.3u w=6.66u l=0.6u
X6032 user_project_wrapper_0.analog_io[0] a_41476_115444# user_project_wrapper_0.IOVDD1 user_project_wrapper_0.IOVDD1 sg13_hv_pmos ad=3.9294p pd=7.84u as=2.1312p ps=7.3u w=6.66u l=0.6u
X6033 IOVDD3 user_project_wrapper_0.sg13g2_IOPadIOVdd_3.sg13g2_RCClampResistor_0.p2 user_project_wrapper_0.sg13g2_IOPadIOVdd_3.sg13g2_Clamp_N43N43D4R_0.gate IOVDD3 sg13_hv_pmos ad=2.38p pd=14.68u as=1.33p ps=7.38u w=7u l=0.5u
X6034 a_309917_199879# a_309516_194555# VDD3 VDD3 sg13_lv_pmos ad=0.19p pd=1.38u as=0.19p ps=1.38u w=1u l=0.7u
X6035 user_project_wrapper_0.analog_io[11] a_156244_29676# user_project_wrapper_0.IOVSS1 user_project_wrapper_0.IOVSS1 sg13_hv_nmos ad=2.596p pd=5.58u as=1.408p ps=5.04u w=4.4u l=0.6u
X6036 analog_io[18] a_355624_115444# IOVDD3 IOVDD3 sg13_hv_pmos ad=3.9294p pd=7.84u as=2.1312p ps=7.3u w=6.66u l=0.6u
X6037 user_project_wrapper_0.IOVSS1 a_301186_192011# a_296731_189665# user_project_wrapper_0.IOVSS1 sg13_lv_nmos ad=0.912p pd=5.18u as=0.912p ps=5.18u w=4.8u l=1.06u
X6038 user_project_wrapper_0.analog_io[27] a_182931_326125# user_project_wrapper_0.IOVSS1 user_project_wrapper_0.IOVSS1 sg13_lv_pmos ad=1.824p pd=9.98u as=1.824p ps=9.98u w=9.6u l=0.13u
X6039 user_project_wrapper_0.sg13g2_IOPadVdd_2.sg13g2_RCClampInverter_noptap_0.out user_project_wrapper_0.sg13g2_IOPadVdd_2.sg13g2_RCClampResistor_0.p2 user_project_wrapper_0.VDD1 user_project_wrapper_0.VDD1 sg13_hv_pmos ad=1.33p pd=7.38u as=1.33p ps=7.38u w=7u l=0.5u
X6040 a_57810_179517# a_58170_179249# user_project_wrapper_0.IOVDD1 user_project_wrapper_0.IOVDD1 sg13_hv_pmos ad=0.102p pd=1.28u as=57f ps=0.68u w=0.3u l=0.45u
X6041 user_project_wrapper_0.IOVDD4 user_project_wrapper_0.sg13g2_IOPadIOVdd_2.sg13g2_Clamp_N43N43D4R_0.gate user_project_wrapper_0.IOVSS1 user_project_wrapper_0.IOVSS1 sg13_hv_nmos ad=2.596p pd=5.58u as=1.408p ps=5.04u w=4.4u l=0.6u
X6042 user_project_wrapper_0.IOVSS1 user_project_wrapper_0.IOVSS1 user_project_wrapper_0.IOVSS1 rppd l=0.5u w=0.5u
X6043 user_project_wrapper_0.sg13g2_IOPadVdd_0.sg13g2_RCClampInverter_noptap_0.out user_project_wrapper_0.sg13g2_IOPadVdd_0.sg13g2_RCClampResistor_0.p2 VDD3 VDD3 sg13_hv_pmos ad=1.33p pd=7.38u as=1.33p ps=7.38u w=7u l=0.5u
X6044 user_project_wrapper_0.analog_io[15] a_190389_101343# QDLL_TOP_0.VDD QDLL_TOP_0.VDD sg13_lv_pmos ad=0.2128p pd=1.5u as=0.4368p ps=3.02u w=1.12u l=0.13u
X6045 a_309516_194555# a_309516_194555# VDD3 VDD3 sg13_lv_pmos ad=0.19p pd=1.38u as=0.19p ps=1.38u w=1u l=0.7u
X6046 user_project_wrapper_0.IOVSS1 a_258244_29676# user_project_wrapper_0.analog_io[16] user_project_wrapper_0.IOVSS1 sg13_hv_nmos ad=1.408p pd=5.04u as=2.596p ps=5.58u w=4.4u l=0.6u
X6047 IOVDD3 a_355624_176644# analog_io[20] IOVDD3 sg13_hv_pmos ad=2.1312p pd=7.3u as=3.9294p ps=7.84u w=6.66u l=0.6u
X6048 user_project_wrapper_0.sg13g2_IOPadIOVdd_0.sg13g2_RCClampResistor_0.p2 a_305695_35456# user_project_wrapper_0.IOVSS1 rppd l=20u w=1u
X6049 user_project_wrapper_0.analog_io[10] a_135844_29676# user_project_wrapper_0.IOVSS1 user_project_wrapper_0.IOVSS1 sg13_hv_nmos ad=2.596p pd=5.58u as=1.408p ps=5.04u w=4.4u l=0.6u
X6050 a_311108_215937# analog_io[23] a_313884_211353# user_project_wrapper_0.IOVSS1 sg13_lv_nmos ad=1.9p pd=10.38u as=1.9p ps=10.38u w=10u l=0.5u
X6051 QDLL_TOP_0.VOUT a_271172_100118# user_project_wrapper_0.IOVSS1 user_project_wrapper_0.IOVSS1 sg13_lv_nmos ad=0.1406p pd=1.12u as=0.1406p ps=1.12u w=0.74u l=0.13u
X6052 user_project_wrapper_0.IOVSS1 user_project_wrapper_0.sg13g2_IOPadVdd_1.sg13g2_RCClampInverter_noptap_0.out user_project_wrapper_0.VDD2 user_project_wrapper_0.IOVSS1 sg13_hv_nmos ad=1.408p pd=5.04u as=2.596p ps=5.58u w=4.4u l=0.6u
X6053 user_project_wrapper_0.VDD1 a_85435_125173# a_85359_125209# user_project_wrapper_0.VDD1 sg13_lv_pmos ad=0.3808p pd=2.92u as=0.2128p ps=1.5u w=1.12u l=0.13u
X6054 user_project_wrapper_0.IOVSS1 user_project_wrapper_0.sg13g2_IOPadIOVdd_2.sg13g2_Clamp_N43N43D4R_0.gate user_project_wrapper_0.IOVDD4 user_project_wrapper_0.IOVSS1 sg13_hv_nmos ad=1.408p pd=5.04u as=2.596p ps=5.58u w=4.4u l=0.6u
X6055 a_190722_327491# a_189756_327491# user_project_wrapper_0.IOVSS1 user_project_wrapper_0.IOVSS1 sg13_lv_nmos ad=0.19p pd=1.38u as=0.34p ps=2.68u w=1u l=0.13u
X6056 user_project_wrapper_0.IOVSS1 user_project_wrapper_0.sg13g2_IOPadVdd_2.sg13g2_RCClampInverter_noptap_0.out user_project_wrapper_0.VDD1 user_project_wrapper_0.IOVSS1 sg13_hv_nmos ad=1.408p pd=5.04u as=2.596p ps=5.58u w=4.4u l=0.6u
X6057 user_project_wrapper_0.IOVSS1 user_project_wrapper_0.sg13g2_IOPadVdd_1.sg13g2_RCClampInverter_noptap_0.out user_project_wrapper_0.VDD2 user_project_wrapper_0.IOVSS1 sg13_hv_nmos ad=1.408p pd=5.04u as=2.596p ps=5.58u w=4.4u l=0.6u
X6058 a_86594_129061# a_86507_129255# user_project_wrapper_0.IOVSS1 user_project_wrapper_0.IOVSS1 sg13_lv_nmos ad=0.1406p pd=1.12u as=0.2516p ps=2.16u w=0.74u l=0.13u
X6059 user_project_wrapper_0.IOVSS1 a_369296_135844# analog_io[19] user_project_wrapper_0.IOVSS1 sg13_hv_nmos ad=1.408p pd=5.04u as=2.596p ps=5.58u w=4.4u l=0.6u
X6060 analog_io[22] a_369296_197044# user_project_wrapper_0.IOVSS1 user_project_wrapper_0.IOVSS1 sg13_hv_nmos ad=2.596p pd=5.58u as=1.408p ps=5.04u w=4.4u l=0.6u
X6061 user_project_wrapper_0.analog_io[4] a_41476_197044# user_project_wrapper_0.IOVDD1 user_project_wrapper_0.IOVDD1 sg13_hv_pmos ad=3.9294p pd=7.84u as=2.1312p ps=7.3u w=6.66u l=0.6u
X6062 IOVDD3 a_355624_135844# analog_io[19] IOVDD3 sg13_hv_pmos ad=2.1312p pd=7.3u as=3.9294p ps=7.84u w=6.66u l=0.6u
X6063 VDD3 a_311189_185546# a_311189_185546# VDD3 sg13_lv_pmos ad=1.9p pd=10.38u as=1.9p ps=10.38u w=10u l=1u
X6064 a_311846_195517# a_311846_195517# user_project_wrapper_0.IOVSS1 user_project_wrapper_0.IOVSS1 sg13_lv_nmos ad=0.6327p pd=3.71u as=0.6327p ps=3.71u w=3.33u l=0.2u
X6065 user_project_wrapper_0.IOVDD1 user_project_wrapper_0.sg13g2_IOPadIOVdd_1.sg13g2_RCClampResistor_0.p2 user_project_wrapper_0.sg13g2_IOPadIOVdd_1.sg13g2_Clamp_N43N43D4R_0.gate user_project_wrapper_0.IOVDD1 sg13_hv_pmos ad=1.33p pd=7.38u as=1.33p ps=7.38u w=7u l=0.5u
X6066 user_project_wrapper_0.IOVSS1 user_project_wrapper_0.sg13g2_IOPadVdd_0.sg13g2_RCClampInverter_noptap_0.out VDD3 user_project_wrapper_0.IOVSS1 sg13_hv_nmos ad=1.408p pd=5.04u as=2.596p ps=5.58u w=4.4u l=0.6u
X6067 user_project_wrapper_0.IOVDD2 a_176644_41476# user_project_wrapper_0.analog_io[12] user_project_wrapper_0.IOVDD2 sg13_hv_pmos ad=3.1302p pd=14.26u as=3.9294p ps=7.84u w=6.66u l=0.6u
X6068 user_project_wrapper_0.analog_io[32] a_202114_326125# user_project_wrapper_0.IOVSS1 user_project_wrapper_0.IOVSS1 sg13_lv_pmos ad=1.824p pd=9.98u as=3.264p ps=19.88u w=9.6u l=0.13u
X6069 user_project_wrapper_0.analog_io[27] a_182931_326125# user_project_wrapper_0.IOVSS1 user_project_wrapper_0.IOVSS1 sg13_lv_pmos ad=1.824p pd=9.98u as=1.824p ps=9.98u w=9.6u l=0.13u
X6070 user_project_wrapper_0.IOVSS1 a_79038_132196# a_79038_132196# user_project_wrapper_0.IOVSS1 sg13_lv_nmos ad=0.1428p pd=1.52u as=0.1428p ps=1.52u w=0.42u l=0.56u
X6071 user_project_wrapper_0.IOVSS1 user_project_wrapper_0.sg13g2_IOPadIOVdd_2.sg13g2_Clamp_N43N43D4R_0.gate user_project_wrapper_0.IOVDD4 user_project_wrapper_0.IOVSS1 sg13_hv_nmos ad=1.408p pd=5.04u as=2.596p ps=5.58u w=4.4u l=0.6u
X6072 user_project_wrapper_0.sg13g2_IOPadVdd_3.sg13g2_RCClampInverter_noptap_0.out user_project_wrapper_0.sg13g2_IOPadVdd_3.sg13g2_RCClampResistor_0.p2 user_project_wrapper_0.IOVSS1 user_project_wrapper_0.IOVSS1 sg13_hv_pmos ad=1.33p pd=7.38u as=1.33p ps=7.38u w=7u l=0.5u
X6073 user_project_wrapper_0.IOVDD2 a_135844_41476# user_project_wrapper_0.analog_io[10] user_project_wrapper_0.IOVDD2 sg13_hv_pmos ad=2.1312p pd=7.3u as=3.9294p ps=7.84u w=6.66u l=0.6u
X6074 a_296731_189665# a_296625_189595# VDD3 VDD3 sg13_lv_pmos ad=0.2603p pd=1.75u as=0.2603p ps=1.75u w=1.37u l=0.35u
X6075 user_project_wrapper_0.IOVSS1 user_project_wrapper_0.sg13g2_IOPadIOVdd_0.sg13g2_Clamp_N43N43D4R_0.gate user_project_wrapper_0.IOVDD2 user_project_wrapper_0.IOVSS1 sg13_hv_nmos ad=1.408p pd=5.04u as=2.596p ps=5.58u w=4.4u l=0.6u
X6076 user_project_wrapper_0.IOVSS1 a_301186_192011# a_296731_189665# user_project_wrapper_0.IOVSS1 sg13_lv_nmos ad=0.912p pd=5.18u as=0.912p ps=5.18u w=4.8u l=1.06u
X6077 user_project_wrapper_0.IOVSS1 a_213870_324142# user_project_wrapper_0.analog_io[35] user_project_wrapper_0.IOVSS1 sg13_lv_pmos ad=1.824p pd=9.98u as=1.824p ps=9.98u w=9.6u l=0.13u
X6078 user_project_wrapper_0.analog_io[27] a_115444_355624# user_project_wrapper_0.IOVDD4 user_project_wrapper_0.IOVDD4 sg13_hv_pmos ad=3.9294p pd=7.84u as=2.1312p ps=7.3u w=6.66u l=0.6u
X6079 user_project_wrapper_0.IOVSS1 user_project_wrapper_0.sg13g2_IOPadIOVdd_0.sg13g2_RCClampResistor_0.p2 user_project_wrapper_0.IOVSS1 user_project_wrapper_0.IOVSS1 sg13_hv_nmos ad=1.71p pd=9.38u as=0 ps=0 w=9u l=9.5u
X6080 user_project_wrapper_0.analog_io[27] a_182931_326125# user_project_wrapper_0.IOVSS1 user_project_wrapper_0.IOVSS1 sg13_lv_pmos ad=1.824p pd=9.98u as=1.824p ps=9.98u w=9.6u l=0.13u
X6081 analog_io[20] a_355624_176644# IOVDD3 IOVDD3 sg13_hv_pmos ad=3.9294p pd=7.84u as=2.1312p ps=7.3u w=6.66u l=0.6u
X6082 VDD3 a_309516_194555# a_309516_194555# VDD3 sg13_lv_pmos ad=0.19p pd=1.38u as=0.19p ps=1.38u w=1u l=0.7u
X6083 user_project_wrapper_0.IOVSS1 user_project_wrapper_0.sg13g2_IOPadIOVdd_0.sg13g2_Clamp_N43N43D4R_0.gate user_project_wrapper_0.IOVDD2 user_project_wrapper_0.IOVSS1 sg13_hv_nmos ad=1.408p pd=5.04u as=2.596p ps=5.58u w=4.4u l=0.6u
X6084 user_project_wrapper_0.IOVDD1 a_41476_115444# user_project_wrapper_0.analog_io[0] user_project_wrapper_0.IOVDD1 sg13_hv_pmos ad=2.1312p pd=7.3u as=3.9294p ps=7.84u w=6.66u l=0.6u
X6085 user_project_wrapper_0.analog_io[15] a_190389_101343# QDLL_TOP_0.VDD QDLL_TOP_0.VDD sg13_lv_pmos ad=0.2128p pd=1.5u as=0.2128p ps=1.5u w=1.12u l=0.13u
X6086 analog_io[20] a_311108_179669# VDD3 user_project_wrapper_0.IOVSS1 sg13_lv_nmos ad=3.4p pd=20.68u as=3.4p ps=20.68u w=10u l=0.15u
X6087 a_296731_208493# a_296625_208423# VDD3 VDD3 sg13_lv_pmos ad=0.2603p pd=1.75u as=0.2603p ps=1.75u w=1.37u l=0.35u
X6088 user_project_wrapper_0.IOVSS1 a_188834_326341# a_189858_325785# w_188704_326203# sg13_lv_pmos ad=0.68p pd=4.68u as=0.38p ps=2.38u w=2u l=0.13u
X6089 user_project_wrapper_0.IOVSS1 user_project_wrapper_0.sg13g2_IOPadIOVdd_1.sg13g2_Clamp_N43N43D4R_0.gate user_project_wrapper_0.IOVDD1 user_project_wrapper_0.IOVSS1 sg13_hv_nmos ad=1.408p pd=5.04u as=2.596p ps=5.58u w=4.4u l=0.6u
X6090 QDLL_TOP_0.VOUT a_271172_100118# user_project_wrapper_0.IOVSS1 user_project_wrapper_0.IOVSS1 sg13_lv_nmos ad=0.1406p pd=1.12u as=0.1406p ps=1.12u w=0.74u l=0.13u
X6091 user_project_wrapper_0.VDD1 a_92512_129426# a_93204_129062# user_project_wrapper_0.VDD1 sg13_lv_pmos ad=0.2128p pd=1.5u as=0.2128p ps=1.5u w=1.12u l=0.13u
X6092 analog_io[26] a_355624_278644# IOVDD3 IOVDD3 sg13_hv_pmos ad=3.9294p pd=7.84u as=2.1312p ps=7.3u w=6.66u l=0.6u
X6093 user_project_wrapper_0.analog_io[32] a_202114_326125# user_project_wrapper_0.IOVSS1 user_project_wrapper_0.IOVSS1 sg13_lv_pmos ad=1.824p pd=9.98u as=1.824p ps=9.98u w=9.6u l=0.13u
X6094 analog_io[19] IOVDD3 dpantenna l=27.78u w=1.26u
X6095 a_304995_198817# a_304889_199957# a_304196_200821# user_project_wrapper_0.IOVSS1 sg13_lv_nmos ad=0.209p pd=1.48u as=0.209p ps=1.48u w=1.1u l=0.15u
X6096 IOVDD3 user_project_wrapper_0.sg13g2_IOPadIOVdd_3.sg13g2_RCClampResistor_0.p2 user_project_wrapper_0.sg13g2_IOPadIOVdd_3.sg13g2_Clamp_N43N43D4R_0.gate IOVDD3 sg13_hv_pmos ad=1.33p pd=7.38u as=1.33p ps=7.38u w=7u l=0.5u
X6097 user_project_wrapper_0.IOVSS1 user_project_wrapper_0.sg13g2_IOPadVdd_3.sg13g2_RCClampResistor_0.p2 user_project_wrapper_0.IOVSS1 user_project_wrapper_0.IOVSS1 sg13_hv_nmos ad=1.71p pd=9.38u as=0 ps=0 w=9u l=9.5u
X6098 user_project_wrapper_0.analog_io[29] a_156244_355624# user_project_wrapper_0.IOVDD4 user_project_wrapper_0.IOVDD4 sg13_hv_pmos ad=3.9294p pd=7.84u as=2.1312p ps=7.3u w=6.66u l=0.6u
X6099 user_project_wrapper_0.IOVSS1 a_258244_29676# user_project_wrapper_0.analog_io[16] user_project_wrapper_0.IOVSS1 sg13_hv_nmos ad=1.408p pd=5.04u as=2.596p ps=5.58u w=4.4u l=0.6u
X6100 IOVDD3 a_355624_237844# analog_io[23] IOVDD3 sg13_hv_pmos ad=2.1312p pd=7.3u as=3.9294p ps=7.84u w=6.66u l=0.6u
X6101 a_210109_328013# a_208367_327491# a_210007_327491# w_207887_327938# sg13_lv_pmos ad=0.38p pd=2.38u as=0.38p ps=2.38u w=2u l=0.13u
X6102 user_project_wrapper_0.IOVSS1 user_project_wrapper_0.IOVSS1 user_project_wrapper_0.IOVSS1 rppd l=0.5u w=0.5u
X6103 a_83389_129203# a_79025_133911# a_83389_128838# user_project_wrapper_0.IOVSS1 sg13_lv_nmos ad=0.2516p pd=2.16u as=0.1406p ps=1.12u w=0.74u l=0.13u
X6104 user_project_wrapper_0.IOVDD4 user_project_wrapper_0.sg13g2_IOPadIOVdd_2.sg13g2_Clamp_N43N43D4R_0.gate user_project_wrapper_0.IOVSS1 user_project_wrapper_0.IOVSS1 sg13_hv_nmos ad=2.596p pd=5.58u as=2.068p ps=9.74u w=4.4u l=0.6u
X6105 user_project_wrapper_0.VDD2 user_project_wrapper_0.sg13g2_IOPadVdd_1.sg13g2_RCClampInverter_noptap_0.out user_project_wrapper_0.IOVSS1 user_project_wrapper_0.IOVSS1 sg13_hv_nmos ad=2.596p pd=5.58u as=1.408p ps=5.04u w=4.4u l=0.6u
X6106 VDD3 a_311189_211724# a_311108_215937# VDD3 sg13_lv_pmos ad=1.9p pd=10.38u as=1.9p ps=10.38u w=10u l=1u
X6107 user_project_wrapper_0.analog_io[32] a_202114_326125# user_project_wrapper_0.IOVSS1 user_project_wrapper_0.IOVSS1 sg13_lv_pmos ad=1.824p pd=9.98u as=1.824p ps=9.98u w=9.6u l=0.13u
X6108 a_309917_199879# a_309516_194555# VDD3 VDD3 sg13_lv_pmos ad=0.19p pd=1.38u as=0.19p ps=1.38u w=1u l=0.7u
X6109 VDD3 a_309516_194555# a_309917_199879# VDD3 sg13_lv_pmos ad=0.19p pd=1.38u as=0.19p ps=1.38u w=1u l=0.7u
X6110 user_project_wrapper_0.IOVSS1 a_194279_327536# a_194687_324142# user_project_wrapper_0.IOVSS1 sg13_lv_nmos ad=0.912p pd=5.18u as=0.912p ps=5.18u w=4.8u l=0.13u
X6111 user_project_wrapper_0.sg13g2_IOPadIOVdd_0.sg13g2_Clamp_N43N43D4R_0.gate user_project_wrapper_0.sg13g2_IOPadIOVdd_0.sg13g2_RCClampResistor_0.p2 user_project_wrapper_0.IOVDD2 user_project_wrapper_0.IOVDD2 sg13_hv_pmos ad=1.33p pd=7.38u as=1.33p ps=7.38u w=7u l=0.5u
X6112 a_315347_192648# a_314793_201808# a_314697_196700# user_project_wrapper_0.IOVSS1 sg13_lv_nmos ad=1.14p pd=6.38u as=1.14p ps=6.38u w=6u l=6.4u
X6113 user_project_wrapper_0.IOVSS1 user_project_wrapper_0.sg13g2_IOPadVdd_3.sg13g2_RCClampResistor_0.p2 user_project_wrapper_0.sg13g2_IOPadVdd_3.sg13g2_RCClampInverter_noptap_0.out user_project_wrapper_0.IOVSS1 sg13_hv_pmos ad=1.33p pd=7.38u as=1.33p ps=7.38u w=7u l=0.5u
X6114 user_project_wrapper_0.IOVDD2 a_217444_41476# user_project_wrapper_0.analog_io[14] user_project_wrapper_0.IOVDD2 sg13_hv_pmos ad=2.1312p pd=7.3u as=3.9294p ps=7.84u w=6.66u l=0.6u
X6115 a_296731_208493# a_296625_208423# VDD3 VDD3 sg13_lv_pmos ad=0.2603p pd=1.75u as=0.2603p ps=1.75u w=1.37u l=0.35u
X6116 user_project_wrapper_0.IOVSS1 a_194279_327536# a_194687_324142# user_project_wrapper_0.IOVSS1 sg13_lv_nmos ad=0.912p pd=5.18u as=0.912p ps=5.18u w=4.8u l=0.13u
X6117 user_project_wrapper_0.VDD2 user_project_wrapper_0.sg13g2_IOPadVdd_1.sg13g2_RCClampInverter_noptap_0.out user_project_wrapper_0.IOVSS1 user_project_wrapper_0.IOVSS1 sg13_hv_nmos ad=2.596p pd=5.58u as=1.408p ps=5.04u w=4.4u l=0.6u
X6118 a_311189_211724# a_296731_208493# a_313884_211353# user_project_wrapper_0.IOVSS1 sg13_lv_nmos ad=1.9p pd=10.38u as=3.4p ps=20.68u w=10u l=0.5u
X6119 user_project_wrapper_0.IOVSS1 a_189729_99046# a_190389_99046# user_project_wrapper_0.IOVSS1 sg13_lv_nmos ad=0.2516p pd=2.16u as=0.1443p ps=1.13u w=0.74u l=0.13u
X6120 user_project_wrapper_0.IOVSS1 user_project_wrapper_0.sg13g2_IOPadIOVdd_3.sg13g2_Clamp_N43N43D4R_0.gate IOVDD3 user_project_wrapper_0.IOVSS1 sg13_hv_nmos ad=1.408p pd=5.04u as=2.596p ps=5.58u w=4.4u l=0.6u
X6121 user_project_wrapper_0.IOVDD4 user_project_wrapper_0.sg13g2_IOPadIOVdd_2.sg13g2_Clamp_N43N43D4R_0.gate user_project_wrapper_0.IOVSS1 user_project_wrapper_0.IOVSS1 sg13_hv_nmos ad=2.596p pd=5.58u as=1.408p ps=5.04u w=4.4u l=0.6u
X6122 a_86507_129255# a_87468_125419# user_project_wrapper_0.VDD1 user_project_wrapper_0.VDD1 sg13_lv_pmos ad=0.3808p pd=2.92u as=0.3808p ps=2.92u w=1.12u l=0.13u
X6123 a_296731_208493# a_296625_208423# VDD3 VDD3 sg13_lv_pmos ad=0.2603p pd=1.75u as=0.2603p ps=1.75u w=1.37u l=0.35u
X6124 a_188834_326341# a_188834_326341# user_project_wrapper_0.IOVSS1 w_188704_326203# sg13_lv_pmos ad=0.68p pd=4.68u as=0.68p ps=4.68u w=2u l=0.13u
X6125 a_296731_208493# a_296625_208423# VDD3 VDD3 sg13_lv_pmos ad=0.2603p pd=1.75u as=0.2603p ps=1.75u w=1.37u l=0.35u
X6126 user_project_wrapper_0.IOVSS1 a_202114_326125# user_project_wrapper_0.analog_io[32] user_project_wrapper_0.IOVSS1 sg13_lv_nmos ad=0.912p pd=5.18u as=0.912p ps=5.18u w=4.8u l=0.13u
X6127 user_project_wrapper_0.sg13g2_IOPadIOVdd_2.sg13g2_Clamp_N43N43D4R_0.gate user_project_wrapper_0.sg13g2_IOPadIOVdd_2.sg13g2_RCClampResistor_0.p2 user_project_wrapper_0.IOVDD4 user_project_wrapper_0.IOVDD4 sg13_hv_pmos ad=1.33p pd=7.38u as=1.33p ps=7.38u w=7u l=0.5u
X6128 user_project_wrapper_0.IOVDD1 a_41476_237844# user_project_wrapper_0.analog_io[6] user_project_wrapper_0.IOVDD1 sg13_hv_pmos ad=2.1312p pd=7.3u as=3.9294p ps=7.84u w=6.66u l=0.6u
X6129 user_project_wrapper_0.IOVDD4 a_237844_355624# user_project_wrapper_0.analog_io[33] user_project_wrapper_0.IOVDD4 sg13_hv_pmos ad=2.1312p pd=7.3u as=3.9294p ps=7.84u w=6.66u l=0.6u
X6130 user_project_wrapper_0.IOVSS1 a_188834_327918# a_189286_328605# w_188704_327938# sg13_lv_pmos ad=0.68p pd=4.68u as=0.38p ps=2.38u w=2u l=0.13u
X6131 user_project_wrapper_0.IOVSS1 a_202114_326125# user_project_wrapper_0.analog_io[32] user_project_wrapper_0.IOVSS1 sg13_lv_nmos ad=0.912p pd=5.18u as=0.912p ps=5.18u w=4.8u l=0.13u
X6132 user_project_wrapper_0.analog_io[11] a_156244_41476# user_project_wrapper_0.IOVDD2 user_project_wrapper_0.IOVDD2 sg13_hv_pmos ad=3.9294p pd=7.84u as=2.1312p ps=7.3u w=6.66u l=0.6u
X6133 a_296625_208423# a_304090_197941# a_304196_200821# user_project_wrapper_0.IOVSS1 sg13_lv_nmos ad=0.361p pd=2.28u as=0.361p ps=2.28u w=1.9u l=0.16u
X6134 VDD3 a_296625_189595# a_296731_189665# VDD3 sg13_lv_pmos ad=0.2603p pd=1.75u as=0.2603p ps=1.75u w=1.37u l=0.35u
X6135 user_project_wrapper_0.IOVSS1 a_301186_192011# a_296731_208493# user_project_wrapper_0.IOVSS1 sg13_lv_nmos ad=0.912p pd=5.18u as=0.912p ps=5.18u w=4.8u l=1.06u
X6136 a_296731_208493# a_296625_208423# VDD3 VDD3 sg13_lv_pmos ad=0.2603p pd=1.75u as=0.4658p ps=3.42u w=1.37u l=0.35u
X6137 user_project_wrapper_0.IOVSS1 user_project_wrapper_0.IOVSS1 user_project_wrapper_0.IOVSS1 rhigh l=4u w=0.5u
X6138 user_project_wrapper_0.analog_io[32] a_202114_326125# user_project_wrapper_0.IOVSS1 user_project_wrapper_0.IOVSS1 sg13_lv_pmos ad=1.824p pd=9.98u as=1.824p ps=9.98u w=9.6u l=0.13u
X6139 a_296731_208493# a_301186_192011# user_project_wrapper_0.IOVSS1 user_project_wrapper_0.IOVSS1 sg13_lv_nmos ad=0.912p pd=5.18u as=1.632p ps=10.28u w=4.8u l=1.06u
X6140 a_309917_194695# a_309516_194555# VDD3 VDD3 sg13_lv_pmos ad=0.19p pd=1.38u as=0.19p ps=1.38u w=1u l=0.7u
X6141 analog_io[23] a_355624_237844# IOVDD3 IOVDD3 sg13_hv_pmos ad=3.9294p pd=7.84u as=3.1302p ps=14.26u w=6.66u l=0.6u
X6142 user_project_wrapper_0.sg13g2_IOPadVdd_3.sg13g2_RCClampInverter_noptap_0.out user_project_wrapper_0.sg13g2_IOPadVdd_3.sg13g2_RCClampResistor_0.p2 user_project_wrapper_0.IOVSS1 user_project_wrapper_0.IOVSS1 sg13_hv_pmos ad=1.33p pd=7.38u as=1.33p ps=7.38u w=7u l=0.5u
X6143 user_project_wrapper_0.IOVSS1 user_project_wrapper_0.sg13g2_IOPadIn$1_2.sg13g2_LevelDown_noptap$1_0.sg13g2_SecondaryProtection$1$1_0.core dantenna l=3.1u w=0.64u
X6144 user_project_wrapper_0.analog_io[29] a_156244_369296# user_project_wrapper_0.IOVSS1 user_project_wrapper_0.IOVSS1 sg13_hv_nmos ad=2.596p pd=5.58u as=2.068p ps=9.74u w=4.4u l=0.6u
X6145 user_project_wrapper_0.IOVDD2 a_176644_41476# user_project_wrapper_0.analog_io[12] user_project_wrapper_0.IOVDD2 sg13_hv_pmos ad=2.1312p pd=7.3u as=3.9294p ps=7.84u w=6.66u l=0.6u
X6146 user_project_wrapper_0.IOVDD1 user_project_wrapper_0.sg13g2_IOPadIOVdd_1.sg13g2_Clamp_N43N43D4R_0.gate user_project_wrapper_0.IOVSS1 user_project_wrapper_0.IOVSS1 sg13_hv_nmos ad=2.596p pd=5.58u as=1.408p ps=5.04u w=4.4u l=0.6u
X6147 user_project_wrapper_0.VDD1 a_83492_127455# a_87434_127896# user_project_wrapper_0.VDD1 sg13_lv_pmos ad=0.3808p pd=2.92u as=0.2128p ps=1.5u w=1.12u l=0.13u
X6148 a_296731_189665# a_296625_189595# VDD3 VDD3 sg13_lv_pmos ad=0.2603p pd=1.75u as=0.2603p ps=1.75u w=1.37u l=0.35u
X6149 a_309917_199879# a_309516_194555# VDD3 VDD3 sg13_lv_pmos ad=0.19p pd=1.38u as=0.19p ps=1.38u w=1u l=0.7u
X6150 user_project_wrapper_0.VDD2 user_project_wrapper_0.sg13g2_IOPadVdd_1.sg13g2_RCClampInverter_noptap_0.out user_project_wrapper_0.IOVSS1 user_project_wrapper_0.IOVSS1 sg13_hv_nmos ad=2.596p pd=5.58u as=1.408p ps=5.04u w=4.4u l=0.6u
X6151 user_project_wrapper_0.IOVSS1 user_project_wrapper_0.sg13g2_IOPadVdd_0.sg13g2_RCClampResistor_0.p2 user_project_wrapper_0.sg13g2_IOPadVdd_0.sg13g2_RCClampInverter_noptap_0.out user_project_wrapper_0.IOVSS1 sg13_hv_nmos ad=1.71p pd=9.38u as=1.71p ps=9.38u w=9u l=0.5u
X6152 a_300745_39542# a_300415_35456# user_project_wrapper_0.IOVSS1 rppd l=20u w=1u
X6153 a_190319_102855# user_project_wrapper_0.analog_io[15] a_190287_102497# QDLL_TOP_0.VDD sg13_lv_pmos ad=0.34p pd=2.68u as=0.1225p ps=1.245u w=1u l=0.13u
X6154 user_project_wrapper_0.IOVDD1 a_41476_217444# user_project_wrapper_0.IOVDD1 rppd l=12.9u w=0.5u
X6155 user_project_wrapper_0.VDD2 user_project_wrapper_0.sg13g2_IOPadVdd_1.sg13g2_RCClampInverter_noptap_0.out user_project_wrapper_0.IOVSS1 user_project_wrapper_0.IOVSS1 sg13_hv_nmos ad=2.596p pd=5.58u as=1.408p ps=5.04u w=4.4u l=0.6u
X6156 analog_io[18] IOVDD3 dpantenna l=27.78u w=1.26u
X6157 user_project_wrapper_0.IOVSS1 a_194687_324142# user_project_wrapper_0.analog_io[30] user_project_wrapper_0.IOVSS1 sg13_lv_nmos ad=0.912p pd=5.18u as=0.912p ps=5.18u w=4.8u l=0.13u
X6158 user_project_wrapper_0.VDD1 user_project_wrapper_0.sg13g2_IOPadVdd_2.sg13g2_RCClampInverter_noptap_0.out user_project_wrapper_0.IOVSS1 user_project_wrapper_0.IOVSS1 sg13_hv_nmos ad=2.596p pd=5.58u as=1.408p ps=5.04u w=4.4u l=0.6u
X6159 VDD3 user_project_wrapper_0.sg13g2_IOPadVdd_0.sg13g2_RCClampInverter_noptap_0.out user_project_wrapper_0.IOVSS1 user_project_wrapper_0.IOVSS1 sg13_hv_nmos ad=2.596p pd=5.58u as=1.408p ps=5.04u w=4.4u l=0.6u
X6160 a_311108_179669# analog_io[20] a_313884_185173# user_project_wrapper_0.IOVSS1 sg13_lv_nmos ad=1.9p pd=10.38u as=1.9p ps=10.38u w=10u l=0.5u
X6161 user_project_wrapper_0.sg13g2_IOPadAnalog_14.padres user_project_wrapper_0.IOVDD1 dpantenna l=4.98u w=0.64u
X6162 user_project_wrapper_0.analog_io[35] a_278644_355624# user_project_wrapper_0.IOVDD4 user_project_wrapper_0.IOVDD4 sg13_hv_pmos ad=3.9294p pd=7.84u as=2.1312p ps=7.3u w=6.66u l=0.6u
X6163 user_project_wrapper_0.IOVSS1 a_307232_196607# a_304995_198817# user_project_wrapper_0.IOVSS1 sg13_lv_nmos ad=0.6327p pd=3.71u as=0.6327p ps=3.71u w=3.33u l=0.2u
X6164 user_project_wrapper_0.analog_io[27] a_115444_355624# user_project_wrapper_0.IOVDD4 user_project_wrapper_0.IOVDD4 sg13_hv_pmos ad=3.9294p pd=7.84u as=2.1312p ps=7.3u w=6.66u l=0.6u
X6165 VDD3 user_project_wrapper_0.sg13g2_IOPadVdd_0.sg13g2_RCClampInverter_noptap_0.out user_project_wrapper_0.IOVSS1 user_project_wrapper_0.IOVSS1 sg13_hv_nmos ad=2.596p pd=5.58u as=1.408p ps=5.04u w=4.4u l=0.6u
X6166 VDD3 a_309516_194555# a_309917_199879# VDD3 sg13_lv_pmos ad=0.19p pd=1.38u as=0.19p ps=1.38u w=1u l=0.7u
X6167 user_project_wrapper_0.IOVSS1 a_206547_324106# a_206201_328627# user_project_wrapper_0.IOVSS1 sg13_lv_nmos ad=1.632p pd=10.28u as=1.632p ps=10.28u w=4.8u l=0.13u
X6168 user_project_wrapper_0.IOVSS1 user_project_wrapper_0.sg13g2_IOPadVdd_0.sg13g2_RCClampInverter_noptap_0.out VDD3 user_project_wrapper_0.IOVSS1 sg13_hv_nmos ad=1.408p pd=5.04u as=2.596p ps=5.58u w=4.4u l=0.6u
X6169 user_project_wrapper_0.analog_io[15] a_237844_29676# user_project_wrapper_0.IOVSS1 user_project_wrapper_0.IOVSS1 sg13_hv_nmos ad=2.596p pd=5.58u as=1.408p ps=5.04u w=4.4u l=0.6u
X6170 user_project_wrapper_0.VDD2 user_project_wrapper_0.sg13g2_IOPadVdd_1.sg13g2_RCClampInverter_noptap_0.out user_project_wrapper_0.IOVSS1 user_project_wrapper_0.IOVSS1 sg13_hv_nmos ad=2.596p pd=5.58u as=2.068p ps=9.74u w=4.4u l=0.6u
X6171 VDD3 a_311108_179669# analog_io[20] user_project_wrapper_0.IOVSS1 sg13_lv_nmos ad=3.4p pd=20.68u as=3.4p ps=20.68u w=10u l=0.15u
X6172 a_300085_39542# a_300415_35456# user_project_wrapper_0.IOVSS1 rppd l=20u w=1u
X6173 a_296731_208493# a_296625_208423# VDD3 VDD3 sg13_lv_pmos ad=0.2603p pd=1.75u as=0.2603p ps=1.75u w=1.37u l=0.35u
X6174 user_project_wrapper_0.IOVDD2 a_217444_41476# user_project_wrapper_0.analog_io[14] user_project_wrapper_0.IOVDD2 sg13_hv_pmos ad=2.1312p pd=7.3u as=3.9294p ps=7.84u w=6.66u l=0.6u
X6175 user_project_wrapper_0.VDD2 user_project_wrapper_0.sg13g2_IOPadVdd_1.sg13g2_RCClampResistor_0.p2 user_project_wrapper_0.sg13g2_IOPadVdd_1.sg13g2_RCClampInverter_noptap_0.out user_project_wrapper_0.VDD2 sg13_hv_pmos ad=1.33p pd=7.38u as=1.33p ps=7.38u w=7u l=0.5u
X6176 a_309917_199879# user_project_wrapper_0.sg13g2_IOPadAnalog_29.padres a_311846_195517# VDD3 sg13_lv_pmos ad=0.24415p pd=1.665u as=0.24415p ps=1.665u w=1.285u l=0.35u
X6177 user_project_wrapper_0.IOVSS1 user_project_wrapper_0.sg13g2_IOPadVdd_2.sg13g2_RCClampInverter_noptap_0.out user_project_wrapper_0.VDD1 user_project_wrapper_0.IOVSS1 sg13_hv_nmos ad=1.408p pd=5.04u as=2.596p ps=5.58u w=4.4u l=0.6u
X6178 a_309917_194695# user_project_wrapper_0.sg13g2_IOPadAnalog_29.padres a_311846_195517# VDD3 sg13_lv_pmos ad=0.24415p pd=1.665u as=0.24415p ps=1.665u w=1.285u l=0.35u
X6179 IOVDD3 a_355624_115444# analog_io[18] IOVDD3 sg13_hv_pmos ad=2.1312p pd=7.3u as=3.9294p ps=7.84u w=6.66u l=0.6u
X6180 a_57810_282219# a_58798_281951# user_project_wrapper_0.IOVSS1 user_project_wrapper_0.IOVSS1 sg13_hv_nmos ad=0.646p pd=4.48u as=0.361p ps=2.28u w=1.9u l=0.45u
X6181 user_project_wrapper_0.IOVSS1 user_project_wrapper_0.analog_io[27] dantenna l=1.26u w=27.78u
X6182 user_project_wrapper_0.analog_io[11] a_156244_41476# user_project_wrapper_0.IOVDD2 user_project_wrapper_0.IOVDD2 sg13_hv_pmos ad=3.9294p pd=7.84u as=2.1312p ps=7.3u w=6.66u l=0.6u
X6183 user_project_wrapper_0.IOVDD1 user_project_wrapper_0.sg13g2_IOPadIOVdd_1.sg13g2_RCClampResistor_0.p2 user_project_wrapper_0.sg13g2_IOPadIOVdd_1.sg13g2_Clamp_N43N43D4R_0.gate user_project_wrapper_0.IOVDD1 sg13_hv_pmos ad=1.33p pd=7.38u as=1.33p ps=7.38u w=7u l=0.5u
X6184 user_project_wrapper_0.IOVDD4 user_project_wrapper_0.sg13g2_IOPadIOVdd_2.sg13g2_Clamp_N43N43D4R_0.gate user_project_wrapper_0.IOVSS1 user_project_wrapper_0.IOVSS1 sg13_hv_nmos ad=2.596p pd=5.58u as=1.408p ps=5.04u w=4.4u l=0.6u
X6185 a_190389_101343# a_189729_101343# QDLL_TOP_0.VDD QDLL_TOP_0.VDD sg13_lv_pmos ad=0.2184p pd=1.51u as=0.2128p ps=1.5u w=1.12u l=0.13u
X6186 user_project_wrapper_0.IOVSS1 a_208017_327918# a_208469_330241# w_207883_330166# sg13_lv_pmos ad=0.68p pd=4.68u as=0.38p ps=2.38u w=2u l=0.13u
X6187 user_project_wrapper_0.analog_io[27] a_182931_326125# user_project_wrapper_0.IOVSS1 user_project_wrapper_0.IOVSS1 sg13_lv_nmos ad=0.912p pd=5.18u as=0.912p ps=5.18u w=4.8u l=0.13u
X6188 IOVDD3 user_project_wrapper_0.sg13g2_IOPadIOVdd_3.sg13g2_Clamp_N43N43D4R_0.gate user_project_wrapper_0.IOVSS1 user_project_wrapper_0.IOVSS1 sg13_hv_nmos ad=2.596p pd=5.58u as=2.068p ps=9.74u w=4.4u l=0.6u
X6189 user_project_wrapper_0.analog_io[34] a_258244_355624# user_project_wrapper_0.IOVDD4 user_project_wrapper_0.IOVDD4 sg13_hv_pmos ad=3.9294p pd=7.84u as=3.1302p ps=14.26u w=6.66u l=0.6u
X6190 IOVDD3 a_355624_237844# analog_io[23] IOVDD3 sg13_hv_pmos ad=2.1312p pd=7.3u as=3.9294p ps=7.84u w=6.66u l=0.6u
X6191 a_304995_198817# a_304889_198885# a_304196_197873# user_project_wrapper_0.IOVSS1 sg13_lv_nmos ad=0.209p pd=1.48u as=0.209p ps=1.48u w=1.1u l=0.15u
X6192 a_114505_39542# a_114835_35456# user_project_wrapper_0.IOVSS1 rppd l=20u w=1u
X6193 user_project_wrapper_0.analog_io[13] a_197044_29676# user_project_wrapper_0.IOVSS1 user_project_wrapper_0.IOVSS1 sg13_hv_nmos ad=2.596p pd=5.58u as=1.408p ps=5.04u w=4.4u l=0.6u
X6194 user_project_wrapper_0.IOVDD4 user_project_wrapper_0.sg13g2_IOPadIOVdd_2.sg13g2_Clamp_N43N43D4R_0.gate user_project_wrapper_0.IOVSS1 user_project_wrapper_0.IOVSS1 sg13_hv_nmos ad=2.596p pd=5.58u as=1.408p ps=5.04u w=4.4u l=0.6u
X6195 user_project_wrapper_0.IOVSS1 user_project_wrapper_0.sg13g2_IOPadVdd_2.sg13g2_RCClampInverter_noptap_0.out user_project_wrapper_0.VDD1 user_project_wrapper_0.IOVSS1 sg13_hv_nmos ad=1.408p pd=5.04u as=2.596p ps=5.58u w=4.4u l=0.6u
X6196 user_project_wrapper_0.IOVDD4 a_115444_355624# user_project_wrapper_0.analog_io[27] user_project_wrapper_0.IOVDD4 sg13_hv_pmos ad=2.1312p pd=7.3u as=3.9294p ps=7.84u w=6.66u l=0.6u
X6197 analog_io[20] a_355624_156244# IOVDD3 IOVDD3 sg13_hv_pmos ad=3.9294p pd=7.84u as=2.1312p ps=7.3u w=6.66u l=0.6u
X6198 a_85257_125209# a_84332_125209# a_85155_125209# user_project_wrapper_0.VDD1 sg13_lv_pmos ad=0.2128p pd=1.5u as=0.2128p ps=1.5u w=1.12u l=0.13u
X6199 user_project_wrapper_0.IOVDD4 a_237844_355624# user_project_wrapper_0.analog_io[33] user_project_wrapper_0.IOVDD4 sg13_hv_pmos ad=2.1312p pd=7.3u as=3.9294p ps=7.84u w=6.66u l=0.6u
X6200 user_project_wrapper_0.IOVSS1 user_project_wrapper_0.sg13g2_IOPadVdd_1.sg13g2_RCClampInverter_noptap_0.out user_project_wrapper_0.VDD2 user_project_wrapper_0.IOVSS1 sg13_hv_nmos ad=1.408p pd=5.04u as=2.596p ps=5.58u w=4.4u l=0.6u
X6201 user_project_wrapper_0.IOVSS1 user_project_wrapper_0.sg13g2_IOPadVdd_3.sg13g2_RCClampResistor_0.p2 user_project_wrapper_0.IOVSS1 user_project_wrapper_0.IOVSS1 sg13_hv_nmos ad=1.71p pd=9.38u as=0 ps=0 w=9u l=9.5u
X6202 user_project_wrapper_0.VDD2 user_project_wrapper_0.sg13g2_IOPadVdd_1.sg13g2_RCClampInverter_noptap_0.out user_project_wrapper_0.IOVSS1 user_project_wrapper_0.IOVSS1 sg13_hv_nmos ad=2.596p pd=5.58u as=1.408p ps=5.04u w=4.4u l=0.6u
X6203 VDD3 a_296625_189595# a_296731_189665# VDD3 sg13_lv_pmos ad=0.2603p pd=1.75u as=0.2603p ps=1.75u w=1.37u l=0.35u
X6204 IOVDD3 a_355624_197044# analog_io[22] IOVDD3 sg13_hv_pmos ad=2.1312p pd=7.3u as=3.9294p ps=7.84u w=6.66u l=0.6u
X6205 user_project_wrapper_0.analog_io[11] a_156244_41476# user_project_wrapper_0.IOVDD2 user_project_wrapper_0.IOVDD2 sg13_hv_pmos ad=3.9294p pd=7.84u as=2.1312p ps=7.3u w=6.66u l=0.6u
X6206 VDD3 a_309516_194555# a_309516_194555# VDD3 sg13_lv_pmos ad=0.19p pd=1.38u as=0.19p ps=1.38u w=1u l=0.7u
X6207 a_296625_189595# a_304090_197941# a_304196_197873# user_project_wrapper_0.IOVSS1 sg13_lv_nmos ad=0.361p pd=2.28u as=0.361p ps=2.28u w=1.9u l=0.16u
X6208 VDD3 a_296625_208423# a_296731_208493# VDD3 sg13_lv_pmos ad=0.2603p pd=1.75u as=0.2603p ps=1.75u w=1.37u l=0.35u
X6209 user_project_wrapper_0.IOVSS1 a_29676_197044# user_project_wrapper_0.analog_io[4] user_project_wrapper_0.IOVSS1 sg13_hv_nmos ad=1.408p pd=5.04u as=2.596p ps=5.58u w=4.4u l=0.6u
X6210 user_project_wrapper_0.analog_io[7] a_29676_258244# user_project_wrapper_0.IOVSS1 user_project_wrapper_0.IOVSS1 sg13_hv_nmos ad=2.596p pd=5.58u as=1.408p ps=5.04u w=4.4u l=0.6u
X6211 a_114505_39542# a_114175_35456# user_project_wrapper_0.IOVSS1 rppd l=20u w=1u
X6212 a_296625_208423# a_304090_197941# a_304196_200821# user_project_wrapper_0.IOVSS1 sg13_lv_nmos ad=0.361p pd=2.28u as=0.361p ps=2.28u w=1.9u l=0.16u
X6213 user_project_wrapper_0.IOVDD1 user_project_wrapper_0.sg13g2_IOPadIOVdd_1.sg13g2_RCClampResistor_0.p2 user_project_wrapper_0.sg13g2_IOPadIOVdd_1.sg13g2_Clamp_N43N43D4R_0.gate user_project_wrapper_0.IOVDD1 sg13_hv_pmos ad=1.33p pd=7.38u as=1.33p ps=7.38u w=7u l=0.5u
X6214 user_project_wrapper_0.IOVSS1 user_project_wrapper_0.sg13g2_IOPadVdd_0.sg13g2_RCClampInverter_noptap_0.out VDD3 user_project_wrapper_0.IOVSS1 sg13_hv_nmos ad=1.408p pd=5.04u as=2.596p ps=5.58u w=4.4u l=0.6u
X6215 analog_io[18] a_355624_115444# IOVDD3 IOVDD3 sg13_hv_pmos ad=3.9294p pd=7.84u as=2.1312p ps=7.3u w=6.66u l=0.6u
X6216 user_project_wrapper_0.analog_io[27] a_182931_326125# user_project_wrapper_0.IOVSS1 user_project_wrapper_0.IOVSS1 sg13_lv_pmos ad=1.824p pd=9.98u as=1.824p ps=9.98u w=9.6u l=0.13u
X6217 user_project_wrapper_0.analog_io[6] a_41476_237844# user_project_wrapper_0.IOVDD1 user_project_wrapper_0.IOVDD1 sg13_hv_pmos ad=3.9294p pd=7.84u as=2.1312p ps=7.3u w=6.66u l=0.6u
X6218 user_project_wrapper_0.IOVSS1 user_project_wrapper_0.sg13g2_IOPadIOVdd_2.sg13g2_Clamp_N43N43D4R_0.gate user_project_wrapper_0.IOVDD4 user_project_wrapper_0.IOVSS1 sg13_hv_nmos ad=1.408p pd=5.04u as=2.596p ps=5.58u w=4.4u l=0.6u
X6219 user_project_wrapper_0.sg13g2_IOPadVdd_1.sg13g2_RCClampInverter_noptap_0.out user_project_wrapper_0.sg13g2_IOPadVdd_1.sg13g2_RCClampResistor_0.p2 user_project_wrapper_0.VDD2 user_project_wrapper_0.VDD2 sg13_hv_pmos ad=1.33p pd=7.38u as=1.33p ps=7.38u w=7u l=0.5u
X6220 a_35456_297775# user_project_wrapper_0.IOVDD1 user_project_wrapper_0.IOVSS1 rppd l=20u w=1u
X6221 user_project_wrapper_0.IOVSS1 user_project_wrapper_0.IOVSS1 user_project_wrapper_0.IOVSS1 rppd l=0.5u w=0.5u
X6222 user_project_wrapper_0.IOVDD2 a_197044_41476# user_project_wrapper_0.analog_io[13] user_project_wrapper_0.IOVDD2 sg13_hv_pmos ad=2.1312p pd=7.3u as=3.9294p ps=7.84u w=6.66u l=0.6u
X6223 user_project_wrapper_0.IOVSS1 user_project_wrapper_0.sg13g2_IOPadVdd_1.sg13g2_RCClampInverter_noptap_0.out user_project_wrapper_0.VDD2 user_project_wrapper_0.IOVSS1 sg13_hv_nmos ad=1.408p pd=5.04u as=2.596p ps=5.58u w=4.4u l=0.6u
X6224 user_project_wrapper_0.IOVSS1 user_project_wrapper_0.sg13g2_IOPadIOVdd_0.sg13g2_Clamp_N43N43D4R_0.gate user_project_wrapper_0.IOVDD2 user_project_wrapper_0.IOVSS1 sg13_hv_nmos ad=1.408p pd=5.04u as=2.596p ps=5.58u w=4.4u l=0.6u
X6225 user_project_wrapper_0.IOVDD4 a_156244_355624# user_project_wrapper_0.analog_io[29] user_project_wrapper_0.IOVDD4 sg13_hv_pmos ad=2.1312p pd=7.3u as=3.9294p ps=7.84u w=6.66u l=0.6u
X6226 user_project_wrapper_0.IOVSS1 a_237844_369296# user_project_wrapper_0.analog_io[33] user_project_wrapper_0.IOVSS1 sg13_hv_nmos ad=2.068p pd=9.74u as=2.596p ps=5.58u w=4.4u l=0.6u
X6227 a_191901_330987# a_190868_330987# user_project_wrapper_0.IOVSS1 rhigh l=4u w=0.5u
X6228 user_project_wrapper_0.IOVSS1 user_project_wrapper_0.sg13g2_IOPadVdd_0.sg13g2_RCClampInverter_noptap_0.out VDD3 user_project_wrapper_0.IOVSS1 sg13_hv_nmos ad=1.408p pd=5.04u as=2.596p ps=5.58u w=4.4u l=0.6u
X6229 user_project_wrapper_0.IOVSS1 user_project_wrapper_0.sg13g2_IOPadIOVdd_2.sg13g2_Clamp_N43N43D4R_0.gate user_project_wrapper_0.IOVDD4 user_project_wrapper_0.IOVSS1 sg13_hv_nmos ad=1.408p pd=5.04u as=2.596p ps=5.58u w=4.4u l=0.6u
X6230 user_project_wrapper_0.IOVSS1 user_project_wrapper_0.sg13g2_IOPadVdd_1.sg13g2_RCClampInverter_noptap_0.out user_project_wrapper_0.VDD2 user_project_wrapper_0.IOVSS1 sg13_hv_nmos ad=1.408p pd=5.04u as=2.596p ps=5.58u w=4.4u l=0.6u
X6231 user_project_wrapper_0.analog_io[27] a_182931_326125# user_project_wrapper_0.IOVSS1 user_project_wrapper_0.IOVSS1 sg13_lv_pmos ad=1.824p pd=9.98u as=1.824p ps=9.98u w=9.6u l=0.13u
X6232 a_35456_77335# a_39542_77005# user_project_wrapper_0.IOVSS1 rppd l=20u w=1u
X6233 user_project_wrapper_0.VDD1 user_project_wrapper_0.sg13g2_IOPadVdd_2.sg13g2_RCClampInverter_noptap_0.out user_project_wrapper_0.IOVSS1 user_project_wrapper_0.IOVSS1 sg13_hv_nmos ad=2.596p pd=5.58u as=1.408p ps=5.04u w=4.4u l=0.6u
X6234 user_project_wrapper_0.IOVSS1 user_project_wrapper_0.sg13g2_IOPadIOVdd_3.sg13g2_RCClampResistor_0.p2 user_project_wrapper_0.IOVSS1 user_project_wrapper_0.IOVSS1 sg13_hv_nmos ad=1.71p pd=9.38u as=0 ps=0 w=9u l=9.5u
X6235 a_209041_326377# a_208939_327491# a_208939_326377# w_207887_326203# sg13_lv_pmos ad=0.38p pd=2.38u as=0.38p ps=2.38u w=2u l=0.13u
X6236 VDD3 a_296625_189595# a_296731_189665# VDD3 sg13_lv_pmos ad=0.2603p pd=1.75u as=0.2603p ps=1.75u w=1.37u l=0.35u
X6237 user_project_wrapper_0.analog_io[15] a_190389_101343# QDLL_TOP_0.VDD QDLL_TOP_0.VDD sg13_lv_pmos ad=0.2128p pd=1.5u as=0.2128p ps=1.5u w=1.12u l=0.13u
X6238 a_311108_215937# analog_io[23] a_313884_211353# user_project_wrapper_0.IOVSS1 sg13_lv_nmos ad=1.9p pd=10.38u as=1.9p ps=10.38u w=10u l=0.5u
X6239 a_189835_330987# a_188802_330987# user_project_wrapper_0.IOVSS1 rhigh l=4u w=0.5u
X6240 a_189756_325263# user_project_wrapper_0.IOVSS1 user_project_wrapper_0.IOVSS1 w_188704_326203# sg13_lv_pmos ad=0.38p pd=2.38u as=0.68p ps=4.68u w=2u l=0.13u
X6241 a_296625_189595# a_301940_196388# a_296732_197880# VDD3 sg13_lv_pmos ad=0.7695p pd=4.43u as=1.377p ps=8.78u w=4.05u l=0.5u
X6242 user_project_wrapper_0.IOVSS1 a_278644_369296# user_project_wrapper_0.analog_io[35] user_project_wrapper_0.IOVSS1 sg13_hv_nmos ad=1.408p pd=5.04u as=2.596p ps=5.58u w=4.4u l=0.6u
X6243 QDLL_TOP_0.VOUT a_271172_100118# user_project_wrapper_0.IOVSS1 user_project_wrapper_0.IOVSS1 sg13_lv_nmos ad=0.1406p pd=1.12u as=0.1406p ps=1.12u w=0.74u l=0.13u
X6244 a_296731_189665# a_296625_189595# VDD3 VDD3 sg13_lv_pmos ad=0.2603p pd=1.75u as=0.2603p ps=1.75u w=1.37u l=0.35u
X6245 user_project_wrapper_0.IOVSS1 a_369296_258244# analog_io[25] user_project_wrapper_0.IOVSS1 sg13_hv_nmos ad=2.068p pd=9.74u as=2.596p ps=5.58u w=4.4u l=0.6u
X6246 user_project_wrapper_0.IOVDD1 user_project_wrapper_0.sg13g2_IOPadIOVdd_1.sg13g2_Clamp_N43N43D4R_0.gate user_project_wrapper_0.IOVSS1 user_project_wrapper_0.IOVSS1 sg13_hv_nmos ad=2.596p pd=5.58u as=1.408p ps=5.04u w=4.4u l=0.6u
X6247 VDD3 a_309516_194555# a_309917_194695# VDD3 sg13_lv_pmos ad=0.19p pd=1.38u as=0.19p ps=1.38u w=1u l=0.7u
X6248 user_project_wrapper_0.IOVSS1 a_188988_324119# a_188920_324155# user_project_wrapper_0.IOVSS1 sg13_lv_nmos ad=0.19p pd=1.38u as=0.34p ps=2.68u w=1u l=0.13u
X6249 user_project_wrapper_0.analog_io[32] a_202114_326125# user_project_wrapper_0.IOVSS1 user_project_wrapper_0.IOVSS1 sg13_lv_pmos ad=1.824p pd=9.98u as=3.264p ps=19.88u w=9.6u l=0.13u
X6250 a_189286_327491# a_189184_328605# a_189184_327491# user_project_wrapper_0.IOVSS1 sg13_lv_nmos ad=0.19p pd=1.38u as=0.19p ps=1.38u w=1u l=0.13u
X6251 IOVDD3 a_355624_135844# analog_io[19] IOVDD3 sg13_hv_pmos ad=2.1312p pd=7.3u as=3.9294p ps=7.84u w=6.66u l=0.6u
X6252 IOVDD3 a_355624_156244# analog_io[20] IOVDD3 sg13_hv_pmos ad=2.1312p pd=7.3u as=3.9294p ps=7.84u w=6.66u l=0.6u
X6253 user_project_wrapper_0.IOVDD1 user_project_wrapper_0.sg13g2_IOPadIOVdd_1.sg13g2_RCClampResistor_0.p2 user_project_wrapper_0.sg13g2_IOPadIOVdd_1.sg13g2_Clamp_N43N43D4R_0.gate user_project_wrapper_0.IOVDD1 sg13_hv_pmos ad=1.33p pd=7.38u as=1.33p ps=7.38u w=7u l=0.5u
X6254 a_304995_198817# a_307232_196607# user_project_wrapper_0.IOVSS1 user_project_wrapper_0.IOVSS1 sg13_lv_nmos ad=1.1322p pd=7.34u as=0.6327p ps=3.71u w=3.33u l=0.2u
X6255 a_57810_282219# a_58170_281951# user_project_wrapper_0.IOVDD1 user_project_wrapper_0.IOVDD1 sg13_hv_pmos ad=0.102p pd=1.28u as=57f ps=0.68u w=0.3u l=0.45u
X6256 user_project_wrapper_0.IOVSS1 user_project_wrapper_0.sg13g2_IOPadVdd_2.sg13g2_RCClampInverter_noptap_0.out user_project_wrapper_0.VDD1 user_project_wrapper_0.IOVSS1 sg13_hv_nmos ad=1.408p pd=5.04u as=2.596p ps=5.58u w=4.4u l=0.6u
X6257 VDD3 a_296625_208423# a_296731_208493# VDD3 sg13_lv_pmos ad=0.2603p pd=1.75u as=0.2603p ps=1.75u w=1.37u l=0.35u
X6258 user_project_wrapper_0.IOVSS1 user_project_wrapper_0.IOVSS1 user_project_wrapper_0.IOVSS1 rppd l=0.5u w=0.5u
X6259 user_project_wrapper_0.IOVSS1 a_213870_324142# user_project_wrapper_0.analog_io[35] user_project_wrapper_0.IOVSS1 sg13_lv_pmos ad=1.824p pd=9.98u as=1.824p ps=9.98u w=9.6u l=0.13u
X6260 user_project_wrapper_0.IOVSS1 user_project_wrapper_0.sg13g2_IOPadIOVdd_3.sg13g2_RCClampResistor_0.p2 user_project_wrapper_0.IOVSS1 user_project_wrapper_0.IOVSS1 sg13_hv_nmos ad=1.71p pd=9.38u as=0 ps=0 w=9u l=9.5u
X6261 user_project_wrapper_0.analog_io[32] a_202114_326125# user_project_wrapper_0.IOVSS1 user_project_wrapper_0.IOVSS1 sg13_lv_pmos ad=1.824p pd=9.98u as=1.824p ps=9.98u w=9.6u l=0.13u
X6262 a_190722_326377# a_189756_326377# user_project_wrapper_0.IOVSS1 w_188704_326203# sg13_lv_pmos ad=0.38p pd=2.38u as=0.68p ps=4.68u w=2u l=0.13u
X6263 user_project_wrapper_0.IOVDD4 user_project_wrapper_0.sg13g2_IOPadIOVdd_2.sg13g2_Clamp_N43N43D4R_0.gate user_project_wrapper_0.IOVSS1 user_project_wrapper_0.IOVSS1 sg13_hv_nmos ad=2.596p pd=5.58u as=1.408p ps=5.04u w=4.4u l=0.6u
X6264 user_project_wrapper_0.analog_io[27] a_182931_326125# user_project_wrapper_0.IOVSS1 user_project_wrapper_0.IOVSS1 sg13_lv_pmos ad=1.824p pd=9.98u as=1.824p ps=9.98u w=9.6u l=0.13u
X6265 user_project_wrapper_0.IOVSS1 a_194279_327536# a_194687_324142# user_project_wrapper_0.IOVSS1 sg13_lv_nmos ad=0.912p pd=5.18u as=0.912p ps=5.18u w=4.8u l=0.13u
X6266 user_project_wrapper_0.IOVDD2 a_278644_41476# QDLL_TOP_0.VOUT user_project_wrapper_0.IOVDD2 sg13_hv_pmos ad=2.1312p pd=7.3u as=3.9294p ps=7.84u w=6.66u l=0.6u
X6267 user_project_wrapper_0.ui_PAD[2] user_project_wrapper_0.IOVDD1 dpantenna l=1.26u w=27.78u
X6268 IOVDD3 a_355624_115444# analog_io[18] IOVDD3 sg13_hv_pmos ad=2.1312p pd=7.3u as=3.9294p ps=7.84u w=6.66u l=0.6u
X6269 a_296731_189665# a_296625_189595# VDD3 VDD3 sg13_lv_pmos ad=0.2603p pd=1.75u as=0.2603p ps=1.75u w=1.37u l=0.35u
X6270 user_project_wrapper_0.IOVSS1 a_194279_327536# a_194687_324142# user_project_wrapper_0.IOVSS1 sg13_lv_nmos ad=0.912p pd=5.18u as=0.912p ps=5.18u w=4.8u l=0.13u
X6271 user_project_wrapper_0.analog_io[11] a_156244_41476# user_project_wrapper_0.IOVDD2 user_project_wrapper_0.IOVDD2 sg13_hv_pmos ad=3.9294p pd=7.84u as=2.1312p ps=7.3u w=6.66u l=0.6u
X6272 a_296731_208493# a_296625_208423# VDD3 VDD3 sg13_lv_pmos ad=0.2603p pd=1.75u as=0.2603p ps=1.75u w=1.37u l=0.35u
X6273 a_307232_196607# a_296731_208493# a_309917_199879# VDD3 sg13_lv_pmos ad=0.24415p pd=1.665u as=0.24415p ps=1.665u w=1.285u l=0.35u
X6274 analog_io[23] a_311108_215937# VDD3 user_project_wrapper_0.IOVSS1 sg13_lv_nmos ad=3.4p pd=20.68u as=3.4p ps=20.68u w=10u l=0.15u
X6275 IOVDD3 user_project_wrapper_0.sg13g2_IOPadIOVdd_3.sg13g2_Clamp_N43N43D4R_0.gate user_project_wrapper_0.IOVSS1 user_project_wrapper_0.IOVSS1 sg13_hv_nmos ad=2.596p pd=5.58u as=1.408p ps=5.04u w=4.4u l=0.6u
X6276 a_182931_326125# a_186202_326221# user_project_wrapper_0.IOVSS1 user_project_wrapper_0.IOVSS1 sg13_lv_pmos ad=1.824p pd=9.98u as=1.824p ps=9.98u w=9.6u l=0.13u
X6277 user_project_wrapper_0.IOVSS1 user_project_wrapper_0.IOVSS1 user_project_wrapper_0.IOVSS1 rppd l=0.5u w=0.5u
X6278 a_186430_98275# a_185968_98275# QDLL_TOP_0.VDD QDLL_TOP_0.VDD sg13_lv_pmos ad=0.7616p pd=5.16u as=0.7616p ps=5.16u w=2.24u l=0.13u
X6279 a_296731_208493# a_301186_192011# user_project_wrapper_0.IOVSS1 user_project_wrapper_0.IOVSS1 sg13_lv_nmos ad=0.912p pd=5.18u as=0.912p ps=5.18u w=4.8u l=1.06u
X6280 analog_io[19] a_369296_135844# user_project_wrapper_0.IOVSS1 user_project_wrapper_0.IOVSS1 sg13_hv_nmos ad=2.596p pd=5.58u as=1.408p ps=5.04u w=4.4u l=0.6u
X6281 user_project_wrapper_0.analog_io[28] a_135844_355624# user_project_wrapper_0.IOVDD4 user_project_wrapper_0.IOVDD4 sg13_hv_pmos ad=3.9294p pd=7.84u as=2.1312p ps=7.3u w=6.66u l=0.6u
X6282 user_project_wrapper_0.IOVSS1 a_202114_326125# user_project_wrapper_0.analog_io[32] user_project_wrapper_0.IOVSS1 sg13_lv_nmos ad=0.912p pd=5.18u as=0.912p ps=5.18u w=4.8u l=0.13u
X6283 user_project_wrapper_0.IOVSS1 user_project_wrapper_0.sg13g2_IOPadVdd_2.sg13g2_RCClampInverter_noptap_0.out user_project_wrapper_0.VDD1 user_project_wrapper_0.IOVSS1 sg13_hv_nmos ad=1.408p pd=5.04u as=2.596p ps=5.58u w=4.4u l=0.6u
X6284 a_307232_196607# a_296731_189665# a_309917_194695# VDD3 sg13_lv_pmos ad=0.24415p pd=1.665u as=0.24415p ps=1.665u w=1.285u l=0.35u
X6285 a_296732_200582# a_296626_197740# VDD3 VDD3 sg13_lv_pmos ad=1.33p pd=7.38u as=1.33p ps=7.38u w=7u l=0.7u
X6286 user_project_wrapper_0.IOVSS1 user_project_wrapper_0.sg13g2_IOPadIOVdd_1.sg13g2_RCClampResistor_0.p2 user_project_wrapper_0.IOVSS1 user_project_wrapper_0.IOVSS1 sg13_hv_nmos ad=1.71p pd=9.38u as=0 ps=0 w=9u l=9.5u
X6287 user_project_wrapper_0.IOVSS1 user_project_wrapper_0.sg13g2_IOPadVdd_1.sg13g2_RCClampInverter_noptap_0.out user_project_wrapper_0.VDD2 user_project_wrapper_0.IOVSS1 sg13_hv_nmos ad=1.408p pd=5.04u as=2.596p ps=5.58u w=4.4u l=0.6u
X6288 VDD3 a_309516_194555# a_309917_199879# VDD3 sg13_lv_pmos ad=0.19p pd=1.38u as=0.19p ps=1.38u w=1u l=0.7u
X6289 user_project_wrapper_0.IOVSS1 a_217444_29676# user_project_wrapper_0.analog_io[14] user_project_wrapper_0.IOVSS1 sg13_hv_nmos ad=1.408p pd=5.04u as=2.596p ps=5.58u w=4.4u l=0.6u
X6290 user_project_wrapper_0.IOVDD4 a_278644_355624# user_project_wrapper_0.analog_io[35] user_project_wrapper_0.IOVDD4 sg13_hv_pmos ad=2.1312p pd=7.3u as=3.9294p ps=7.84u w=6.66u l=0.6u
X6291 user_project_wrapper_0.IOVDD4 a_115444_355624# user_project_wrapper_0.analog_io[27] user_project_wrapper_0.IOVDD4 sg13_hv_pmos ad=2.1312p pd=7.3u as=3.9294p ps=7.84u w=6.66u l=0.6u
X6292 user_project_wrapper_0.analog_io[12] a_176644_41476# user_project_wrapper_0.IOVDD2 user_project_wrapper_0.IOVDD2 sg13_hv_pmos ad=3.9294p pd=7.84u as=2.1312p ps=7.3u w=6.66u l=0.6u
X6293 a_296731_208493# a_296625_208423# VDD3 VDD3 sg13_lv_pmos ad=0.2603p pd=1.75u as=0.2603p ps=1.75u w=1.37u l=0.35u
X6294 user_project_wrapper_0.analog_io[32] a_202114_326125# user_project_wrapper_0.IOVSS1 user_project_wrapper_0.IOVSS1 sg13_lv_pmos ad=1.824p pd=9.98u as=1.824p ps=9.98u w=9.6u l=0.13u
X6295 a_309917_199879# a_309516_194555# VDD3 VDD3 sg13_lv_pmos ad=0.19p pd=1.38u as=0.19p ps=1.38u w=1u l=0.7u
X6296 user_project_wrapper_0.analog_io[4] a_41476_197044# user_project_wrapper_0.IOVDD1 user_project_wrapper_0.IOVDD1 sg13_hv_pmos ad=3.9294p pd=7.84u as=2.1312p ps=7.3u w=6.66u l=0.6u
X6297 IOVDD3 user_project_wrapper_0.sg13g2_IOPadIOVdd_3.sg13g2_Clamp_N43N43D4R_0.gate user_project_wrapper_0.IOVSS1 user_project_wrapper_0.IOVSS1 sg13_hv_nmos ad=2.596p pd=5.58u as=1.408p ps=5.04u w=4.4u l=0.6u
X6298 a_309516_194555# a_309516_194555# VDD3 VDD3 sg13_lv_pmos ad=0.19p pd=1.38u as=0.19p ps=1.38u w=1u l=0.7u
X6299 user_project_wrapper_0.sg13g2_IOPadVdd_2.sg13g2_RCClampInverter_noptap_0.out user_project_wrapper_0.sg13g2_IOPadVdd_2.sg13g2_RCClampResistor_0.p2 user_project_wrapper_0.VDD1 user_project_wrapper_0.VDD1 sg13_hv_pmos ad=1.33p pd=7.38u as=1.33p ps=7.38u w=7u l=0.5u
X6300 user_project_wrapper_0.sg13g2_IOPadVdd_1.sg13g2_RCClampInverter_noptap_0.out user_project_wrapper_0.sg13g2_IOPadVdd_1.sg13g2_RCClampResistor_0.p2 user_project_wrapper_0.IOVSS1 user_project_wrapper_0.IOVSS1 sg13_hv_nmos ad=1.71p pd=9.38u as=3.06p ps=18.68u w=9u l=0.5u
X6301 a_189190_110495# a_188632_108410# user_project_wrapper_0.IOVSS1 rppd l=10u w=1u
X6302 a_307232_196607# a_307232_196607# user_project_wrapper_0.IOVSS1 user_project_wrapper_0.IOVSS1 sg13_lv_nmos ad=0.6327p pd=3.71u as=0.6327p ps=3.71u w=3.33u l=0.2u
X6303 user_project_wrapper_0.IOVDD2 a_135844_41476# user_project_wrapper_0.analog_io[10] user_project_wrapper_0.IOVDD2 sg13_hv_pmos ad=3.1302p pd=14.26u as=3.9294p ps=7.84u w=6.66u l=0.6u
X6304 user_project_wrapper_0.IOVDD4 user_project_wrapper_0.sg13g2_IOPadIOVdd_2.sg13g2_RCClampResistor_0.p2 user_project_wrapper_0.sg13g2_IOPadIOVdd_2.sg13g2_Clamp_N43N43D4R_0.gate user_project_wrapper_0.IOVDD4 sg13_hv_pmos ad=1.33p pd=7.38u as=1.33p ps=7.38u w=7u l=0.5u
X6305 user_project_wrapper_0.IOVDD1 user_project_wrapper_0.sg13g2_IOPadIOVdd_1.sg13g2_Clamp_N43N43D4R_0.gate user_project_wrapper_0.IOVSS1 user_project_wrapper_0.IOVSS1 sg13_hv_nmos ad=2.596p pd=5.58u as=1.408p ps=5.04u w=4.4u l=0.6u
X6306 user_project_wrapper_0.IOVSS1 a_194687_324142# user_project_wrapper_0.analog_io[30] user_project_wrapper_0.IOVSS1 sg13_lv_nmos ad=0.912p pd=5.18u as=0.912p ps=5.18u w=4.8u l=0.13u
X6307 user_project_wrapper_0.IOVSS1 user_project_wrapper_0.sg13g2_IOPadIOVdd_1.sg13g2_RCClampResistor_0.p2 user_project_wrapper_0.IOVSS1 user_project_wrapper_0.IOVSS1 sg13_hv_nmos ad=1.71p pd=9.38u as=0 ps=0 w=9u l=9.5u
X6308 a_208939_326377# user_project_wrapper_0.IOVSS1 user_project_wrapper_0.IOVSS1 user_project_wrapper_0.IOVSS1 sg13_lv_nmos ad=0.19p pd=1.38u as=0.34p ps=2.68u w=1u l=0.13u
X6309 user_project_wrapper_0.IOVSS1 user_project_wrapper_0.IOVSS1 user_project_wrapper_0.IOVSS1 rhigh l=4u w=0.5u
X6310 user_project_wrapper_0.IOVSS1 a_194687_324142# user_project_wrapper_0.analog_io[30] user_project_wrapper_0.IOVSS1 sg13_lv_nmos ad=0.912p pd=5.18u as=0.912p ps=5.18u w=4.8u l=0.13u
X6311 user_project_wrapper_0.IOVSS1 a_190389_101343# user_project_wrapper_0.analog_io[15] user_project_wrapper_0.IOVSS1 sg13_lv_nmos ad=0.1406p pd=1.12u as=0.1406p ps=1.12u w=0.74u l=0.13u
X6312 a_296731_189665# a_296625_189595# VDD3 VDD3 sg13_lv_pmos ad=0.2603p pd=1.75u as=0.4658p ps=3.42u w=1.37u l=0.35u
X6313 user_project_wrapper_0.sg13g2_IOPadVdd_2.sg13g2_RCClampInverter_noptap_0.out user_project_wrapper_0.sg13g2_IOPadVdd_2.sg13g2_RCClampResistor_0.p2 user_project_wrapper_0.VDD1 user_project_wrapper_0.VDD1 sg13_hv_pmos ad=1.33p pd=7.38u as=1.33p ps=7.38u w=7u l=0.5u
X6314 user_project_wrapper_0.IOVSS1 a_176644_29676# user_project_wrapper_0.analog_io[12] user_project_wrapper_0.IOVSS1 sg13_hv_nmos ad=1.408p pd=5.04u as=2.596p ps=5.58u w=4.4u l=0.6u
X6315 VDD3 a_309516_194555# a_309917_199879# VDD3 sg13_lv_pmos ad=0.19p pd=1.38u as=0.19p ps=1.38u w=1u l=0.7u
X6316 user_project_wrapper_0.sg13g2_IOPadIOVdd_0.sg13g2_Clamp_N43N43D4R_0.gate user_project_wrapper_0.sg13g2_IOPadIOVdd_0.sg13g2_RCClampResistor_0.p2 user_project_wrapper_0.IOVDD2 user_project_wrapper_0.IOVDD2 sg13_hv_pmos ad=1.33p pd=7.38u as=1.33p ps=7.38u w=7u l=0.5u
X6317 a_296731_189665# a_296625_189595# VDD3 VDD3 sg13_lv_pmos ad=0.2603p pd=1.75u as=0.2603p ps=1.75u w=1.37u l=0.35u
X6318 a_189184_325263# user_project_wrapper_0.IOVSS1 user_project_wrapper_0.IOVSS1 w_188704_326203# sg13_lv_pmos ad=0.38p pd=2.38u as=0.68p ps=4.68u w=2u l=0.13u
X6319 user_project_wrapper_0.IOVSS1 a_205385_326221# a_202114_326125# user_project_wrapper_0.IOVSS1 sg13_lv_nmos ad=0.912p pd=5.18u as=0.912p ps=5.18u w=4.8u l=0.13u
X6320 user_project_wrapper_0.IOVSS1 user_project_wrapper_0.sg13g2_IOPadVdd_0.sg13g2_RCClampInverter_noptap_0.out VDD3 user_project_wrapper_0.IOVSS1 sg13_hv_nmos ad=1.408p pd=5.04u as=2.596p ps=5.58u w=4.4u l=0.6u
X6321 user_project_wrapper_0.IOVDD1 user_project_wrapper_0.sg13g2_IOPadIOVdd_1.sg13g2_RCClampResistor_0.p2 user_project_wrapper_0.sg13g2_IOPadIOVdd_1.sg13g2_Clamp_N43N43D4R_0.gate user_project_wrapper_0.IOVDD1 sg13_hv_pmos ad=1.33p pd=7.38u as=1.33p ps=7.38u w=7u l=0.5u
X6322 user_project_wrapper_0.analog_io[27] a_115444_355624# user_project_wrapper_0.IOVDD4 user_project_wrapper_0.IOVDD4 sg13_hv_pmos ad=3.9294p pd=7.84u as=3.1302p ps=14.26u w=6.66u l=0.6u
X6323 a_77335_364458# a_77665_360372# user_project_wrapper_0.IOVSS1 rppd l=20u w=1u
X6324 QDLL_TOP_0.VOUT a_271172_100118# QDLL_TOP_0.VDD QDLL_TOP_0.VDD sg13_lv_pmos ad=0.2128p pd=1.5u as=0.2128p ps=1.5u w=1.12u l=0.13u
X6325 user_project_wrapper_0.analog_io[16] a_258244_41476# user_project_wrapper_0.IOVDD2 user_project_wrapper_0.IOVDD2 sg13_hv_pmos ad=3.9294p pd=7.84u as=2.1312p ps=7.3u w=6.66u l=0.6u
X6326 a_309917_199879# a_309516_194555# VDD3 VDD3 sg13_lv_pmos ad=0.19p pd=1.38u as=0.19p ps=1.38u w=1u l=0.7u
X6327 user_project_wrapper_0.IOVSS1 a_115444_369296# user_project_wrapper_0.IOVSS1 rppd l=3.54u w=0.5u
X6328 user_project_wrapper_0.IOVSS1 user_project_wrapper_0.analog_io[16] dantenna l=1.26u w=27.78u
X6329 VDD3 a_296625_189595# a_296731_189665# VDD3 sg13_lv_pmos ad=0.2603p pd=1.75u as=0.2603p ps=1.75u w=1.37u l=0.35u
X6330 user_project_wrapper_0.analog_io[6] a_29676_237844# user_project_wrapper_0.IOVSS1 user_project_wrapper_0.IOVSS1 sg13_hv_nmos ad=2.596p pd=5.58u as=2.068p ps=9.74u w=4.4u l=0.6u
X6331 user_project_wrapper_0.IOVSS1 user_project_wrapper_0.sg13g2_IOPadVdd_0.sg13g2_RCClampResistor_0.p2 user_project_wrapper_0.IOVSS1 user_project_wrapper_0.IOVSS1 sg13_hv_nmos ad=1.71p pd=9.38u as=0 ps=0 w=9u l=9.5u
X6332 user_project_wrapper_0.IOVSS1 a_217444_29676# user_project_wrapper_0.analog_io[14] user_project_wrapper_0.IOVSS1 sg13_hv_nmos ad=1.408p pd=5.04u as=2.596p ps=5.58u w=4.4u l=0.6u
X6333 a_304995_198817# a_307232_196607# user_project_wrapper_0.IOVSS1 user_project_wrapper_0.IOVSS1 sg13_lv_nmos ad=0.6327p pd=3.71u as=0.6327p ps=3.71u w=3.33u l=0.2u
X6334 user_project_wrapper_0.IOVSS1 user_project_wrapper_0.sg13g2_IOPadVdd_0.sg13g2_RCClampInverter_noptap_0.out VDD3 user_project_wrapper_0.IOVSS1 sg13_hv_nmos ad=1.408p pd=5.04u as=2.596p ps=5.58u w=4.4u l=0.6u
X6335 a_190389_101343# a_189729_101343# QDLL_TOP_0.VDD QDLL_TOP_0.VDD sg13_lv_pmos ad=0.2128p pd=1.5u as=0.2128p ps=1.5u w=1.12u l=0.13u
X6336 user_project_wrapper_0.analog_io[5] a_41476_217444# user_project_wrapper_0.IOVDD1 user_project_wrapper_0.IOVDD1 sg13_hv_pmos ad=3.9294p pd=7.84u as=2.1312p ps=7.3u w=6.66u l=0.6u
X6337 a_209018_330987# a_209904_331163# user_project_wrapper_0.IOVSS1 rhigh l=4u w=0.5u
X6338 a_208367_329719# user_project_wrapper_0.IOVSS1 user_project_wrapper_0.IOVSS1 w_207883_330166# sg13_lv_pmos ad=0.38p pd=2.38u as=0.68p ps=4.68u w=2u l=0.13u
X6339 user_project_wrapper_0.analog_io[12] a_176644_41476# user_project_wrapper_0.IOVDD2 user_project_wrapper_0.IOVDD2 sg13_hv_pmos ad=3.9294p pd=7.84u as=2.1312p ps=7.3u w=6.66u l=0.6u
X6340 user_project_wrapper_0.IOVSS1 user_project_wrapper_0.sg13g2_IOPadIOVdd_1.sg13g2_Clamp_N43N43D4R_0.gate user_project_wrapper_0.IOVDD1 user_project_wrapper_0.IOVSS1 sg13_hv_nmos ad=1.408p pd=5.04u as=2.596p ps=5.58u w=4.4u l=0.6u
X6341 a_82645_240231# a_82645_240231# user_project_wrapper_0.VDD1 user_project_wrapper_0.VDD1 sg13_lv_pmos ad=0.95p pd=5.38u as=1.7p ps=10.68u w=5u l=0.15u
X6342 a_296625_189595# a_301940_196388# a_296732_197880# VDD3 sg13_lv_pmos ad=0.7695p pd=4.43u as=0.7695p ps=4.43u w=4.05u l=0.5u
X6343 user_project_wrapper_0.IOVSS1 user_project_wrapper_0.IOVSS1 user_project_wrapper_0.IOVSS1 rppd l=0.5u w=0.5u
X6344 user_project_wrapper_0.IOVDD2 a_278644_41476# QDLL_TOP_0.VOUT user_project_wrapper_0.IOVDD2 sg13_hv_pmos ad=2.1312p pd=7.3u as=3.9294p ps=7.84u w=6.66u l=0.6u
X6345 VDD3 a_296625_208423# a_296731_208493# VDD3 sg13_lv_pmos ad=0.4658p pd=3.42u as=0.2603p ps=1.75u w=1.37u l=0.35u
X6346 analog_io[26] a_369296_278644# user_project_wrapper_0.IOVSS1 user_project_wrapper_0.IOVSS1 sg13_hv_nmos ad=2.596p pd=5.58u as=1.408p ps=5.04u w=4.4u l=0.6u
X6347 user_project_wrapper_0.IOVSS1 user_project_wrapper_0.sg13g2_IOPadVdd_2.sg13g2_RCClampInverter_noptap_0.out user_project_wrapper_0.VDD1 user_project_wrapper_0.IOVSS1 sg13_hv_nmos ad=1.408p pd=5.04u as=2.596p ps=5.58u w=4.4u l=0.6u
X6348 a_189858_328013# a_189756_328605# a_189756_327491# w_188704_327938# sg13_lv_pmos ad=0.38p pd=2.38u as=0.38p ps=2.38u w=2u l=0.13u
X6349 user_project_wrapper_0.IOVSS1 a_210645_324119# a_210307_324119# w_207989_323975# sg13_lv_pmos ad=0.68p pd=4.68u as=0.68p ps=4.68u w=2u l=0.65u
X6350 user_project_wrapper_0.sg13g2_IOPadVdd_2.sg13g2_RCClampInverter_noptap_0.out user_project_wrapper_0.sg13g2_IOPadVdd_2.sg13g2_RCClampResistor_0.p2 user_project_wrapper_0.VDD1 user_project_wrapper_0.VDD1 sg13_hv_pmos ad=1.33p pd=7.38u as=1.33p ps=7.38u w=7u l=0.5u
X6351 a_210621_325263# TOP_ROILIFNEURON_0.MEM user_project_wrapper_0.IOVSS1 rppd l=0.5u w=0.5u
X6352 VDD3 a_296625_189595# a_296731_189665# VDD3 sg13_lv_pmos ad=0.2603p pd=1.75u as=0.2603p ps=1.75u w=1.37u l=0.35u
X6353 a_296731_208493# a_301186_192011# user_project_wrapper_0.IOVSS1 user_project_wrapper_0.IOVSS1 sg13_lv_nmos ad=0.912p pd=5.18u as=0.912p ps=5.18u w=4.8u l=1.06u
X6354 user_project_wrapper_0.IOVSS1 IOVDD3 dpantenna l=1.26u w=27.78u
X6355 user_project_wrapper_0.sg13g2_IOPadVdd_0.sg13g2_RCClampInverter_noptap_0.out user_project_wrapper_0.sg13g2_IOPadVdd_0.sg13g2_RCClampResistor_0.p2 VDD3 VDD3 sg13_hv_pmos ad=1.33p pd=7.38u as=1.33p ps=7.38u w=7u l=0.5u
X6356 user_project_wrapper_0.IOVSS1 a_182931_326125# user_project_wrapper_0.analog_io[27] user_project_wrapper_0.IOVSS1 sg13_lv_nmos ad=0.912p pd=5.18u as=0.912p ps=5.18u w=4.8u l=0.13u
X6357 VDD3 user_project_wrapper_0.sg13g2_IOPadVdd_0.sg13g2_RCClampInverter_noptap_0.out user_project_wrapper_0.IOVSS1 user_project_wrapper_0.IOVSS1 sg13_hv_nmos ad=2.596p pd=5.58u as=1.408p ps=5.04u w=4.4u l=0.6u
X6358 user_project_wrapper_0.IOVSS1 user_project_wrapper_0.sg13g2_IOPadVdd_3.sg13g2_RCClampInverter_noptap_0.out user_project_wrapper_0.IOVSS1 user_project_wrapper_0.IOVSS1 sg13_hv_nmos ad=1.408p pd=5.04u as=0 ps=0 w=4.4u l=0.6u
X6359 analog_io[20] a_355624_156244# IOVDD3 IOVDD3 sg13_hv_pmos ad=3.9294p pd=7.84u as=2.1312p ps=7.3u w=6.66u l=0.6u
X6360 user_project_wrapper_0.IOVSS1 user_project_wrapper_0.IOVSS1 user_project_wrapper_0.IOVSS1 rppd l=0.5u w=0.5u
X6361 user_project_wrapper_0.VDD2 user_project_wrapper_0.sg13g2_IOPadVdd_1.sg13g2_RCClampResistor_0.p2 user_project_wrapper_0.sg13g2_IOPadVdd_1.sg13g2_RCClampInverter_noptap_0.out user_project_wrapper_0.VDD2 sg13_hv_pmos ad=1.33p pd=7.38u as=1.33p ps=7.38u w=7u l=0.5u
X6362 user_project_wrapper_0.analog_io[11] a_156244_29676# user_project_wrapper_0.IOVSS1 user_project_wrapper_0.IOVSS1 sg13_hv_nmos ad=2.596p pd=5.58u as=1.408p ps=5.04u w=4.4u l=0.6u
X6363 user_project_wrapper_0.IOVSS1 user_project_wrapper_0.sg13g2_IOPadIOVdd_2.sg13g2_Clamp_N43N43D4R_0.gate user_project_wrapper_0.IOVDD4 user_project_wrapper_0.IOVSS1 sg13_hv_nmos ad=1.408p pd=5.04u as=2.596p ps=5.58u w=4.4u l=0.6u
X6364 user_project_wrapper_0.IOVDD1 user_project_wrapper_0.sg13g2_IOPadIOVdd_1.sg13g2_Clamp_N43N43D4R_0.gate user_project_wrapper_0.IOVSS1 user_project_wrapper_0.IOVSS1 sg13_hv_nmos ad=2.596p pd=5.58u as=1.408p ps=5.04u w=4.4u l=0.6u
X6365 VDD3 a_296625_208423# a_296731_208493# VDD3 sg13_lv_pmos ad=0.4658p pd=3.42u as=0.2603p ps=1.75u w=1.37u l=0.35u
X6366 user_project_wrapper_0.IOVSS1 user_project_wrapper_0.sg13g2_IOPadIOVdd_2.sg13g2_Clamp_N43N43D4R_0.gate user_project_wrapper_0.IOVDD4 user_project_wrapper_0.IOVSS1 sg13_hv_nmos ad=1.408p pd=5.04u as=2.596p ps=5.58u w=4.4u l=0.6u
X6367 a_186202_326221# a_187018_328627# user_project_wrapper_0.IOVSS1 user_project_wrapper_0.IOVSS1 sg13_lv_nmos ad=0.912p pd=5.18u as=0.912p ps=5.18u w=4.8u l=0.13u
X6368 user_project_wrapper_0.IOVDD2 a_135844_41476# user_project_wrapper_0.analog_io[10] user_project_wrapper_0.IOVDD2 sg13_hv_pmos ad=2.1312p pd=7.3u as=3.9294p ps=7.84u w=6.66u l=0.6u
X6369 a_309917_199879# a_309516_194555# VDD3 VDD3 sg13_lv_pmos ad=0.19p pd=1.38u as=0.19p ps=1.38u w=1u l=0.7u
X6370 user_project_wrapper_0.IOVSS1 user_project_wrapper_0.sg13g2_IOPadIOVdd_1.sg13g2_Clamp_N43N43D4R_0.gate dantenna l=0.48u w=0.48u
X6371 user_project_wrapper_0.IOVSS1 a_209869_324119# a_209638_324119# w_207989_323975# sg13_lv_pmos ad=0.38p pd=2.38u as=0.68p ps=4.68u w=2u l=0.13u
X6372 user_project_wrapper_0.IOVSS1 a_29676_237844# user_project_wrapper_0.analog_io[6] user_project_wrapper_0.IOVSS1 sg13_hv_nmos ad=1.408p pd=5.04u as=2.596p ps=5.58u w=4.4u l=0.6u
X6373 user_project_wrapper_0.IOVSS1 a_189016_101343# a_189148_101407# user_project_wrapper_0.IOVSS1 sg13_lv_nmos ad=0.1405p pd=1.15u as=0.2163p ps=1.87u w=0.42u l=0.18u
X6374 analog_io[26] a_355624_278644# IOVDD3 IOVDD3 sg13_hv_pmos ad=3.9294p pd=7.84u as=2.1312p ps=7.3u w=6.66u l=0.6u
X6375 user_project_wrapper_0.analog_io[16] a_258244_41476# user_project_wrapper_0.IOVDD2 user_project_wrapper_0.IOVDD2 sg13_hv_pmos ad=3.9294p pd=7.84u as=2.1312p ps=7.3u w=6.66u l=0.6u
X6376 user_project_wrapper_0.analog_io[14] a_190389_99046# user_project_wrapper_0.IOVSS1 user_project_wrapper_0.IOVSS1 sg13_lv_nmos ad=0.1406p pd=1.12u as=0.1406p ps=1.12u w=0.74u l=0.13u
X6377 VDD3 a_296625_189595# a_296731_189665# VDD3 sg13_lv_pmos ad=0.2603p pd=1.75u as=0.2603p ps=1.75u w=1.37u l=0.35u
X6378 VDD3 a_309516_194555# a_309917_194695# VDD3 sg13_lv_pmos ad=0.19p pd=1.38u as=0.19p ps=1.38u w=1u l=0.7u
X6379 a_79025_138251# a_78824_137391# user_project_wrapper_0.VDD1 user_project_wrapper_0.VDD1 sg13_lv_pmos ad=1.7p pd=10.68u as=1.7p ps=10.68u w=5u l=0.15u
X6380 VDD3 a_296625_208423# a_296731_208493# VDD3 sg13_lv_pmos ad=0.2603p pd=1.75u as=0.2603p ps=1.75u w=1.37u l=0.35u
X6381 a_360372_303385# a_364458_303055# user_project_wrapper_0.IOVSS1 rppd l=20u w=1u
X6382 user_project_wrapper_0.analog_io[1] a_41476_135844# user_project_wrapper_0.IOVDD1 user_project_wrapper_0.IOVDD1 sg13_hv_pmos ad=3.9294p pd=7.84u as=2.1312p ps=7.3u w=6.66u l=0.6u
X6383 user_project_wrapper_0.IOVSS1 a_270512_100118# a_271172_100118# user_project_wrapper_0.IOVSS1 sg13_lv_nmos ad=0.2516p pd=2.16u as=0.1443p ps=1.13u w=0.74u l=0.13u
X6384 user_project_wrapper_0.sg13g2_IOPadVdd_1.sg13g2_RCClampInverter_noptap_0.out user_project_wrapper_0.sg13g2_IOPadVdd_1.sg13g2_RCClampResistor_0.p2 user_project_wrapper_0.IOVSS1 user_project_wrapper_0.IOVSS1 sg13_hv_nmos ad=1.71p pd=9.38u as=3.06p ps=18.68u w=9u l=0.5u
X6385 VDD3 a_296626_197740# a_296732_197880# VDD3 sg13_lv_pmos ad=1.33p pd=7.38u as=1.33p ps=7.38u w=7u l=0.7u
X6386 VDD3 a_296625_208423# a_296731_208493# VDD3 sg13_lv_pmos ad=0.2603p pd=1.75u as=0.2603p ps=1.75u w=1.37u l=0.35u
X6387 user_project_wrapper_0.IOVSS1 a_202114_326125# user_project_wrapper_0.analog_io[32] user_project_wrapper_0.IOVSS1 sg13_lv_nmos ad=0.912p pd=5.18u as=0.912p ps=5.18u w=4.8u l=0.13u
X6388 user_project_wrapper_0.IOVSS1 user_project_wrapper_0.sg13g2_IOPadVdd_2.sg13g2_RCClampInverter_noptap_0.out user_project_wrapper_0.VDD1 user_project_wrapper_0.IOVSS1 sg13_hv_nmos ad=1.408p pd=5.04u as=2.596p ps=5.58u w=4.4u l=0.6u
X6389 user_project_wrapper_0.IOVDD1 a_41476_115444# user_project_wrapper_0.analog_io[0] user_project_wrapper_0.IOVDD1 sg13_hv_pmos ad=2.1312p pd=7.3u as=3.9294p ps=7.84u w=6.66u l=0.6u
X6390 a_296625_208423# a_304090_197941# a_304196_200821# user_project_wrapper_0.IOVSS1 sg13_lv_nmos ad=0.361p pd=2.28u as=0.646p ps=4.48u w=1.9u l=0.16u
X6391 user_project_wrapper_0.IOVSS1 a_278644_369296# user_project_wrapper_0.analog_io[35] user_project_wrapper_0.IOVSS1 sg13_hv_nmos ad=1.408p pd=5.04u as=2.596p ps=5.58u w=4.4u l=0.6u
X6392 user_project_wrapper_0.analog_io[34] a_258244_355624# user_project_wrapper_0.IOVDD4 user_project_wrapper_0.IOVDD4 sg13_hv_pmos ad=3.9294p pd=7.84u as=2.1312p ps=7.3u w=6.66u l=0.6u
X6393 user_project_wrapper_0.analog_io[27] a_182931_326125# user_project_wrapper_0.IOVSS1 user_project_wrapper_0.IOVSS1 sg13_lv_pmos ad=1.824p pd=9.98u as=1.824p ps=9.98u w=9.6u l=0.13u
X6394 user_project_wrapper_0.analog_io[13] user_project_wrapper_0.IOVDD2 dpantenna l=0.64u w=4.98u
X6395 user_project_wrapper_0.IOVDD4 a_237844_355624# user_project_wrapper_0.analog_io[33] user_project_wrapper_0.IOVDD4 sg13_hv_pmos ad=2.1312p pd=7.3u as=3.9294p ps=7.84u w=6.66u l=0.6u
X6396 user_project_wrapper_0.IOVSS1 user_project_wrapper_0.sg13g2_IOPadVdd_2.sg13g2_RCClampInverter_noptap_0.out user_project_wrapper_0.VDD1 user_project_wrapper_0.IOVSS1 sg13_hv_nmos ad=1.408p pd=5.04u as=2.596p ps=5.58u w=4.4u l=0.6u
X6397 a_182931_326125# a_186202_326221# user_project_wrapper_0.IOVSS1 user_project_wrapper_0.IOVSS1 sg13_lv_pmos ad=1.824p pd=9.98u as=1.824p ps=9.98u w=9.6u l=0.13u
X6398 user_project_wrapper_0.sg13g2_IOPadVdd_1.sg13g2_RCClampInverter_noptap_0.out user_project_wrapper_0.sg13g2_IOPadVdd_1.sg13g2_RCClampResistor_0.p2 user_project_wrapper_0.VDD2 user_project_wrapper_0.VDD2 sg13_hv_pmos ad=1.33p pd=7.38u as=1.33p ps=7.38u w=7u l=0.5u
X6399 user_project_wrapper_0.analog_io[5] a_41476_217444# user_project_wrapper_0.IOVDD1 user_project_wrapper_0.IOVDD1 sg13_hv_pmos ad=3.9294p pd=7.84u as=2.1312p ps=7.3u w=6.66u l=0.6u
X6400 IOVDD3 user_project_wrapper_0.sg13g2_IOPadIOVdd_3.sg13g2_Clamp_N43N43D4R_0.gate user_project_wrapper_0.IOVSS1 user_project_wrapper_0.IOVSS1 sg13_hv_nmos ad=2.596p pd=5.58u as=1.408p ps=5.04u w=4.4u l=0.6u
X6401 user_project_wrapper_0.analog_io[4] user_project_wrapper_0.IOVDD1 dpantenna l=27.78u w=1.26u
X6402 user_project_wrapper_0.VDD2 user_project_wrapper_0.sg13g2_IOPadVdd_1.sg13g2_RCClampInverter_noptap_0.out user_project_wrapper_0.IOVSS1 user_project_wrapper_0.IOVSS1 sg13_hv_nmos ad=2.596p pd=5.58u as=1.408p ps=5.04u w=4.4u l=0.6u
X6403 user_project_wrapper_0.IOVSS1 user_project_wrapper_0.sg13g2_IOPadIOVdd_1.sg13g2_Clamp_N43N43D4R_0.gate user_project_wrapper_0.IOVDD1 user_project_wrapper_0.IOVSS1 sg13_hv_nmos ad=1.408p pd=5.04u as=2.596p ps=5.58u w=4.4u l=0.6u
X6404 a_296732_200582# a_301940_196388# a_296625_208423# VDD3 sg13_lv_pmos ad=0.7695p pd=4.43u as=0.7695p ps=4.43u w=4.05u l=0.5u
X6405 user_project_wrapper_0.IOVSS1 a_278644_29676# QDLL_TOP_0.VOUT user_project_wrapper_0.IOVSS1 sg13_hv_nmos ad=1.408p pd=5.04u as=2.596p ps=5.58u w=4.4u l=0.6u
X6406 user_project_wrapper_0.analog_io[11] a_156244_29676# user_project_wrapper_0.IOVSS1 user_project_wrapper_0.IOVSS1 sg13_hv_nmos ad=2.596p pd=5.58u as=1.408p ps=5.04u w=4.4u l=0.6u
X6407 user_project_wrapper_0.IOVDD2 a_278644_41476# QDLL_TOP_0.VOUT user_project_wrapper_0.IOVDD2 sg13_hv_pmos ad=2.1312p pd=7.3u as=3.9294p ps=7.84u w=6.66u l=0.6u
X6408 user_project_wrapper_0.VDD1 a_91911_127530# a_92512_127896# user_project_wrapper_0.VDD1 sg13_lv_pmos ad=0.3808p pd=2.92u as=0.2128p ps=1.5u w=1.12u l=0.13u
X6409 user_project_wrapper_0.analog_io[7] a_41476_258244# user_project_wrapper_0.IOVDD1 user_project_wrapper_0.IOVDD1 sg13_hv_pmos ad=3.9294p pd=7.84u as=2.1312p ps=7.3u w=6.66u l=0.6u
X6410 user_project_wrapper_0.analog_io[32] a_202114_326125# user_project_wrapper_0.IOVSS1 user_project_wrapper_0.IOVSS1 sg13_lv_pmos ad=1.824p pd=9.98u as=1.824p ps=9.98u w=9.6u l=0.13u
X6411 user_project_wrapper_0.IOVSS1 a_29676_135844# user_project_wrapper_0.analog_io[1] user_project_wrapper_0.IOVSS1 sg13_hv_nmos ad=1.408p pd=5.04u as=2.596p ps=5.58u w=4.4u l=0.6u
X6412 user_project_wrapper_0.IOVDD1 user_project_wrapper_0.sg13g2_IOPadIOVdd_1.sg13g2_RCClampResistor_0.p2 user_project_wrapper_0.sg13g2_IOPadIOVdd_1.sg13g2_Clamp_N43N43D4R_0.gate user_project_wrapper_0.IOVDD1 sg13_hv_pmos ad=1.33p pd=7.38u as=1.33p ps=7.38u w=7u l=0.5u
X6413 user_project_wrapper_0.IOVSS1 user_project_wrapper_0.sg13g2_IOPadIOVdd_1.sg13g2_Clamp_N43N43D4R_0.gate user_project_wrapper_0.IOVDD1 user_project_wrapper_0.IOVSS1 sg13_hv_nmos ad=1.408p pd=5.04u as=2.596p ps=5.58u w=4.4u l=0.6u
X6414 a_309917_199879# a_309516_194555# VDD3 VDD3 sg13_lv_pmos ad=0.19p pd=1.38u as=0.19p ps=1.38u w=1u l=0.7u
X6415 VDD3 a_296625_208423# a_296731_208493# VDD3 sg13_lv_pmos ad=0.2603p pd=1.75u as=0.2603p ps=1.75u w=1.37u l=0.35u
X6416 user_project_wrapper_0.IOVSS1 user_project_wrapper_0.sg13g2_IOPadAnalog_29.padres dantenna l=0.64u w=3.1u
X6417 user_project_wrapper_0.IOVSS1 a_369296_115444# analog_io[18] user_project_wrapper_0.IOVSS1 sg13_hv_nmos ad=1.408p pd=5.04u as=2.596p ps=5.58u w=4.4u l=0.6u
X6418 a_311846_195517# user_project_wrapper_0.sg13g2_IOPadAnalog_29.padres a_309917_199879# VDD3 sg13_lv_pmos ad=0.24415p pd=1.665u as=0.24415p ps=1.665u w=1.285u l=0.35u
X6419 user_project_wrapper_0.IOVSS1 user_project_wrapper_0.sg13g2_IOPadIOVdd_2.sg13g2_Clamp_N43N43D4R_0.gate user_project_wrapper_0.IOVDD4 user_project_wrapper_0.IOVSS1 sg13_hv_nmos ad=1.408p pd=5.04u as=2.596p ps=5.58u w=4.4u l=0.6u
X6420 user_project_wrapper_0.IOVDD2 user_project_wrapper_0.sg13g2_IOPadIOVdd_0.sg13g2_Clamp_N43N43D4R_0.gate user_project_wrapper_0.IOVSS1 user_project_wrapper_0.IOVSS1 sg13_hv_nmos ad=2.596p pd=5.58u as=1.408p ps=5.04u w=4.4u l=0.6u
X6421 user_project_wrapper_0.IOVSS1 user_project_wrapper_0.sg13g2_IOPadVdd_3.sg13g2_RCClampResistor_0.p2 user_project_wrapper_0.sg13g2_IOPadVdd_3.sg13g2_RCClampInverter_noptap_0.out user_project_wrapper_0.IOVSS1 sg13_hv_pmos ad=1.33p pd=7.38u as=1.33p ps=7.38u w=7u l=0.5u
X6422 a_311846_195517# user_project_wrapper_0.sg13g2_IOPadAnalog_29.padres a_309917_194695# VDD3 sg13_lv_pmos ad=0.24415p pd=1.665u as=0.24415p ps=1.665u w=1.285u l=0.35u
X6423 a_189286_326377# a_189184_327491# a_189184_326377# w_188704_326203# sg13_lv_pmos ad=0.38p pd=2.38u as=0.38p ps=2.38u w=2u l=0.13u
X6424 user_project_wrapper_0.IOVSS1 user_project_wrapper_0.sg13g2_IOPadVdd_3.sg13g2_RCClampInverter_noptap_0.out user_project_wrapper_0.IOVSS1 user_project_wrapper_0.IOVSS1 sg13_hv_nmos ad=1.408p pd=5.04u as=0 ps=0 w=4.4u l=0.6u
X6425 a_182931_326125# a_186202_326221# user_project_wrapper_0.IOVSS1 user_project_wrapper_0.IOVSS1 sg13_lv_pmos ad=1.824p pd=9.98u as=1.824p ps=9.98u w=9.6u l=0.13u
X6426 user_project_wrapper_0.IOVSS1 a_194687_324142# user_project_wrapper_0.analog_io[30] user_project_wrapper_0.IOVSS1 sg13_lv_nmos ad=0.912p pd=5.18u as=0.912p ps=5.18u w=4.8u l=0.13u
X6427 user_project_wrapper_0.IOVSS1 user_project_wrapper_0.sg13g2_IOPadIOVdd_3.sg13g2_Clamp_N43N43D4R_0.gate IOVDD3 user_project_wrapper_0.IOVSS1 sg13_hv_nmos ad=1.408p pd=5.04u as=2.596p ps=5.58u w=4.4u l=0.6u
X6428 a_304196_200821# a_304889_199957# a_304995_198817# user_project_wrapper_0.IOVSS1 sg13_lv_nmos ad=0.209p pd=1.48u as=0.209p ps=1.48u w=1.1u l=0.15u
X6429 user_project_wrapper_0.analog_io[30] a_176644_355624# user_project_wrapper_0.IOVDD4 user_project_wrapper_0.IOVDD4 sg13_hv_pmos ad=3.9294p pd=7.84u as=3.1302p ps=14.26u w=6.66u l=0.6u
X6430 user_project_wrapper_0.IOVDD2 a_156244_41476# user_project_wrapper_0.analog_io[11] user_project_wrapper_0.IOVDD2 sg13_hv_pmos ad=2.1312p pd=7.3u as=3.9294p ps=7.84u w=6.66u l=0.6u
X6431 user_project_wrapper_0.ui_PAD[2] user_project_wrapper_0.sg13g2_IOPadIn$1_0.sg13g2_LevelDown_noptap$1_0.sg13g2_SecondaryProtection$1$1_0.core user_project_wrapper_0.IOVSS1 rppd l=2u w=1u
X6432 a_307232_196607# a_296731_189665# a_309917_194695# VDD3 sg13_lv_pmos ad=0.24415p pd=1.665u as=0.24415p ps=1.665u w=1.285u l=0.35u
X6433 user_project_wrapper_0.analog_io[34] a_258244_369296# user_project_wrapper_0.IOVSS1 user_project_wrapper_0.IOVSS1 sg13_hv_nmos ad=2.596p pd=5.58u as=1.408p ps=5.04u w=4.4u l=0.6u
X6434 user_project_wrapper_0.IOVSS1 a_194687_324142# user_project_wrapper_0.analog_io[30] user_project_wrapper_0.IOVSS1 sg13_lv_nmos ad=0.912p pd=5.18u as=0.912p ps=5.18u w=4.8u l=0.13u
X6435 user_project_wrapper_0.VDD1 user_project_wrapper_0.sg13g2_IOPadVdd_2.sg13g2_RCClampInverter_noptap_0.out user_project_wrapper_0.IOVSS1 user_project_wrapper_0.IOVSS1 sg13_hv_nmos ad=2.596p pd=5.58u as=1.408p ps=5.04u w=4.4u l=0.6u
X6436 user_project_wrapper_0.IOVDD4 user_project_wrapper_0.sg13g2_IOPadIOVdd_2.sg13g2_RCClampResistor_0.p2 user_project_wrapper_0.sg13g2_IOPadIOVdd_2.sg13g2_Clamp_N43N43D4R_0.gate user_project_wrapper_0.IOVDD4 sg13_hv_pmos ad=1.33p pd=7.38u as=1.33p ps=7.38u w=7u l=0.5u
X6437 VDD3 a_309516_194555# a_309917_199879# VDD3 sg13_lv_pmos ad=0.19p pd=1.38u as=0.19p ps=1.38u w=1u l=0.7u
X6438 user_project_wrapper_0.IOVSS1 user_project_wrapper_0.IOVSS1 user_project_wrapper_0.IOVSS1 rppd l=0.5u w=0.5u
X6439 user_project_wrapper_0.analog_io[14] a_190389_99046# user_project_wrapper_0.IOVSS1 user_project_wrapper_0.IOVSS1 sg13_lv_nmos ad=0.1406p pd=1.12u as=0.1406p ps=1.12u w=0.74u l=0.13u
X6440 user_project_wrapper_0.IOVSS1 a_369296_176644# analog_io[20] user_project_wrapper_0.IOVSS1 sg13_hv_nmos ad=1.408p pd=5.04u as=2.596p ps=5.58u w=4.4u l=0.6u
X6441 a_304995_198817# a_307232_196607# user_project_wrapper_0.IOVSS1 user_project_wrapper_0.IOVSS1 sg13_lv_nmos ad=0.6327p pd=3.71u as=0.6327p ps=3.71u w=3.33u l=0.2u
X6442 VDD3 a_309516_194555# a_309917_194695# VDD3 sg13_lv_pmos ad=0.19p pd=1.38u as=0.19p ps=1.38u w=1u l=0.7u
X6443 VDD3 a_296626_197740# a_296732_200582# VDD3 sg13_lv_pmos ad=1.33p pd=7.38u as=1.33p ps=7.38u w=7u l=0.7u
X6444 user_project_wrapper_0.IOVSS1 user_project_wrapper_0.sg13g2_IOPadOut4mA$1_0.c2p a_58798_179951# user_project_wrapper_0.IOVSS1 sg13_lv_nmos ad=0.935p pd=6.18u as=0.935p ps=6.18u w=2.75u l=0.13u
X6445 user_project_wrapper_0.IOVDD2 user_project_wrapper_0.sg13g2_IOPadIOVdd_0.sg13g2_Clamp_N43N43D4R_0.gate user_project_wrapper_0.IOVSS1 user_project_wrapper_0.IOVSS1 sg13_hv_nmos ad=2.596p pd=5.58u as=1.408p ps=5.04u w=4.4u l=0.6u
X6446 analog_io[20] a_355624_156244# IOVDD3 IOVDD3 sg13_hv_pmos ad=3.9294p pd=7.84u as=2.1312p ps=7.3u w=6.66u l=0.6u
X6447 a_296731_189665# a_296625_189595# VDD3 VDD3 sg13_lv_pmos ad=0.2603p pd=1.75u as=0.2603p ps=1.75u w=1.37u l=0.35u
X6448 user_project_wrapper_0.IOVSS1 a_191234_329719# a_191438_329719# w_188700_330166# sg13_lv_pmos ad=0.38p pd=2.38u as=0.38p ps=2.38u w=2u l=0.13u
X6449 VDD3 user_project_wrapper_0.sg13g2_IOPadVdd_0.sg13g2_RCClampInverter_noptap_0.out user_project_wrapper_0.IOVSS1 user_project_wrapper_0.IOVSS1 sg13_hv_nmos ad=2.596p pd=5.58u as=1.408p ps=5.04u w=4.4u l=0.6u
X6450 user_project_wrapper_0.IOVDD4 a_156244_355624# user_project_wrapper_0.analog_io[29] user_project_wrapper_0.IOVDD4 sg13_hv_pmos ad=2.1312p pd=7.3u as=3.9294p ps=7.84u w=6.66u l=0.6u
X6451 user_project_wrapper_0.IOVSS1 a_205385_326221# a_202114_326125# user_project_wrapper_0.IOVSS1 sg13_lv_nmos ad=0.912p pd=5.18u as=0.912p ps=5.18u w=4.8u l=0.13u
X6452 user_project_wrapper_0.analog_io[32] a_217444_355624# user_project_wrapper_0.IOVDD4 user_project_wrapper_0.IOVDD4 sg13_hv_pmos ad=3.9294p pd=7.84u as=2.1312p ps=7.3u w=6.66u l=0.6u
X6453 user_project_wrapper_0.IOVSS1 a_369296_197044# analog_io[22] user_project_wrapper_0.IOVSS1 sg13_hv_nmos ad=1.408p pd=5.04u as=2.596p ps=5.58u w=4.4u l=0.6u
X6454 user_project_wrapper_0.IOVDD2 a_135844_41476# user_project_wrapper_0.analog_io[10] user_project_wrapper_0.IOVDD2 sg13_hv_pmos ad=2.1312p pd=7.3u as=3.9294p ps=7.84u w=6.66u l=0.6u
X6455 user_project_wrapper_0.IOVSS1 user_project_wrapper_0.sg13g2_IOPadIOVdd_0.sg13g2_Clamp_N43N43D4R_0.gate user_project_wrapper_0.IOVDD2 user_project_wrapper_0.IOVSS1 sg13_hv_nmos ad=1.408p pd=5.04u as=2.596p ps=5.58u w=4.4u l=0.6u
X6456 a_296625_189595# a_304090_197941# a_304196_197873# user_project_wrapper_0.IOVSS1 sg13_lv_nmos ad=0.361p pd=2.28u as=0.361p ps=2.28u w=1.9u l=0.16u
X6457 analog_io[18] a_369296_115444# user_project_wrapper_0.IOVSS1 user_project_wrapper_0.IOVSS1 sg13_hv_nmos ad=2.596p pd=5.58u as=1.408p ps=5.04u w=4.4u l=0.6u
X6458 QDLL_TOP_0.VOUT a_271172_100118# QDLL_TOP_0.VDD QDLL_TOP_0.VDD sg13_lv_pmos ad=0.2128p pd=1.5u as=0.2128p ps=1.5u w=1.12u l=0.13u
X6459 a_190926_325785# a_189184_325263# a_190824_325263# w_188704_326203# sg13_lv_pmos ad=0.38p pd=2.38u as=0.38p ps=2.38u w=2u l=0.13u
X6460 a_82840_127455# a_79025_131741# user_project_wrapper_0.IOVSS1 user_project_wrapper_0.IOVSS1 sg13_lv_nmos ad=0.2516p pd=2.16u as=0.2516p ps=2.16u w=0.74u l=0.13u
X6461 user_project_wrapper_0.IOVSS1 user_project_wrapper_0.sg13g2_IOPadIOVdd_0.sg13g2_Clamp_N43N43D4R_0.gate user_project_wrapper_0.IOVDD2 user_project_wrapper_0.IOVSS1 sg13_hv_nmos ad=1.408p pd=5.04u as=2.596p ps=5.58u w=4.4u l=0.6u
X6462 VDD3 user_project_wrapper_0.sg13g2_IOPadVdd_0.sg13g2_RCClampInverter_noptap_0.out user_project_wrapper_0.IOVSS1 user_project_wrapper_0.IOVSS1 sg13_hv_nmos ad=2.596p pd=5.58u as=1.408p ps=5.04u w=4.4u l=0.6u
X6463 a_191234_328605# a_190824_328605# user_project_wrapper_0.IOVSS1 user_project_wrapper_0.IOVSS1 sg13_lv_nmos ad=0.34p pd=2.68u as=0.34p ps=2.68u w=1u l=0.13u
X6464 a_296731_189665# a_296625_189595# VDD3 VDD3 sg13_lv_pmos ad=0.2603p pd=1.75u as=0.4658p ps=3.42u w=1.37u l=0.35u
X6465 user_project_wrapper_0.IOVDD1 a_41476_237844# user_project_wrapper_0.analog_io[6] user_project_wrapper_0.IOVDD1 sg13_hv_pmos ad=2.1312p pd=7.3u as=3.9294p ps=7.84u w=6.66u l=0.6u
X6466 user_project_wrapper_0.IOVSS1 user_project_wrapper_0.sg13g2_IOPadIOVdd_1.sg13g2_Clamp_N43N43D4R_0.gate user_project_wrapper_0.IOVDD1 user_project_wrapper_0.IOVSS1 sg13_hv_nmos ad=1.408p pd=5.04u as=2.596p ps=5.58u w=4.4u l=0.6u
X6467 user_project_wrapper_0.IOVDD1 a_41476_258244# user_project_wrapper_0.analog_io[7] user_project_wrapper_0.IOVDD1 sg13_hv_pmos ad=2.1312p pd=7.3u as=3.9294p ps=7.84u w=6.66u l=0.6u
X6468 user_project_wrapper_0.sg13g2_IOPadIOVdd_0.sg13g2_Clamp_N43N43D4R_0.gate user_project_wrapper_0.sg13g2_IOPadIOVdd_0.sg13g2_RCClampResistor_0.p2 user_project_wrapper_0.IOVDD2 user_project_wrapper_0.IOVDD2 sg13_hv_pmos ad=1.33p pd=7.38u as=1.33p ps=7.38u w=7u l=0.5u
X6469 user_project_wrapper_0.analog_io[16] a_258244_29676# user_project_wrapper_0.IOVSS1 user_project_wrapper_0.IOVSS1 sg13_hv_nmos ad=2.596p pd=5.58u as=1.408p ps=5.04u w=4.4u l=0.6u
X6470 a_296731_189665# a_296625_189595# VDD3 VDD3 sg13_lv_pmos ad=0.2603p pd=1.75u as=0.2603p ps=1.75u w=1.37u l=0.35u
X6471 a_296731_208493# a_296625_208423# VDD3 VDD3 sg13_lv_pmos ad=0.2603p pd=1.75u as=0.2603p ps=1.75u w=1.37u l=0.35u
X6472 a_296731_208493# a_301186_192011# user_project_wrapper_0.IOVSS1 user_project_wrapper_0.IOVSS1 sg13_lv_nmos ad=0.912p pd=5.18u as=0.912p ps=5.18u w=4.8u l=1.06u
X6473 user_project_wrapper_0.IOVDD2 a_237844_41476# user_project_wrapper_0.analog_io[15] user_project_wrapper_0.IOVDD2 sg13_hv_pmos ad=2.1312p pd=7.3u as=3.9294p ps=7.84u w=6.66u l=0.6u
X6474 user_project_wrapper_0.VDD2 user_project_wrapper_0.sg13g2_IOPadVdd_1.sg13g2_RCClampInverter_noptap_0.out user_project_wrapper_0.IOVSS1 user_project_wrapper_0.IOVSS1 sg13_hv_nmos ad=2.596p pd=5.58u as=1.408p ps=5.04u w=4.4u l=0.6u
X6475 user_project_wrapper_0.IOVSS1 a_190389_101343# user_project_wrapper_0.analog_io[15] user_project_wrapper_0.IOVSS1 sg13_lv_nmos ad=0.2516p pd=2.16u as=0.1406p ps=1.12u w=0.74u l=0.13u
X6476 user_project_wrapper_0.IOVSS1 user_project_wrapper_0.sg13g2_IOPadVdd_2.sg13g2_RCClampInverter_noptap_0.out user_project_wrapper_0.VDD1 user_project_wrapper_0.IOVSS1 sg13_hv_nmos ad=1.408p pd=5.04u as=2.596p ps=5.58u w=4.4u l=0.6u
X6477 user_project_wrapper_0.IOVSS1 user_project_wrapper_0.sg13g2_IOPadIOVdd_0.sg13g2_Clamp_N43N43D4R_0.gate user_project_wrapper_0.IOVDD2 user_project_wrapper_0.IOVSS1 sg13_hv_nmos ad=1.408p pd=5.04u as=2.596p ps=5.58u w=4.4u l=0.6u
X6478 a_79025_131741# a_78824_130881# user_project_wrapper_0.VDD1 user_project_wrapper_0.VDD1 sg13_lv_pmos ad=1.7p pd=10.68u as=1.7p ps=10.68u w=5u l=0.15u
X6479 user_project_wrapper_0.IOVSS1 a_301186_192011# a_296731_208493# user_project_wrapper_0.IOVSS1 sg13_lv_nmos ad=0.912p pd=5.18u as=0.912p ps=5.18u w=4.8u l=1.06u
X6480 user_project_wrapper_0.analog_io[34] a_258244_369296# user_project_wrapper_0.IOVSS1 user_project_wrapper_0.IOVSS1 sg13_hv_nmos ad=2.596p pd=5.58u as=1.408p ps=5.04u w=4.4u l=0.6u
X6481 analog_io[18] a_355624_115444# IOVDD3 IOVDD3 sg13_hv_pmos ad=3.9294p pd=7.84u as=2.1312p ps=7.3u w=6.66u l=0.6u
X6482 IOVDD3 a_355624_278644# analog_io[26] IOVDD3 sg13_hv_pmos ad=2.1312p pd=7.3u as=3.9294p ps=7.84u w=6.66u l=0.6u
X6483 a_296732_200582# a_296626_197740# VDD3 VDD3 sg13_lv_pmos ad=1.33p pd=7.38u as=1.33p ps=7.38u w=7u l=0.7u
X6484 a_296731_208493# a_296625_208423# VDD3 VDD3 sg13_lv_pmos ad=0.2603p pd=1.75u as=0.2603p ps=1.75u w=1.37u l=0.35u
X6485 a_87627_124843# a_86507_127725# user_project_wrapper_0.IOVSS1 user_project_wrapper_0.IOVSS1 sg13_lv_nmos ad=0.2516p pd=2.16u as=0.2516p ps=2.16u w=0.74u l=0.13u
X6486 a_85591_241383# a_85287_241383# user_project_wrapper_0.IOVSS1 user_project_wrapper_0.IOVSS1 sg13_lv_nmos ad=0.1406p pd=1.12u as=0.2516p ps=2.16u w=0.74u l=0.13u
X6487 analog_io[22] a_355624_197044# IOVDD3 IOVDD3 sg13_hv_pmos ad=3.9294p pd=7.84u as=3.1302p ps=14.26u w=6.66u l=0.6u
X6488 a_82846_240684# a_82118_239118# a_82859_239842# user_project_wrapper_0.VDD1 sg13_lv_pmos ad=1.7p pd=10.68u as=0.95p ps=5.38u w=5u l=0.3u
X6489 user_project_wrapper_0.analog_io[12] a_176644_41476# user_project_wrapper_0.IOVDD2 user_project_wrapper_0.IOVDD2 sg13_hv_pmos ad=3.9294p pd=7.84u as=2.1312p ps=7.3u w=6.66u l=0.6u
X6490 a_87434_127896# a_83492_127455# a_87434_127531# user_project_wrapper_0.IOVSS1 sg13_lv_nmos ad=0.2516p pd=2.16u as=0.1406p ps=1.12u w=0.74u l=0.13u
X6491 a_296731_189665# a_304889_199957# user_project_wrapper_0.IOVSS1 rppd l=19u w=0.6u
X6492 a_79025_127401# a_78824_126541# user_project_wrapper_0.VDD1 user_project_wrapper_0.VDD1 sg13_lv_pmos ad=1.7p pd=10.68u as=1.7p ps=10.68u w=5u l=0.15u
X6493 a_35456_74035# a_39542_73705# user_project_wrapper_0.IOVSS1 rppd l=20u w=1u
X6494 user_project_wrapper_0.IOVSS1 user_project_wrapper_0.sg13g2_IOPadVdd_0.sg13g2_RCClampInverter_noptap_0.out VDD3 user_project_wrapper_0.IOVSS1 sg13_hv_nmos ad=1.408p pd=5.04u as=2.596p ps=5.58u w=4.4u l=0.6u
X6495 user_project_wrapper_0.IOVSS1 a_182931_326125# user_project_wrapper_0.analog_io[27] user_project_wrapper_0.IOVSS1 sg13_lv_nmos ad=0.912p pd=5.18u as=0.912p ps=5.18u w=4.8u l=0.13u
X6496 analog_io[23] a_355624_217444# IOVDD3 IOVDD3 sg13_hv_pmos ad=3.9294p pd=7.84u as=2.1312p ps=7.3u w=6.66u l=0.6u
X6497 user_project_wrapper_0.IOVSS1 user_project_wrapper_0.sg13g2_IOPadVdd_3.sg13g2_RCClampResistor_0.p2 user_project_wrapper_0.sg13g2_IOPadVdd_3.sg13g2_RCClampInverter_noptap_0.out user_project_wrapper_0.IOVSS1 sg13_hv_pmos ad=1.33p pd=7.38u as=1.33p ps=7.38u w=7u l=0.5u
X6498 user_project_wrapper_0.analog_io[10] a_135844_41476# user_project_wrapper_0.IOVDD2 user_project_wrapper_0.IOVDD2 sg13_hv_pmos ad=3.9294p pd=7.84u as=2.1312p ps=7.3u w=6.66u l=0.6u
X6499 user_project_wrapper_0.IOVSS1 user_project_wrapper_0.sg13g2_IOPadIOVdd_0.sg13g2_Clamp_N43N43D4R_0.gate user_project_wrapper_0.IOVDD2 user_project_wrapper_0.IOVSS1 sg13_hv_nmos ad=1.408p pd=5.04u as=2.596p ps=5.58u w=4.4u l=0.6u
X6500 a_296731_208493# a_296625_208423# VDD3 VDD3 sg13_lv_pmos ad=0.2603p pd=1.75u as=0.2603p ps=1.75u w=1.37u l=0.35u
X6501 IOVDD3 user_project_wrapper_0.sg13g2_IOPadIOVdd_3.sg13g2_Clamp_N43N43D4R_0.gate user_project_wrapper_0.IOVSS1 user_project_wrapper_0.IOVSS1 sg13_hv_nmos ad=2.596p pd=5.58u as=2.068p ps=9.74u w=4.4u l=0.6u
X6502 user_project_wrapper_0.IOVSS1 a_369296_115444# analog_io[18] user_project_wrapper_0.IOVSS1 sg13_hv_nmos ad=2.068p pd=9.74u as=2.596p ps=5.58u w=4.4u l=0.6u
X6503 a_296731_208493# a_296625_208423# VDD3 VDD3 sg13_lv_pmos ad=0.2603p pd=1.75u as=0.4658p ps=3.42u w=1.37u l=0.35u
X6504 IOVDD3 user_project_wrapper_0.sg13g2_IOPadIOVdd_3.sg13g2_Clamp_N43N43D4R_0.gate user_project_wrapper_0.IOVSS1 user_project_wrapper_0.IOVSS1 sg13_hv_nmos ad=2.596p pd=5.58u as=2.068p ps=9.74u w=4.4u l=0.6u
X6505 user_project_wrapper_0.IOVDD1 a_41476_258244# user_project_wrapper_0.analog_io[7] user_project_wrapper_0.IOVDD1 sg13_hv_pmos ad=2.1312p pd=7.3u as=3.9294p ps=7.84u w=6.66u l=0.6u
X6506 user_project_wrapper_0.IOVSS1 user_project_wrapper_0.sg13g2_IOPadVdd_0.sg13g2_RCClampInverter_noptap_0.out VDD3 user_project_wrapper_0.IOVSS1 sg13_hv_nmos ad=1.408p pd=5.04u as=2.596p ps=5.58u w=4.4u l=0.6u
X6507 user_project_wrapper_0.IOVDD4 a_258244_355624# user_project_wrapper_0.analog_io[34] user_project_wrapper_0.IOVDD4 sg13_hv_pmos ad=2.1312p pd=7.3u as=3.9294p ps=7.84u w=6.66u l=0.6u
X6508 user_project_wrapper_0.IOVDD2 a_197044_41476# user_project_wrapper_0.analog_io[13] user_project_wrapper_0.IOVDD2 sg13_hv_pmos ad=2.1312p pd=7.3u as=3.9294p ps=7.84u w=6.66u l=0.6u
X6509 user_project_wrapper_0.IOVDD4 user_project_wrapper_0.sg13g2_IOPadIOVdd_2.sg13g2_RCClampResistor_0.p2 user_project_wrapper_0.sg13g2_IOPadIOVdd_2.sg13g2_Clamp_N43N43D4R_0.gate user_project_wrapper_0.IOVDD4 sg13_hv_pmos ad=1.33p pd=7.38u as=1.33p ps=7.38u w=7u l=0.5u
X6510 VDD3 a_296625_208423# a_296731_208493# VDD3 sg13_lv_pmos ad=0.4658p pd=3.42u as=0.2603p ps=1.75u w=1.37u l=0.35u
X6511 analog_io[20] a_355624_176644# IOVDD3 IOVDD3 sg13_hv_pmos ad=3.9294p pd=7.84u as=2.1312p ps=7.3u w=6.66u l=0.6u
X6512 a_83592_125209# user_project_wrapper_0.sg13g2_IOPadIn$1_0.p2c a_83490_125209# user_project_wrapper_0.VDD1 sg13_lv_pmos ad=0.2128p pd=1.5u as=0.2128p ps=1.5u w=1.12u l=0.13u
X6513 user_project_wrapper_0.IOVSS1 a_210417_329719# a_210621_329719# w_207883_330166# sg13_lv_pmos ad=0.38p pd=2.38u as=0.38p ps=2.38u w=2u l=0.13u
X6514 user_project_wrapper_0.IOVSS1 user_project_wrapper_0.sg13g2_IOPadVdd_1.sg13g2_RCClampInverter_noptap_0.out user_project_wrapper_0.VDD2 user_project_wrapper_0.IOVSS1 sg13_hv_nmos ad=1.408p pd=5.04u as=2.596p ps=5.58u w=4.4u l=0.6u
X6515 user_project_wrapper_0.IOVSS1 analog_io[20] dantenna l=27.78u w=1.26u
X6516 a_309917_199879# a_296731_208493# a_307232_196607# VDD3 sg13_lv_pmos ad=0.24415p pd=1.665u as=0.24415p ps=1.665u w=1.285u l=0.35u
X6517 VDD3 user_project_wrapper_0.sg13g2_IOPadVdd_0.sg13g2_RCClampInverter_noptap_0.out user_project_wrapper_0.IOVSS1 user_project_wrapper_0.IOVSS1 sg13_hv_nmos ad=2.596p pd=5.58u as=1.408p ps=5.04u w=4.4u l=0.6u
X6518 user_project_wrapper_0.analog_io[5] a_41476_217444# user_project_wrapper_0.IOVDD1 user_project_wrapper_0.IOVDD1 sg13_hv_pmos ad=3.9294p pd=7.84u as=2.1312p ps=7.3u w=6.66u l=0.6u
X6519 IOVDD3 a_355624_135844# analog_io[19] IOVDD3 sg13_hv_pmos ad=2.1312p pd=7.3u as=3.9294p ps=7.84u w=6.66u l=0.6u
X6520 user_project_wrapper_0.IOVSS1 a_135844_29676# user_project_wrapper_0.analog_io[10] user_project_wrapper_0.IOVSS1 sg13_hv_nmos ad=1.408p pd=5.04u as=2.596p ps=5.58u w=4.4u l=0.6u
X6521 user_project_wrapper_0.IOVSS1 user_project_wrapper_0.sg13g2_IOPadVdd_3.sg13g2_RCClampInverter_noptap_0.out user_project_wrapper_0.IOVSS1 user_project_wrapper_0.IOVSS1 sg13_hv_nmos ad=2.596p pd=5.58u as=0 ps=0 w=4.4u l=0.6u
X6522 user_project_wrapper_0.IOVSS1 user_project_wrapper_0.sg13g2_IOPadVdd_2.sg13g2_RCClampResistor_0.p2 user_project_wrapper_0.IOVSS1 user_project_wrapper_0.IOVSS1 sg13_hv_nmos ad=3.06p pd=18.68u as=0 ps=0 w=9u l=9.5u
X6523 user_project_wrapper_0.IOVSS1 a_202114_326125# user_project_wrapper_0.analog_io[32] user_project_wrapper_0.IOVSS1 sg13_lv_nmos ad=0.912p pd=5.18u as=0.912p ps=5.18u w=4.8u l=0.13u
X6524 user_project_wrapper_0.IOVSS1 user_project_wrapper_0.sg13g2_IOPadVdd_3.sg13g2_RCClampInverter_noptap_0.out user_project_wrapper_0.IOVSS1 user_project_wrapper_0.IOVSS1 sg13_hv_nmos ad=2.596p pd=5.58u as=0 ps=0 w=4.4u l=0.6u
X6525 a_315347_192648# a_314793_201808# a_314697_196700# user_project_wrapper_0.IOVSS1 sg13_lv_nmos ad=1.14p pd=6.38u as=1.14p ps=6.38u w=6u l=6.4u
X6526 user_project_wrapper_0.analog_io[16] a_258244_29676# user_project_wrapper_0.IOVSS1 user_project_wrapper_0.IOVSS1 sg13_hv_nmos ad=2.596p pd=5.58u as=1.408p ps=5.04u w=4.4u l=0.6u
X6527 a_188074_110495# a_187518_108410# user_project_wrapper_0.IOVSS1 rppd l=10u w=1u
X6528 a_309917_199879# a_309516_194555# VDD3 VDD3 sg13_lv_pmos ad=0.19p pd=1.38u as=0.19p ps=1.38u w=1u l=0.7u
X6529 user_project_wrapper_0.sg13g2_IOPadIOVdd_1.sg13g2_Clamp_N43N43D4R_0.gate user_project_wrapper_0.sg13g2_IOPadIOVdd_1.sg13g2_RCClampResistor_0.p2 user_project_wrapper_0.IOVSS1 user_project_wrapper_0.IOVSS1 sg13_hv_nmos ad=1.71p pd=9.38u as=1.71p ps=9.38u w=9u l=0.5u
X6530 user_project_wrapper_0.analog_io[30] a_176644_369296# user_project_wrapper_0.IOVSS1 user_project_wrapper_0.IOVSS1 sg13_hv_nmos ad=2.596p pd=5.58u as=1.408p ps=5.04u w=4.4u l=0.6u
X6531 user_project_wrapper_0.IOVDD1 user_project_wrapper_0.sg13g2_IOPadOut4mA$1_1.sg13g2_GateLevelUpInv_noptap$1$1_0.pgate user_project_wrapper_0.uo_PAD[8] user_project_wrapper_0.IOVDD1 sg13_hv_pmos ad=3.1302p pd=14.26u as=3.9294p ps=7.84u w=6.66u l=0.6u
X6532 VDD3 a_296625_208423# a_296731_208493# VDD3 sg13_lv_pmos ad=0.2603p pd=1.75u as=0.2603p ps=1.75u w=1.37u l=0.35u
X6533 user_project_wrapper_0.analog_io[7] a_41476_258244# user_project_wrapper_0.IOVDD1 user_project_wrapper_0.IOVDD1 sg13_hv_pmos ad=3.9294p pd=7.84u as=2.1312p ps=7.3u w=6.66u l=0.6u
X6534 user_project_wrapper_0.analog_io[35] a_213870_324142# user_project_wrapper_0.IOVSS1 user_project_wrapper_0.IOVSS1 sg13_lv_nmos ad=0.912p pd=5.18u as=0.912p ps=5.18u w=4.8u l=0.13u
X6535 a_304196_197873# a_304889_198885# a_304995_198817# user_project_wrapper_0.IOVSS1 sg13_lv_nmos ad=0.209p pd=1.48u as=0.209p ps=1.48u w=1.1u l=0.15u
X6536 user_project_wrapper_0.IOVSS1 a_182931_326125# user_project_wrapper_0.analog_io[27] user_project_wrapper_0.IOVSS1 sg13_lv_nmos ad=0.912p pd=5.18u as=0.912p ps=5.18u w=4.8u l=0.13u
X6537 user_project_wrapper_0.IOVSS1 user_project_wrapper_0.sg13g2_IOPadVdd_0.sg13g2_RCClampInverter_noptap_0.out VDD3 user_project_wrapper_0.IOVSS1 sg13_hv_nmos ad=1.408p pd=5.04u as=2.596p ps=5.58u w=4.4u l=0.6u
X6538 user_project_wrapper_0.sg13g2_IOPadAnalog_21.padres user_project_wrapper_0.IOVDD4 dpantenna l=0.64u w=4.98u
X6539 user_project_wrapper_0.IOVSS1 user_project_wrapper_0.analog_io[14] dantenna l=1.26u w=27.78u
X6540 a_309516_194555# a_314793_201808# user_project_wrapper_0.IOVSS1 user_project_wrapper_0.IOVSS1 sg13_lv_nmos ad=2.04p pd=12.68u as=1.14p ps=6.38u w=6u l=6.4u
X6541 user_project_wrapper_0.IOVDD1 a_41476_217444# user_project_wrapper_0.analog_io[5] user_project_wrapper_0.IOVDD1 sg13_hv_pmos ad=2.1312p pd=7.3u as=3.9294p ps=7.84u w=6.66u l=0.6u
X6542 a_209684_325263# a_208367_325263# user_project_wrapper_0.IOVSS1 user_project_wrapper_0.IOVSS1 sg13_lv_nmos ad=0.34p pd=2.68u as=0.34p ps=2.68u w=1u l=0.13u
X6543 IOVDD3 a_355624_217444# analog_io[23] IOVDD3 sg13_hv_pmos ad=3.1302p pd=14.26u as=3.9294p ps=7.84u w=6.66u l=0.6u
X6544 a_296732_197880# a_296626_197740# VDD3 VDD3 sg13_lv_pmos ad=1.33p pd=7.38u as=1.33p ps=7.38u w=7u l=0.7u
X6545 user_project_wrapper_0.sg13g2_IOPadAnalog_29.padres analog_io[22] user_project_wrapper_0.IOVSS1 rppd l=2u w=1u
X6546 user_project_wrapper_0.VDD1 a_82645_240231# a_82645_240231# user_project_wrapper_0.VDD1 sg13_lv_pmos ad=1.7p pd=10.68u as=0.95p ps=5.38u w=5u l=0.15u
X6547 user_project_wrapper_0.IOVSS1 a_189672_324776# a_190686_324119# w_188806_323975# sg13_lv_pmos ad=0.68p pd=4.68u as=0.38p ps=2.38u w=2u l=0.13u
X6548 user_project_wrapper_0.sg13g2_IOPadIOVdd_1.sg13g2_Clamp_N43N43D4R_0.gate user_project_wrapper_0.sg13g2_IOPadIOVdd_1.sg13g2_RCClampResistor_0.p2 user_project_wrapper_0.IOVSS1 user_project_wrapper_0.IOVSS1 sg13_hv_nmos ad=1.71p pd=9.38u as=1.71p ps=9.38u w=9u l=0.5u
X6549 user_project_wrapper_0.VDD1 user_project_wrapper_0.sg13g2_IOPadVdd_2.sg13g2_RCClampInverter_noptap_0.out user_project_wrapper_0.IOVSS1 user_project_wrapper_0.IOVSS1 sg13_hv_nmos ad=2.596p pd=5.58u as=1.408p ps=5.04u w=4.4u l=0.6u
X6550 user_project_wrapper_0.IOVSS1 a_369296_156244# analog_io[20] user_project_wrapper_0.IOVSS1 sg13_hv_nmos ad=1.408p pd=5.04u as=2.596p ps=5.58u w=4.4u l=0.6u
X6551 user_project_wrapper_0.IOVSS1 user_project_wrapper_0.sg13g2_IOPadIOVdd_3.sg13g2_Clamp_N43N43D4R_0.gate IOVDD3 user_project_wrapper_0.IOVSS1 sg13_hv_nmos ad=1.408p pd=5.04u as=2.596p ps=5.58u w=4.4u l=0.6u
X6552 user_project_wrapper_0.IOVSS1 user_project_wrapper_0.sg13g2_IOPadVdd_3.sg13g2_RCClampInverter_noptap_0.out user_project_wrapper_0.IOVSS1 user_project_wrapper_0.IOVSS1 sg13_hv_nmos ad=1.408p pd=5.04u as=0 ps=0 w=4.4u l=0.6u
X6553 QDLL_TOP_0.VDD a_190389_99046# user_project_wrapper_0.analog_io[14] QDLL_TOP_0.VDD sg13_lv_pmos ad=0.3808p pd=2.92u as=0.2128p ps=1.5u w=1.12u l=0.13u
X6554 VDD3 a_309516_194555# a_309917_194695# VDD3 sg13_lv_pmos ad=0.19p pd=1.38u as=0.19p ps=1.38u w=1u l=0.7u
X6555 user_project_wrapper_0.IOVSS1 user_project_wrapper_0.sg13g2_IOPadVdd_3.sg13g2_RCClampInverter_noptap_0.out user_project_wrapper_0.IOVSS1 user_project_wrapper_0.IOVSS1 sg13_hv_nmos ad=1.408p pd=5.04u as=0 ps=0 w=4.4u l=0.6u
X6556 user_project_wrapper_0.IOVSS1 user_project_wrapper_0.sg13g2_IOPadVdd_3.sg13g2_RCClampInverter_noptap_0.out user_project_wrapper_0.IOVSS1 user_project_wrapper_0.IOVSS1 sg13_hv_nmos ad=1.408p pd=5.04u as=0 ps=0 w=4.4u l=0.6u
X6557 user_project_wrapper_0.IOVDD2 a_237844_41476# user_project_wrapper_0.analog_io[15] user_project_wrapper_0.IOVDD2 sg13_hv_pmos ad=2.1312p pd=7.3u as=3.9294p ps=7.84u w=6.66u l=0.6u
X6558 user_project_wrapper_0.IOVDD4 a_217444_355624# user_project_wrapper_0.analog_io[32] user_project_wrapper_0.IOVDD4 sg13_hv_pmos ad=2.1312p pd=7.3u as=3.9294p ps=7.84u w=6.66u l=0.6u
X6559 user_project_wrapper_0.IOVSS1 a_202114_326125# user_project_wrapper_0.analog_io[32] user_project_wrapper_0.IOVSS1 sg13_lv_nmos ad=0.912p pd=5.18u as=0.912p ps=5.18u w=4.8u l=0.13u
X6560 a_304196_197873# a_304090_197941# a_296625_189595# user_project_wrapper_0.IOVSS1 sg13_lv_nmos ad=0.361p pd=2.28u as=0.361p ps=2.28u w=1.9u l=0.16u
X6561 VDD3 a_296625_208423# a_296731_208493# VDD3 sg13_lv_pmos ad=0.2603p pd=1.75u as=0.2603p ps=1.75u w=1.37u l=0.35u
X6562 user_project_wrapper_0.IOVDD1 a_41476_197044# user_project_wrapper_0.analog_io[4] user_project_wrapper_0.IOVDD1 sg13_hv_pmos ad=3.1302p pd=14.26u as=3.9294p ps=7.84u w=6.66u l=0.6u
X6563 user_project_wrapper_0.IOVSS1 user_project_wrapper_0.sg13g2_IOPadIOVdd_0.sg13g2_RCClampResistor_0.p2 user_project_wrapper_0.sg13g2_IOPadIOVdd_0.sg13g2_Clamp_N43N43D4R_0.gate user_project_wrapper_0.IOVSS1 sg13_hv_nmos ad=1.71p pd=9.38u as=1.71p ps=9.38u w=9u l=0.5u
X6564 a_296732_200582# a_296626_197740# VDD3 VDD3 sg13_lv_pmos ad=1.33p pd=7.38u as=2.38p ps=14.68u w=7u l=0.7u
X6565 user_project_wrapper_0.analog_io[12] a_176644_41476# user_project_wrapper_0.IOVDD2 user_project_wrapper_0.IOVDD2 sg13_hv_pmos ad=3.9294p pd=7.84u as=2.1312p ps=7.3u w=6.66u l=0.6u
X6566 user_project_wrapper_0.VDD1 a_78218_138195# user_project_wrapper_0.IOVSS1 rppd l=2u w=0.5u
X6567 VDD3 a_309516_194555# a_309917_194695# VDD3 sg13_lv_pmos ad=0.19p pd=1.38u as=0.19p ps=1.38u w=1u l=0.7u
X6568 user_project_wrapper_0.VDD2 user_project_wrapper_0.sg13g2_IOPadVdd_1.sg13g2_RCClampInverter_noptap_0.out user_project_wrapper_0.IOVSS1 user_project_wrapper_0.IOVSS1 sg13_hv_nmos ad=2.596p pd=5.58u as=1.408p ps=5.04u w=4.4u l=0.6u
X6569 user_project_wrapper_0.IOVSS1 user_project_wrapper_0.sg13g2_IOPadVdd_1.sg13g2_RCClampInverter_noptap_0.out user_project_wrapper_0.VDD2 user_project_wrapper_0.IOVSS1 sg13_hv_nmos ad=1.408p pd=5.04u as=2.596p ps=5.58u w=4.4u l=0.6u
X6570 QDLL_TOP_0.VDD a_185968_98275# a_185968_98275# QDLL_TOP_0.VDD sg13_lv_pmos ad=0.7616p pd=5.16u as=0.7616p ps=5.16u w=2.24u l=0.13u
X6571 VDD3 user_project_wrapper_0.sg13g2_IOPadVdd_0.sg13g2_RCClampInverter_noptap_0.out user_project_wrapper_0.IOVSS1 user_project_wrapper_0.IOVSS1 sg13_hv_nmos ad=2.596p pd=5.58u as=1.408p ps=5.04u w=4.4u l=0.6u
X6572 user_project_wrapper_0.IOVSS1 a_278644_29676# QDLL_TOP_0.VOUT user_project_wrapper_0.IOVSS1 sg13_hv_nmos ad=1.408p pd=5.04u as=2.596p ps=5.58u w=4.4u l=0.6u
X6573 a_182931_326125# a_186202_326221# user_project_wrapper_0.IOVSS1 user_project_wrapper_0.IOVSS1 sg13_lv_pmos ad=1.824p pd=9.98u as=1.824p ps=9.98u w=9.6u l=0.13u
X6574 user_project_wrapper_0.IOVSS1 user_project_wrapper_0.sg13g2_IOPadVdd_2.sg13g2_RCClampResistor_0.p2 user_project_wrapper_0.IOVSS1 user_project_wrapper_0.IOVSS1 sg13_hv_nmos ad=1.71p pd=9.38u as=0 ps=0 w=9u l=9.5u
X6575 user_project_wrapper_0.VDD1 user_project_wrapper_0.sg13g2_IOPadVdd_2.sg13g2_RCClampInverter_noptap_0.out user_project_wrapper_0.IOVSS1 user_project_wrapper_0.IOVSS1 sg13_hv_nmos ad=2.596p pd=5.58u as=1.408p ps=5.04u w=4.4u l=0.6u
X6576 IOVDD3 user_project_wrapper_0.sg13g2_IOPadIOVdd_3.sg13g2_Clamp_N43N43D4R_0.gate user_project_wrapper_0.IOVSS1 user_project_wrapper_0.IOVSS1 sg13_hv_nmos ad=2.596p pd=5.58u as=1.408p ps=5.04u w=4.4u l=0.6u
X6577 IOVDD3 user_project_wrapper_0.sg13g2_IOPadIOVdd_3.sg13g2_Clamp_N43N43D4R_0.gate user_project_wrapper_0.IOVSS1 user_project_wrapper_0.IOVSS1 sg13_hv_nmos ad=2.596p pd=5.58u as=1.408p ps=5.04u w=4.4u l=0.6u
X6578 user_project_wrapper_0.IOVSS1 user_project_wrapper_0.IOVSS1 user_project_wrapper_0.IOVSS1 rppd l=0.5u w=0.5u
X6579 user_project_wrapper_0.IOVSS1 a_369296_237844# analog_io[23] user_project_wrapper_0.IOVSS1 sg13_hv_nmos ad=1.408p pd=5.04u as=2.596p ps=5.58u w=4.4u l=0.6u
X6580 a_83796_128838# a_83389_129203# user_project_wrapper_0.IOVSS1 user_project_wrapper_0.IOVSS1 sg13_lv_nmos ad=0.1406p pd=1.12u as=0.2516p ps=2.16u w=0.74u l=0.13u
X6581 analog_io[23] a_355624_217444# IOVDD3 IOVDD3 sg13_hv_pmos ad=3.9294p pd=7.84u as=2.1312p ps=7.3u w=6.66u l=0.6u
X6582 IOVDD3 a_355624_156244# analog_io[20] IOVDD3 sg13_hv_pmos ad=2.1312p pd=7.3u as=3.9294p ps=7.84u w=6.66u l=0.6u
X6583 analog_io[23] a_311108_215937# VDD3 user_project_wrapper_0.IOVSS1 sg13_lv_nmos ad=3.4p pd=20.68u as=3.4p ps=20.68u w=10u l=0.15u
X6584 user_project_wrapper_0.IOVSS1 user_project_wrapper_0.sg13g2_IOPadIOVdd_0.sg13g2_Clamp_N43N43D4R_0.gate user_project_wrapper_0.IOVDD2 user_project_wrapper_0.IOVSS1 sg13_hv_nmos ad=1.408p pd=5.04u as=2.596p ps=5.58u w=4.4u l=0.6u
X6585 user_project_wrapper_0.sg13g2_IOPadIOVdd_3.sg13g2_Clamp_N43N43D4R_0.gate user_project_wrapper_0.sg13g2_IOPadIOVdd_3.sg13g2_RCClampResistor_0.p2 IOVDD3 IOVDD3 sg13_hv_pmos ad=1.33p pd=7.38u as=1.33p ps=7.38u w=7u l=0.5u
X6586 IOVDD3 user_project_wrapper_0.sg13g2_IOPadIOVdd_3.sg13g2_Clamp_N43N43D4R_0.gate user_project_wrapper_0.IOVSS1 user_project_wrapper_0.IOVSS1 sg13_hv_nmos ad=2.596p pd=5.58u as=1.408p ps=5.04u w=4.4u l=0.6u
X6587 IOVDD3 user_project_wrapper_0.sg13g2_IOPadIOVdd_3.sg13g2_Clamp_N43N43D4R_0.gate user_project_wrapper_0.IOVSS1 user_project_wrapper_0.IOVSS1 sg13_hv_nmos ad=2.596p pd=5.58u as=1.408p ps=5.04u w=4.4u l=0.6u
X6588 a_88274_127896# a_86594_127896# user_project_wrapper_0.VDD1 user_project_wrapper_0.VDD1 sg13_lv_pmos ad=0.2128p pd=1.5u as=0.3808p ps=2.92u w=1.12u l=0.13u
X6589 a_82840_127455# a_79025_131741# user_project_wrapper_0.VDD1 user_project_wrapper_0.VDD1 sg13_lv_pmos ad=0.3808p pd=2.92u as=0.3808p ps=2.92u w=1.12u l=0.13u
X6590 IOVDD3 a_355624_258244# analog_io[25] IOVDD3 sg13_hv_pmos ad=2.1312p pd=7.3u as=3.9294p ps=7.84u w=6.66u l=0.6u
X6591 QDLL_TOP_0.VOUT a_271172_100118# QDLL_TOP_0.VDD QDLL_TOP_0.VDD sg13_lv_pmos ad=0.2128p pd=1.5u as=0.2128p ps=1.5u w=1.12u l=0.13u
X6592 a_313884_211353# a_296731_208493# a_311189_211724# user_project_wrapper_0.IOVSS1 sg13_lv_nmos ad=1.9p pd=10.38u as=1.9p ps=10.38u w=10u l=0.5u
X6593 user_project_wrapper_0.IOVSS1 a_301186_192011# a_296731_208493# user_project_wrapper_0.IOVSS1 sg13_lv_nmos ad=0.912p pd=5.18u as=0.912p ps=5.18u w=4.8u l=1.06u
X6594 user_project_wrapper_0.IOVDD1 user_project_wrapper_0.sg13g2_IOPadIOVdd_1.sg13g2_Clamp_N43N43D4R_0.gate user_project_wrapper_0.IOVSS1 user_project_wrapper_0.IOVSS1 sg13_hv_nmos ad=2.596p pd=5.58u as=1.408p ps=5.04u w=4.4u l=0.6u
X6595 VDD3 a_309516_194555# a_309516_194555# VDD3 sg13_lv_pmos ad=0.19p pd=1.38u as=0.19p ps=1.38u w=1u l=0.7u
X6596 user_project_wrapper_0.sg13g2_IOPadAnalog_6.padres user_project_wrapper_0.IOVDD2 dpantenna l=0.64u w=4.98u
X6597 a_314793_198352# a_314697_196700# VDD3 VDD3 sg13_lv_pmos ad=1.14p pd=6.38u as=1.14p ps=6.38u w=6u l=2.5u
X6598 user_project_wrapper_0.IOVSS1 user_project_wrapper_0.sg13g2_IOPadVdd_1.sg13g2_RCClampInverter_noptap_0.out user_project_wrapper_0.VDD2 user_project_wrapper_0.IOVSS1 sg13_hv_nmos ad=1.408p pd=5.04u as=2.596p ps=5.58u w=4.4u l=0.6u
X6599 user_project_wrapper_0.VDD2 user_project_wrapper_0.sg13g2_IOPadVdd_1.sg13g2_RCClampInverter_noptap_0.out user_project_wrapper_0.IOVSS1 user_project_wrapper_0.IOVSS1 sg13_hv_nmos ad=2.596p pd=5.58u as=1.408p ps=5.04u w=4.4u l=0.6u
X6600 a_210621_326377# TOP_ROILIFNEURON_0.MEM user_project_wrapper_0.IOVSS1 rppd l=0.5u w=0.5u
X6601 a_296731_189665# a_296625_189595# VDD3 VDD3 sg13_lv_pmos ad=0.2603p pd=1.75u as=0.4658p ps=3.42u w=1.37u l=0.35u
X6602 a_210109_329327# a_209684_328605# a_210007_328605# user_project_wrapper_0.IOVSS1 sg13_lv_nmos ad=0.19p pd=1.38u as=0.19p ps=1.38u w=1u l=0.13u
X6603 QDLL_TOP_0.VDD a_190389_99046# user_project_wrapper_0.analog_io[14] QDLL_TOP_0.VDD sg13_lv_pmos ad=0.2128p pd=1.5u as=0.2128p ps=1.5u w=1.12u l=0.13u
X6604 QDLL_TOP_0.VDD a_189729_99046# a_190389_99046# QDLL_TOP_0.VDD sg13_lv_pmos ad=0.2128p pd=1.5u as=0.2128p ps=1.5u w=1.12u l=0.13u
X6605 a_296732_197880# a_296626_197740# VDD3 VDD3 sg13_lv_pmos ad=1.33p pd=7.38u as=2.38p ps=14.68u w=7u l=0.7u
X6606 a_296625_208423# a_301940_196388# a_296732_200582# VDD3 sg13_lv_pmos ad=0.7695p pd=4.43u as=0.7695p ps=4.43u w=4.05u l=0.5u
X6607 user_project_wrapper_0.IOVSS1 user_project_wrapper_0.sg13g2_IOPadVdd_2.sg13g2_RCClampResistor_0.p2 user_project_wrapper_0.IOVSS1 user_project_wrapper_0.IOVSS1 sg13_hv_nmos ad=1.71p pd=9.38u as=0 ps=0 w=9u l=9.5u
X6608 a_78218_138195# a_78219_135283# user_project_wrapper_0.IOVSS1 rppd l=2u w=0.5u
X6609 user_project_wrapper_0.IOVSS1 a_237844_29676# user_project_wrapper_0.analog_io[15] user_project_wrapper_0.IOVSS1 sg13_hv_nmos ad=1.408p pd=5.04u as=2.596p ps=5.58u w=4.4u l=0.6u
X6610 user_project_wrapper_0.IOVSS1 a_307232_196607# a_304995_198817# user_project_wrapper_0.IOVSS1 sg13_lv_nmos ad=0.6327p pd=3.71u as=0.6327p ps=3.71u w=3.33u l=0.2u
X6611 user_project_wrapper_0.IOVSS1 user_project_wrapper_0.sg13g2_IOPadVdd_3.sg13g2_RCClampInverter_noptap_0.out user_project_wrapper_0.IOVSS1 user_project_wrapper_0.IOVSS1 sg13_hv_nmos ad=1.408p pd=5.04u as=0 ps=0 w=4.4u l=0.6u
X6612 user_project_wrapper_0.IOVDD4 a_135844_355624# user_project_wrapper_0.IOVDD4 rppd l=12.9u w=0.5u
X6613 user_project_wrapper_0.IOVSS1 a_194687_324142# user_project_wrapper_0.analog_io[30] user_project_wrapper_0.IOVSS1 sg13_lv_pmos ad=1.824p pd=9.98u as=1.824p ps=9.98u w=9.6u l=0.13u
X6614 user_project_wrapper_0.IOVSS1 user_project_wrapper_0.sg13g2_IOPadVdd_0.sg13g2_RCClampInverter_noptap_0.out VDD3 user_project_wrapper_0.IOVSS1 sg13_hv_nmos ad=1.408p pd=5.04u as=2.596p ps=5.58u w=4.4u l=0.6u
X6615 user_project_wrapper_0.IOVSS1 a_182931_326125# user_project_wrapper_0.analog_io[27] user_project_wrapper_0.IOVSS1 sg13_lv_nmos ad=0.912p pd=5.18u as=0.912p ps=5.18u w=4.8u l=0.13u
X6616 analog_io[19] a_355624_135844# IOVDD3 IOVDD3 sg13_hv_pmos ad=3.9294p pd=7.84u as=2.1312p ps=7.3u w=6.66u l=0.6u
X6617 user_project_wrapper_0.analog_io[13] a_197044_41476# user_project_wrapper_0.IOVDD2 user_project_wrapper_0.IOVDD2 sg13_hv_pmos ad=3.9294p pd=7.84u as=2.1312p ps=7.3u w=6.66u l=0.6u
X6618 user_project_wrapper_0.IOVDD2 a_237844_41476# user_project_wrapper_0.analog_io[15] user_project_wrapper_0.IOVDD2 sg13_hv_pmos ad=2.1312p pd=7.3u as=3.9294p ps=7.84u w=6.66u l=0.6u
X6619 QDLL_TOP_0.VOUT a_271172_100118# QDLL_TOP_0.VDD QDLL_TOP_0.VDD sg13_lv_pmos ad=0.2128p pd=1.5u as=0.2128p ps=1.5u w=1.12u l=0.13u
X6620 a_296625_189595# a_301940_196388# a_296732_197880# VDD3 sg13_lv_pmos ad=0.7695p pd=4.43u as=0.7695p ps=4.43u w=4.05u l=0.5u
X6621 a_296731_208493# a_296625_208423# VDD3 VDD3 sg13_lv_pmos ad=0.2603p pd=1.75u as=0.2603p ps=1.75u w=1.37u l=0.35u
X6622 user_project_wrapper_0.IOVSS1 user_project_wrapper_0.sg13g2_IOPadOut4mA$1_1.c2p a_58170_281951# user_project_wrapper_0.IOVSS1 sg13_hv_nmos ad=0.361p pd=2.28u as=0.646p ps=4.48u w=1.9u l=0.45u
X6623 user_project_wrapper_0.analog_io[34] a_258244_369296# user_project_wrapper_0.IOVSS1 user_project_wrapper_0.IOVSS1 sg13_hv_nmos ad=2.596p pd=5.58u as=1.408p ps=5.04u w=4.4u l=0.6u
X6624 a_304196_197873# a_304090_197941# a_296625_189595# user_project_wrapper_0.IOVSS1 sg13_lv_nmos ad=0.361p pd=2.28u as=0.361p ps=2.28u w=1.9u l=0.16u
X6625 user_project_wrapper_0.IOVSS1 a_301186_192011# a_296731_208493# user_project_wrapper_0.IOVSS1 sg13_lv_nmos ad=0.912p pd=5.18u as=0.912p ps=5.18u w=4.8u l=1.06u
X6626 user_project_wrapper_0.IOVSS1 a_176644_369296# user_project_wrapper_0.analog_io[30] user_project_wrapper_0.IOVSS1 sg13_hv_nmos ad=1.408p pd=5.04u as=2.596p ps=5.58u w=4.4u l=0.6u
X6627 user_project_wrapper_0.IOVSS1 user_project_wrapper_0.sg13g2_IOPadIOVdd_1.sg13g2_Clamp_N43N43D4R_0.gate user_project_wrapper_0.IOVDD1 user_project_wrapper_0.IOVSS1 sg13_hv_nmos ad=1.408p pd=5.04u as=2.596p ps=5.58u w=4.4u l=0.6u
X6628 user_project_wrapper_0.IOVSS1 user_project_wrapper_0.sg13g2_IOPadVdd_3.sg13g2_RCClampInverter_noptap_0.out user_project_wrapper_0.IOVSS1 user_project_wrapper_0.IOVSS1 sg13_hv_nmos ad=1.408p pd=5.04u as=0 ps=0 w=4.4u l=0.6u
X6629 user_project_wrapper_0.IOVSS1 user_project_wrapper_0.sg13g2_IOPadVdd_2.sg13g2_RCClampInverter_noptap_0.out user_project_wrapper_0.VDD1 user_project_wrapper_0.IOVSS1 sg13_hv_nmos ad=1.408p pd=5.04u as=2.596p ps=5.58u w=4.4u l=0.6u
X6630 user_project_wrapper_0.analog_io[32] a_217444_355624# user_project_wrapper_0.IOVDD4 user_project_wrapper_0.IOVDD4 sg13_hv_pmos ad=3.9294p pd=7.84u as=2.1312p ps=7.3u w=6.66u l=0.6u
X6631 user_project_wrapper_0.IOVSS1 user_project_wrapper_0.sg13g2_IOPadAnalog_18.padres dantenna l=3.1u w=0.64u
X6632 a_360372_300085# a_364458_299755# user_project_wrapper_0.IOVSS1 rppd l=20u w=1u
X6633 IOVDD3 a_355624_176644# analog_io[20] IOVDD3 sg13_hv_pmos ad=2.1312p pd=7.3u as=3.9294p ps=7.84u w=6.66u l=0.6u
X6634 analog_io[23] a_355624_237844# IOVDD3 IOVDD3 sg13_hv_pmos ad=3.9294p pd=7.84u as=2.1312p ps=7.3u w=6.66u l=0.6u
X6635 a_211928_324776# TOP_ROILIFNEURON_0.MEM user_project_wrapper_0.IOVSS1 w_207989_323975# sg13_lv_pmos ad=0.38p pd=2.38u as=0.38p ps=2.38u w=2u l=0.13u
X6636 user_project_wrapper_0.VDD2 user_project_wrapper_0.sg13g2_IOPadVdd_1.sg13g2_RCClampResistor_0.p2 user_project_wrapper_0.sg13g2_IOPadVdd_1.sg13g2_RCClampInverter_noptap_0.out user_project_wrapper_0.VDD2 sg13_hv_pmos ad=1.33p pd=7.38u as=1.33p ps=7.38u w=7u l=0.5u
X6637 user_project_wrapper_0.analog_io[12] a_176644_41476# user_project_wrapper_0.IOVDD2 user_project_wrapper_0.IOVDD2 sg13_hv_pmos ad=3.9294p pd=7.84u as=2.1312p ps=7.3u w=6.66u l=0.6u
X6638 IOVDD3 user_project_wrapper_0.sg13g2_IOPadIOVdd_3.sg13g2_Clamp_N43N43D4R_0.gate user_project_wrapper_0.IOVSS1 user_project_wrapper_0.IOVSS1 sg13_hv_nmos ad=2.596p pd=5.58u as=1.408p ps=5.04u w=4.4u l=0.6u
X6639 VDD3 a_309516_194555# a_309917_199879# VDD3 sg13_lv_pmos ad=0.19p pd=1.38u as=0.19p ps=1.38u w=1u l=0.7u
X6640 user_project_wrapper_0.uo_PAD[3] user_project_wrapper_0.IOVDD1 dpantenna l=27.78u w=1.26u
X6641 a_83050_125173# a_82872_125209# user_project_wrapper_0.VDD1 user_project_wrapper_0.VDD1 sg13_lv_pmos ad=0.2128p pd=1.5u as=0.3808p ps=2.92u w=1.12u l=0.13u
X6642 a_309917_194695# a_309516_194555# VDD3 VDD3 sg13_lv_pmos ad=0.19p pd=1.38u as=0.34p ps=2.68u w=1u l=0.7u
X6643 a_304995_198817# a_304889_199957# a_304196_200821# user_project_wrapper_0.IOVSS1 sg13_lv_nmos ad=0.209p pd=1.48u as=0.209p ps=1.48u w=1.1u l=0.15u
X6644 a_296731_208493# a_296625_208423# VDD3 VDD3 sg13_lv_pmos ad=0.2603p pd=1.75u as=0.2603p ps=1.75u w=1.37u l=0.35u
X6645 QDLL_TOP_0.VDD a_189395_99046# a_189729_99046# QDLL_TOP_0.VDD sg13_lv_pmos ad=0.3808p pd=2.92u as=0.2128p ps=1.5u w=1.12u l=0.13u
X6646 user_project_wrapper_0.IOVSS1 a_197044_29676# user_project_wrapper_0.analog_io[13] user_project_wrapper_0.IOVSS1 sg13_hv_nmos ad=1.408p pd=5.04u as=2.596p ps=5.58u w=4.4u l=0.6u
X6647 user_project_wrapper_0.analog_io[0] a_29676_115444# user_project_wrapper_0.IOVSS1 user_project_wrapper_0.IOVSS1 sg13_hv_nmos ad=2.596p pd=5.58u as=1.408p ps=5.04u w=4.4u l=0.6u
X6648 user_project_wrapper_0.VDD1 a_79025_133911# a_83389_129203# user_project_wrapper_0.VDD1 sg13_lv_pmos ad=0.3808p pd=2.92u as=0.2128p ps=1.5u w=1.12u l=0.13u
X6649 user_project_wrapper_0.IOVSS1 user_project_wrapper_0.sg13g2_IOPadIOVdd_0.sg13g2_RCClampResistor_0.p2 user_project_wrapper_0.sg13g2_IOPadIOVdd_0.sg13g2_Clamp_N43N43D4R_0.gate user_project_wrapper_0.IOVSS1 sg13_hv_nmos ad=1.71p pd=9.38u as=1.71p ps=9.38u w=9u l=0.5u
X6650 user_project_wrapper_0.analog_io[27] a_182931_326125# user_project_wrapper_0.IOVSS1 user_project_wrapper_0.IOVSS1 sg13_lv_pmos ad=1.824p pd=9.98u as=1.824p ps=9.98u w=9.6u l=0.13u
X6651 user_project_wrapper_0.analog_io[7] a_41476_258244# user_project_wrapper_0.IOVDD1 user_project_wrapper_0.IOVDD1 sg13_hv_pmos ad=3.9294p pd=7.84u as=2.1312p ps=7.3u w=6.66u l=0.6u
X6652 a_35456_303055# a_39542_302725# user_project_wrapper_0.IOVSS1 rppd l=20u w=1u
X6653 user_project_wrapper_0.IOVSS1 user_project_wrapper_0.sg13g2_IOPadVdd_3.sg13g2_RCClampInverter_noptap_0.out user_project_wrapper_0.IOVSS1 user_project_wrapper_0.IOVSS1 sg13_hv_nmos ad=2.596p pd=5.58u as=0 ps=0 w=4.4u l=0.6u
X6654 user_project_wrapper_0.analog_io[34] a_258244_355624# user_project_wrapper_0.IOVDD4 user_project_wrapper_0.IOVDD4 sg13_hv_pmos ad=3.9294p pd=7.84u as=2.1312p ps=7.3u w=6.66u l=0.6u
X6655 user_project_wrapper_0.IOVSS1 user_project_wrapper_0.sg13g2_IOPadVdd_3.sg13g2_RCClampInverter_noptap_0.out user_project_wrapper_0.IOVSS1 user_project_wrapper_0.IOVSS1 sg13_hv_nmos ad=2.596p pd=5.58u as=0 ps=0 w=4.4u l=0.6u
X6656 IOVDD3 a_355624_258244# analog_io[25] IOVDD3 sg13_hv_pmos ad=2.1312p pd=7.3u as=3.9294p ps=7.84u w=6.66u l=0.6u
X6657 user_project_wrapper_0.IOVSS1 a_182931_326125# user_project_wrapper_0.analog_io[27] user_project_wrapper_0.IOVSS1 sg13_lv_nmos ad=0.912p pd=5.18u as=0.912p ps=5.18u w=4.8u l=0.13u
X6658 QDLL_TOP_0.VOUT a_278644_41476# user_project_wrapper_0.IOVDD2 user_project_wrapper_0.IOVDD2 sg13_hv_pmos ad=3.9294p pd=7.84u as=2.1312p ps=7.3u w=6.66u l=0.6u
X6659 user_project_wrapper_0.IOVSS1 QDLL_TOP_0.VOUT dantenna l=1.26u w=27.78u
X6660 user_project_wrapper_0.IOVSS1 a_182931_326125# user_project_wrapper_0.analog_io[27] user_project_wrapper_0.IOVSS1 sg13_lv_nmos ad=0.912p pd=5.18u as=0.912p ps=5.18u w=4.8u l=0.13u
X6661 a_309917_199879# user_project_wrapper_0.sg13g2_IOPadAnalog_29.padres a_311846_195517# VDD3 sg13_lv_pmos ad=0.24415p pd=1.665u as=0.24415p ps=1.665u w=1.285u l=0.35u
X6662 a_309917_194695# a_309516_194555# VDD3 VDD3 sg13_lv_pmos ad=0.19p pd=1.38u as=0.19p ps=1.38u w=1u l=0.7u
X6663 a_209480_325263# a_208939_325263# user_project_wrapper_0.IOVSS1 user_project_wrapper_0.IOVSS1 sg13_lv_nmos ad=0.34p pd=2.68u as=0.34p ps=2.68u w=1u l=0.13u
X6664 VDD3 user_project_wrapper_0.sg13g2_IOPadVdd_0.sg13g2_RCClampInverter_noptap_0.out user_project_wrapper_0.IOVSS1 user_project_wrapper_0.IOVSS1 sg13_hv_nmos ad=2.596p pd=5.58u as=1.408p ps=5.04u w=4.4u l=0.6u
X6665 a_309917_194695# a_296731_189665# a_307232_196607# VDD3 sg13_lv_pmos ad=0.24415p pd=1.665u as=0.24415p ps=1.665u w=1.285u l=0.35u
X6666 a_296732_200582# a_296626_197740# VDD3 VDD3 sg13_lv_pmos ad=1.33p pd=7.38u as=1.33p ps=7.38u w=7u l=0.7u
X6667 user_project_wrapper_0.IOVSS1 user_project_wrapper_0.sg13g2_IOPadIOVdd_0.sg13g2_Clamp_N43N43D4R_0.gate user_project_wrapper_0.IOVDD2 user_project_wrapper_0.IOVSS1 sg13_hv_nmos ad=1.408p pd=5.04u as=2.596p ps=5.58u w=4.4u l=0.6u
X6668 a_76015_364458# a_76345_360372# user_project_wrapper_0.IOVSS1 rppd l=20u w=1u
X6669 user_project_wrapper_0.IOVSS1 user_project_wrapper_0.sg13g2_IOPadVdd_0.sg13g2_RCClampInverter_noptap_0.out dantenna l=0.48u w=0.48u
X6670 user_project_wrapper_0.IOVDD1 a_41476_237844# user_project_wrapper_0.analog_io[6] user_project_wrapper_0.IOVDD1 sg13_hv_pmos ad=2.1312p pd=7.3u as=3.9294p ps=7.84u w=6.66u l=0.6u
X6671 user_project_wrapper_0.IOVSS1 analog_io[26] dantenna l=27.78u w=1.26u
X6672 user_project_wrapper_0.analog_io[28] a_135844_355624# user_project_wrapper_0.IOVDD4 user_project_wrapper_0.IOVDD4 sg13_hv_pmos ad=3.9294p pd=7.84u as=2.1312p ps=7.3u w=6.66u l=0.6u
X6673 a_190501_329719# a_189184_329719# user_project_wrapper_0.IOVSS1 w_188700_330166# sg13_lv_pmos ad=0.68p pd=4.68u as=0.68p ps=4.68u w=2u l=0.13u
X6674 QDLL_TOP_0.VDD a_190389_99046# user_project_wrapper_0.analog_io[14] QDLL_TOP_0.VDD sg13_lv_pmos ad=0.2128p pd=1.5u as=0.2128p ps=1.5u w=1.12u l=0.13u
X6675 a_78220_128592# a_78220_128106# user_project_wrapper_0.IOVSS1 rppd l=2u w=0.5u
X6676 a_91090_129425# a_90579_129060# user_project_wrapper_0.VDD1 user_project_wrapper_0.VDD1 sg13_lv_pmos ad=0.2128p pd=1.5u as=0.3808p ps=2.92u w=1.12u l=0.13u
X6677 user_project_wrapper_0.IOVSS1 user_project_wrapper_0.sg13g2_IOPadVdd_3.sg13g2_RCClampInverter_noptap_0.out user_project_wrapper_0.IOVSS1 user_project_wrapper_0.IOVSS1 sg13_hv_nmos ad=1.408p pd=5.04u as=0 ps=0 w=4.4u l=0.6u
X6678 user_project_wrapper_0.IOVDD1 a_57810_282219# a_58170_281951# user_project_wrapper_0.IOVDD1 sg13_hv_pmos ad=57f pd=0.68u as=0.102p ps=1.28u w=0.3u l=0.45u
X6679 user_project_wrapper_0.IOVSS1 a_202114_326125# user_project_wrapper_0.analog_io[32] user_project_wrapper_0.IOVSS1 sg13_lv_nmos ad=0.912p pd=5.18u as=0.912p ps=5.18u w=4.8u l=0.13u
X6680 VDD3 a_296625_189595# a_296731_189665# VDD3 sg13_lv_pmos ad=0.2603p pd=1.75u as=0.2603p ps=1.75u w=1.37u l=0.35u
X6681 a_309917_199879# a_309516_194555# VDD3 VDD3 sg13_lv_pmos ad=0.19p pd=1.38u as=0.19p ps=1.38u w=1u l=0.7u
X6682 user_project_wrapper_0.IOVDD1 user_project_wrapper_0.sg13g2_IOPadIOVdd_1.sg13g2_Clamp_N43N43D4R_0.gate user_project_wrapper_0.IOVSS1 user_project_wrapper_0.IOVSS1 sg13_hv_nmos ad=2.596p pd=5.58u as=1.408p ps=5.04u w=4.4u l=0.6u
X6683 user_project_wrapper_0.IOVSS1 a_202114_326125# user_project_wrapper_0.analog_io[32] user_project_wrapper_0.IOVSS1 sg13_lv_nmos ad=0.912p pd=5.18u as=0.912p ps=5.18u w=4.8u l=0.13u
X6684 a_208939_327491# a_208103_324155# user_project_wrapper_0.IOVSS1 user_project_wrapper_0.IOVSS1 sg13_lv_nmos ad=0.19p pd=1.38u as=0.34p ps=2.68u w=1u l=0.13u
X6685 user_project_wrapper_0.analog_io[10] a_135844_41476# user_project_wrapper_0.IOVDD2 user_project_wrapper_0.IOVDD2 sg13_hv_pmos ad=3.9294p pd=7.84u as=2.1312p ps=7.3u w=6.66u l=0.6u
X6686 user_project_wrapper_0.IOVSS1 a_307232_196607# a_304995_198817# user_project_wrapper_0.IOVSS1 sg13_lv_nmos ad=0.6327p pd=3.71u as=0.6327p ps=3.71u w=3.33u l=0.2u
X6687 a_304995_198817# a_304889_199957# a_304196_200821# user_project_wrapper_0.IOVSS1 sg13_lv_nmos ad=0.209p pd=1.48u as=0.209p ps=1.48u w=1.1u l=0.15u
X6688 user_project_wrapper_0.IOVSS1 a_186202_326221# a_182931_326125# user_project_wrapper_0.IOVSS1 sg13_lv_nmos ad=0.912p pd=5.18u as=0.912p ps=5.18u w=4.8u l=0.13u
X6689 a_313884_211353# analog_io[23] a_311108_215937# user_project_wrapper_0.IOVSS1 sg13_lv_nmos ad=3.4p pd=20.68u as=1.9p ps=10.38u w=10u l=0.5u
X6690 user_project_wrapper_0.IOVDD4 user_project_wrapper_0.sg13g2_IOPadIOVdd_2.sg13g2_Clamp_N43N43D4R_0.gate user_project_wrapper_0.IOVSS1 user_project_wrapper_0.IOVSS1 sg13_hv_nmos ad=2.596p pd=5.58u as=1.408p ps=5.04u w=4.4u l=0.6u
X6691 a_304196_200821# a_304090_197941# a_296625_208423# user_project_wrapper_0.IOVSS1 sg13_lv_nmos ad=0.646p pd=4.48u as=0.361p ps=2.28u w=1.9u l=0.16u
X6692 IOVDD3 user_project_wrapper_0.sg13g2_IOPadIOVdd_3.sg13g2_Clamp_N43N43D4R_0.gate user_project_wrapper_0.IOVSS1 user_project_wrapper_0.IOVSS1 sg13_hv_nmos ad=2.596p pd=5.58u as=1.408p ps=5.04u w=4.4u l=0.6u
X6693 user_project_wrapper_0.IOVDD4 user_project_wrapper_0.sg13g2_IOPadIOVdd_2.sg13g2_Clamp_N43N43D4R_0.gate user_project_wrapper_0.IOVSS1 user_project_wrapper_0.IOVSS1 sg13_hv_nmos ad=2.596p pd=5.58u as=1.408p ps=5.04u w=4.4u l=0.6u
X6694 user_project_wrapper_0.analog_io[12] a_176644_29676# user_project_wrapper_0.IOVSS1 user_project_wrapper_0.IOVSS1 sg13_hv_nmos ad=2.596p pd=5.58u as=1.408p ps=5.04u w=4.4u l=0.6u
X6695 IOVDD3 a_355624_217444# analog_io[23] IOVDD3 sg13_hv_pmos ad=2.1312p pd=7.3u as=3.9294p ps=7.84u w=6.66u l=0.6u
X6696 user_project_wrapper_0.IOVSS1 a_190297_326377# a_190926_327099# user_project_wrapper_0.IOVSS1 sg13_lv_nmos ad=0.34p pd=2.68u as=0.19p ps=1.38u w=1u l=0.13u
X6697 a_309917_199879# a_309516_194555# VDD3 VDD3 sg13_lv_pmos ad=0.19p pd=1.38u as=0.19p ps=1.38u w=1u l=0.7u
X6698 user_project_wrapper_0.IOVSS1 user_project_wrapper_0.sg13g2_IOPadVdd_3.sg13g2_RCClampInverter_noptap_0.out user_project_wrapper_0.IOVSS1 user_project_wrapper_0.IOVSS1 sg13_hv_nmos ad=2.596p pd=5.58u as=0 ps=0 w=4.4u l=0.6u
X6699 user_project_wrapper_0.IOVSS1 user_project_wrapper_0.sg13g2_IOPadVdd_3.sg13g2_RCClampInverter_noptap_0.out user_project_wrapper_0.IOVSS1 user_project_wrapper_0.IOVSS1 sg13_hv_nmos ad=2.596p pd=5.58u as=0 ps=0 w=4.4u l=0.6u
X6700 VDD3 a_309516_194555# a_309917_194695# VDD3 sg13_lv_pmos ad=0.19p pd=1.38u as=0.19p ps=1.38u w=1u l=0.7u
X6701 VDD3 a_296625_208423# a_296731_208493# VDD3 sg13_lv_pmos ad=0.2603p pd=1.75u as=0.2603p ps=1.75u w=1.37u l=0.35u
X6702 VDD3 a_296625_189595# a_296731_189665# VDD3 sg13_lv_pmos ad=0.2603p pd=1.75u as=0.2603p ps=1.75u w=1.37u l=0.35u
X6703 user_project_wrapper_0.analog_io[30] a_176644_369296# user_project_wrapper_0.IOVSS1 user_project_wrapper_0.IOVSS1 sg13_hv_nmos ad=2.596p pd=5.58u as=1.408p ps=5.04u w=4.4u l=0.6u
X6704 user_project_wrapper_0.sg13g2_IOPadVdd_1.sg13g2_RCClampInverter_noptap_0.out user_project_wrapper_0.sg13g2_IOPadVdd_1.sg13g2_RCClampResistor_0.p2 user_project_wrapper_0.IOVSS1 user_project_wrapper_0.IOVSS1 sg13_hv_nmos ad=1.71p pd=9.38u as=1.71p ps=9.38u w=9u l=0.5u
X6705 user_project_wrapper_0.IOVSS1 a_211928_324776# a_208855_324776# user_project_wrapper_0.IOVSS1 sg13_lv_nmos ad=0.19p pd=1.38u as=0.19p ps=1.38u w=1u l=0.13u
X6706 user_project_wrapper_0.IOVSS1 user_project_wrapper_0.sg13g2_IOPadIOVdd_3.sg13g2_RCClampResistor_0.p2 user_project_wrapper_0.IOVSS1 user_project_wrapper_0.IOVSS1 sg13_hv_nmos ad=1.71p pd=9.38u as=0 ps=0 w=9u l=9.5u
X6707 analog_io[22] a_369296_197044# user_project_wrapper_0.IOVSS1 user_project_wrapper_0.IOVSS1 sg13_hv_nmos ad=2.596p pd=5.58u as=1.408p ps=5.04u w=4.4u l=0.6u
X6708 VDD3 a_309516_194555# a_309516_194555# VDD3 sg13_lv_pmos ad=0.34p pd=2.68u as=0.19p ps=1.38u w=1u l=0.7u
X6709 a_305035_364458# a_304705_360372# user_project_wrapper_0.IOVSS1 rppd l=20u w=1u
X6710 user_project_wrapper_0.IOVSS1 a_191800_324119# a_191462_324119# w_188806_323975# sg13_lv_pmos ad=0.68p pd=4.68u as=0.68p ps=4.68u w=2u l=0.65u
X6711 a_210007_326377# a_208367_326377# a_209905_327099# user_project_wrapper_0.IOVSS1 sg13_lv_nmos ad=0.19p pd=1.38u as=0.19p ps=1.38u w=1u l=0.13u
X6712 VDD3 a_296625_208423# a_296731_208493# VDD3 sg13_lv_pmos ad=0.2603p pd=1.75u as=0.2603p ps=1.75u w=1.37u l=0.35u
X6713 a_304995_198817# a_304889_198885# a_304196_197873# user_project_wrapper_0.IOVSS1 sg13_lv_nmos ad=0.209p pd=1.48u as=0.209p ps=1.48u w=1.1u l=0.15u
X6714 user_project_wrapper_0.IOVSS1 user_project_wrapper_0.sg13g2_IOPadVdd_3.sg13g2_RCClampInverter_noptap_0.out user_project_wrapper_0.IOVSS1 user_project_wrapper_0.IOVSS1 sg13_hv_nmos ad=2.596p pd=5.58u as=0 ps=0 w=4.4u l=0.6u
X6715 a_79038_127856# a_78220_128106# a_79025_129164# user_project_wrapper_0.VDD1 sg13_lv_pmos ad=0.95p pd=5.38u as=1.7p ps=10.68u w=5u l=0.3u
X6716 user_project_wrapper_0.IOVSS1 user_project_wrapper_0.sg13g2_IOPadVdd_2.sg13g2_RCClampInverter_noptap_0.out user_project_wrapper_0.VDD1 user_project_wrapper_0.IOVSS1 sg13_hv_nmos ad=1.408p pd=5.04u as=2.596p ps=5.58u w=4.4u l=0.6u
X6717 user_project_wrapper_0.IOVSS1 user_project_wrapper_0.sg13g2_IOPadIOVdd_3.sg13g2_Clamp_N43N43D4R_0.gate IOVDD3 user_project_wrapper_0.IOVSS1 sg13_hv_nmos ad=1.408p pd=5.04u as=2.596p ps=5.58u w=4.4u l=0.6u
X6718 user_project_wrapper_0.sg13g2_IOPadOut4mA$1_1.sg13g2_GateLevelUpInv_noptap$1$1_0.pgate a_57810_282219# user_project_wrapper_0.IOVSS1 user_project_wrapper_0.IOVSS1 sg13_hv_nmos ad=0.646p pd=4.48u as=0.646p ps=4.48u w=1.9u l=0.45u
X6719 VDD3 a_296625_189595# a_296731_189665# VDD3 sg13_lv_pmos ad=0.2603p pd=1.75u as=0.2603p ps=1.75u w=1.37u l=0.35u
X6720 user_project_wrapper_0.IOVSS1 user_project_wrapper_0.sg13g2_IOPadIOVdd_3.sg13g2_Clamp_N43N43D4R_0.gate IOVDD3 user_project_wrapper_0.IOVSS1 sg13_hv_nmos ad=1.408p pd=5.04u as=2.596p ps=5.58u w=4.4u l=0.6u
X6721 a_296732_197880# a_296626_197740# VDD3 VDD3 sg13_lv_pmos ad=1.33p pd=7.38u as=1.33p ps=7.38u w=7u l=0.7u
X6722 a_79025_133504# a_78824_133051# user_project_wrapper_0.VDD1 user_project_wrapper_0.VDD1 sg13_lv_pmos ad=0.95p pd=5.38u as=1.7p ps=10.68u w=5u l=0.15u
X6723 user_project_wrapper_0.IOVSS1 user_project_wrapper_0.sg13g2_IOPadVdd_2.sg13g2_RCClampResistor_0.p2 user_project_wrapper_0.sg13g2_IOPadVdd_2.sg13g2_RCClampInverter_noptap_0.out user_project_wrapper_0.IOVSS1 sg13_hv_nmos ad=1.71p pd=9.38u as=1.71p ps=9.38u w=9u l=0.5u
X6724 user_project_wrapper_0.IOVSS1 user_project_wrapper_0.sg13g2_IOPadVdd_0.sg13g2_RCClampInverter_noptap_0.out VDD3 user_project_wrapper_0.IOVSS1 sg13_hv_nmos ad=1.408p pd=5.04u as=2.596p ps=5.58u w=4.4u l=0.6u
X6725 a_186202_326221# a_187018_328627# user_project_wrapper_0.IOVSS1 user_project_wrapper_0.IOVSS1 sg13_lv_pmos ad=1.824p pd=9.98u as=1.824p ps=9.98u w=9.6u l=0.13u
X6726 a_270178_100118# a_269931_100182# user_project_wrapper_0.IOVSS1 user_project_wrapper_0.IOVSS1 sg13_lv_nmos ad=0.2516p pd=2.16u as=0.1405p ps=1.15u w=0.74u l=0.13u
X6727 VDD3 a_296625_208423# a_296731_208493# VDD3 sg13_lv_pmos ad=0.2603p pd=1.75u as=0.2603p ps=1.75u w=1.37u l=0.35u
X6728 user_project_wrapper_0.sg13g2_IOPadIOVdd_0.sg13g2_Clamp_N43N43D4R_0.gate user_project_wrapper_0.sg13g2_IOPadIOVdd_0.sg13g2_RCClampResistor_0.p2 user_project_wrapper_0.IOVDD2 user_project_wrapper_0.IOVDD2 sg13_hv_pmos ad=1.33p pd=7.38u as=1.33p ps=7.38u w=7u l=0.5u
X6729 a_296731_189665# a_301186_192011# user_project_wrapper_0.IOVSS1 user_project_wrapper_0.IOVSS1 sg13_lv_nmos ad=0.912p pd=5.18u as=0.912p ps=5.18u w=4.8u l=1.06u
X6730 VDD3 a_296625_208423# a_296731_208493# VDD3 sg13_lv_pmos ad=0.2603p pd=1.75u as=0.2603p ps=1.75u w=1.37u l=0.35u
X6731 user_project_wrapper_0.analog_io[35] a_213870_324142# user_project_wrapper_0.IOVSS1 user_project_wrapper_0.IOVSS1 sg13_lv_pmos ad=1.824p pd=9.98u as=1.824p ps=9.98u w=9.6u l=0.13u
X6732 a_311846_195517# user_project_wrapper_0.sg13g2_IOPadAnalog_29.padres a_309917_194695# VDD3 sg13_lv_pmos ad=0.24415p pd=1.665u as=0.24415p ps=1.665u w=1.285u l=0.35u
X6733 VDD3 user_project_wrapper_0.sg13g2_IOPadVdd_0.sg13g2_RCClampResistor_0.p2 user_project_wrapper_0.sg13g2_IOPadVdd_0.sg13g2_RCClampInverter_noptap_0.out VDD3 sg13_hv_pmos ad=1.33p pd=7.38u as=1.33p ps=7.38u w=7u l=0.5u
X6734 user_project_wrapper_0.IOVDD2 a_156244_41476# user_project_wrapper_0.analog_io[11] user_project_wrapper_0.IOVDD2 sg13_hv_pmos ad=2.1312p pd=7.3u as=3.9294p ps=7.84u w=6.66u l=0.6u
X6735 user_project_wrapper_0.IOVSS1 user_project_wrapper_0.sg13g2_IOPadIOVdd_0.sg13g2_Clamp_N43N43D4R_0.gate user_project_wrapper_0.IOVDD2 user_project_wrapper_0.IOVSS1 sg13_hv_nmos ad=1.408p pd=5.04u as=2.596p ps=5.58u w=4.4u l=0.6u
X6736 user_project_wrapper_0.IOVSS1 user_project_wrapper_0.sg13g2_IOPadIOVdd_3.sg13g2_RCClampResistor_0.p2 user_project_wrapper_0.IOVSS1 user_project_wrapper_0.IOVSS1 sg13_hv_nmos ad=1.71p pd=9.38u as=0 ps=0 w=9u l=9.5u
X6737 a_92512_127896# a_91911_127530# a_92512_127531# user_project_wrapper_0.IOVSS1 sg13_lv_nmos ad=0.2516p pd=2.16u as=0.1406p ps=1.12u w=0.74u l=0.13u
X6738 a_296731_189665# a_296625_189595# VDD3 VDD3 sg13_lv_pmos ad=0.2603p pd=1.75u as=0.2603p ps=1.75u w=1.37u l=0.35u
X6739 user_project_wrapper_0.analog_io[5] a_29676_217444# user_project_wrapper_0.IOVSS1 user_project_wrapper_0.IOVSS1 sg13_hv_nmos ad=2.596p pd=5.58u as=1.408p ps=5.04u w=4.4u l=0.6u
X6740 QDLL_TOP_0.VOUT a_278644_41476# user_project_wrapper_0.IOVDD2 user_project_wrapper_0.IOVDD2 sg13_hv_pmos ad=3.9294p pd=7.84u as=2.1312p ps=7.3u w=6.66u l=0.6u
X6741 user_project_wrapper_0.IOVDD4 a_217444_355624# user_project_wrapper_0.analog_io[32] user_project_wrapper_0.IOVDD4 sg13_hv_pmos ad=2.1312p pd=7.3u as=3.9294p ps=7.84u w=6.66u l=0.6u
X6742 user_project_wrapper_0.IOVSS1 a_191124_324119# a_190757_324686# w_188806_323975# sg13_lv_pmos ad=0.68p pd=4.68u as=0.68p ps=4.68u w=2u l=0.65u
X6743 a_309917_194695# a_309516_194555# VDD3 VDD3 sg13_lv_pmos ad=0.19p pd=1.38u as=0.19p ps=1.38u w=1u l=0.7u
X6744 a_307232_196607# a_296731_208493# a_309917_199879# VDD3 sg13_lv_pmos ad=0.4369p pd=3.25u as=0.24415p ps=1.665u w=1.285u l=0.35u
X6745 a_237844_41476# user_project_wrapper_0.IOVDD2 user_project_wrapper_0.IOVDD2 rppd l=12.9u w=0.5u
X6746 a_83164_127820# a_79025_127401# a_83164_127455# user_project_wrapper_0.IOVSS1 sg13_lv_nmos ad=0.2516p pd=2.16u as=0.1406p ps=1.12u w=0.74u l=0.13u
X6747 user_project_wrapper_0.IOVSS1 a_135844_369296# user_project_wrapper_0.analog_io[28] user_project_wrapper_0.IOVSS1 sg13_hv_nmos ad=1.408p pd=5.04u as=2.596p ps=5.58u w=4.4u l=0.6u
X6748 VDD3 a_311108_215937# analog_io[23] user_project_wrapper_0.IOVSS1 sg13_lv_nmos ad=3.4p pd=20.68u as=3.4p ps=20.68u w=10u l=0.15u
X6749 user_project_wrapper_0.sg13g2_IOPadIOVdd_2.sg13g2_Clamp_N43N43D4R_0.gate user_project_wrapper_0.sg13g2_IOPadIOVdd_2.sg13g2_RCClampResistor_0.p2 user_project_wrapper_0.IOVSS1 user_project_wrapper_0.IOVSS1 sg13_hv_nmos ad=1.71p pd=9.38u as=3.06p ps=18.68u w=9u l=0.5u
X6750 user_project_wrapper_0.IOVSS1 user_project_wrapper_0.IOVSS1 user_project_wrapper_0.IOVSS1 rppd l=0.5u w=0.5u
X6751 IOVDD3 a_355624_135844# analog_io[19] IOVDD3 sg13_hv_pmos ad=2.1312p pd=7.3u as=3.9294p ps=7.84u w=6.66u l=0.6u
X6752 analog_io[22] a_355624_197044# IOVDD3 IOVDD3 sg13_hv_pmos ad=3.9294p pd=7.84u as=2.1312p ps=7.3u w=6.66u l=0.6u
X6753 a_85989_241383# a_86046_241645# a_85989_241748# user_project_wrapper_0.VDD1 sg13_lv_pmos ad=0.3808p pd=2.92u as=0.2128p ps=1.5u w=1.12u l=0.13u
X6754 user_project_wrapper_0.IOVSS1 user_project_wrapper_0.sg13g2_IOPadVdd_3.sg13g2_RCClampInverter_noptap_0.out user_project_wrapper_0.IOVSS1 user_project_wrapper_0.IOVSS1 sg13_hv_nmos ad=2.068p pd=9.74u as=0 ps=0 w=4.4u l=0.6u
X6755 user_project_wrapper_0.IOVSS1 user_project_wrapper_0.sg13g2_IOPadIOVdd_0.sg13g2_Clamp_N43N43D4R_0.gate user_project_wrapper_0.IOVDD2 user_project_wrapper_0.IOVSS1 sg13_hv_nmos ad=1.408p pd=5.04u as=2.596p ps=5.58u w=4.4u l=0.6u
X6756 user_project_wrapper_0.analog_io[35] a_278644_355624# user_project_wrapper_0.IOVDD4 user_project_wrapper_0.IOVDD4 sg13_hv_pmos ad=3.9294p pd=7.84u as=2.1312p ps=7.3u w=6.66u l=0.6u
X6757 user_project_wrapper_0.analog_io[27] a_115444_355624# user_project_wrapper_0.IOVDD4 user_project_wrapper_0.IOVDD4 sg13_hv_pmos ad=3.9294p pd=7.84u as=2.1312p ps=7.3u w=6.66u l=0.6u
X6758 QDLL_TOP_0.VOUT a_271172_100118# QDLL_TOP_0.VDD QDLL_TOP_0.VDD sg13_lv_pmos ad=0.2128p pd=1.5u as=0.2128p ps=1.5u w=1.12u l=0.13u
X6759 user_project_wrapper_0.IOVSS1 user_project_wrapper_0.sg13g2_IOPadIOVdd_1.sg13g2_Clamp_N43N43D4R_0.gate user_project_wrapper_0.IOVDD1 user_project_wrapper_0.IOVSS1 sg13_hv_nmos ad=1.408p pd=5.04u as=2.596p ps=5.58u w=4.4u l=0.6u
X6760 user_project_wrapper_0.IOVSS1 user_project_wrapper_0.IOVSS1 user_project_wrapper_0.IOVSS1 rppd l=0.5u w=0.5u
X6761 user_project_wrapper_0.IOVDD2 a_197044_41476# user_project_wrapper_0.analog_io[13] user_project_wrapper_0.IOVDD2 sg13_hv_pmos ad=2.1312p pd=7.3u as=3.9294p ps=7.84u w=6.66u l=0.6u
X6762 user_project_wrapper_0.IOVDD4 a_258244_355624# user_project_wrapper_0.analog_io[34] user_project_wrapper_0.IOVDD4 sg13_hv_pmos ad=2.1312p pd=7.3u as=3.9294p ps=7.84u w=6.66u l=0.6u
X6763 user_project_wrapper_0.analog_io[10] a_135844_41476# user_project_wrapper_0.IOVDD2 user_project_wrapper_0.IOVDD2 sg13_hv_pmos ad=3.9294p pd=7.84u as=2.1312p ps=7.3u w=6.66u l=0.6u
X6764 a_79038_137002# a_79038_136536# user_project_wrapper_0.IOVSS1 user_project_wrapper_0.IOVSS1 sg13_lv_nmos ad=0.1428p pd=1.52u as=0.1428p ps=1.52u w=0.42u l=0.56u
X6765 user_project_wrapper_0.sg13g2_IOPadAnalog_17.padres user_project_wrapper_0.IOVDD4 dpantenna l=0.64u w=4.98u
X6766 user_project_wrapper_0.IOVSS1 a_209480_326377# a_210109_327099# user_project_wrapper_0.IOVSS1 sg13_lv_nmos ad=0.34p pd=2.68u as=0.19p ps=1.38u w=1u l=0.13u
X6767 user_project_wrapper_0.IOVSS1 a_237844_29676# user_project_wrapper_0.analog_io[15] user_project_wrapper_0.IOVSS1 sg13_hv_nmos ad=1.408p pd=5.04u as=2.596p ps=5.58u w=4.4u l=0.6u
X6768 user_project_wrapper_0.IOVSS1 user_project_wrapper_0.sg13g2_IOPadIOVdd_3.sg13g2_Clamp_N43N43D4R_0.gate IOVDD3 user_project_wrapper_0.IOVSS1 sg13_hv_nmos ad=1.408p pd=5.04u as=2.596p ps=5.58u w=4.4u l=0.6u
X6769 analog_io[19] a_369296_135844# user_project_wrapper_0.IOVSS1 user_project_wrapper_0.IOVSS1 sg13_hv_nmos ad=2.596p pd=5.58u as=1.408p ps=5.04u w=4.4u l=0.6u
X6770 user_project_wrapper_0.IOVDD1 user_project_wrapper_0.sg13g2_IOPadIOVdd_1.sg13g2_Clamp_N43N43D4R_0.gate user_project_wrapper_0.IOVSS1 user_project_wrapper_0.IOVSS1 sg13_hv_nmos ad=3.256p pd=10.28u as=1.408p ps=5.04u w=4.4u l=0.6u
X6771 VDD3 user_project_wrapper_0.sg13g2_IOPadVdd_0.sg13g2_RCClampInverter_noptap_0.out user_project_wrapper_0.IOVSS1 user_project_wrapper_0.IOVSS1 sg13_hv_nmos ad=2.596p pd=5.58u as=1.408p ps=5.04u w=4.4u l=0.6u
X6772 a_296731_189665# a_296625_189595# VDD3 VDD3 sg13_lv_pmos ad=0.2603p pd=1.75u as=0.2603p ps=1.75u w=1.37u l=0.35u
X6773 user_project_wrapper_0.IOVSS1 user_project_wrapper_0.sg13g2_IOPadIOVdd_2.sg13g2_RCClampResistor_0.p2 user_project_wrapper_0.IOVSS1 user_project_wrapper_0.IOVSS1 sg13_hv_nmos ad=1.71p pd=9.38u as=0 ps=0 w=9u l=9.5u
X6774 user_project_wrapper_0.IOVSS1 user_project_wrapper_0.sg13g2_IOPadVdd_0.sg13g2_RCClampResistor_0.p2 user_project_wrapper_0.sg13g2_IOPadVdd_0.sg13g2_RCClampInverter_noptap_0.out user_project_wrapper_0.IOVSS1 sg13_hv_nmos ad=1.71p pd=9.38u as=1.71p ps=9.38u w=9u l=0.5u
X6775 user_project_wrapper_0.IOVSS1 a_194687_324142# user_project_wrapper_0.analog_io[30] user_project_wrapper_0.IOVSS1 sg13_lv_pmos ad=1.824p pd=9.98u as=1.824p ps=9.98u w=9.6u l=0.13u
X6776 user_project_wrapper_0.VDD1 user_project_wrapper_0.sg13g2_IOPadVdd_2.sg13g2_RCClampInverter_noptap_0.out user_project_wrapper_0.IOVSS1 user_project_wrapper_0.IOVSS1 sg13_hv_nmos ad=2.596p pd=5.58u as=1.408p ps=5.04u w=4.4u l=0.6u
X6777 a_296625_208423# a_301940_196388# a_296732_200582# VDD3 sg13_lv_pmos ad=0.7695p pd=4.43u as=0.7695p ps=4.43u w=4.05u l=0.5u
X6778 user_project_wrapper_0.analog_io[27] a_182931_326125# user_project_wrapper_0.IOVSS1 user_project_wrapper_0.IOVSS1 sg13_lv_pmos ad=1.824p pd=9.98u as=1.824p ps=9.98u w=9.6u l=0.13u
X6779 user_project_wrapper_0.IOVSS1 a_210983_324119# a_210645_324119# w_207989_323975# sg13_lv_pmos ad=0.68p pd=4.68u as=0.68p ps=4.68u w=2u l=0.65u
X6780 a_86046_241645# a_85989_241383# user_project_wrapper_0.IOVSS1 user_project_wrapper_0.IOVSS1 sg13_lv_nmos ad=0.1406p pd=1.12u as=0.2516p ps=2.16u w=0.74u l=0.13u
X6781 user_project_wrapper_0.IOVDD4 a_135844_355624# user_project_wrapper_0.analog_io[28] user_project_wrapper_0.IOVDD4 sg13_hv_pmos ad=2.1312p pd=7.3u as=3.9294p ps=7.84u w=6.66u l=0.6u
X6782 user_project_wrapper_0.IOVDD2 a_156244_41476# user_project_wrapper_0.analog_io[11] user_project_wrapper_0.IOVDD2 sg13_hv_pmos ad=2.1312p pd=7.3u as=3.9294p ps=7.84u w=6.66u l=0.6u
X6783 user_project_wrapper_0.sg13g2_IOPadIOVdd_3.sg13g2_Clamp_N43N43D4R_0.gate user_project_wrapper_0.sg13g2_IOPadIOVdd_3.sg13g2_RCClampResistor_0.p2 IOVDD3 IOVDD3 sg13_hv_pmos ad=1.33p pd=7.38u as=1.33p ps=7.38u w=7u l=0.5u
X6784 user_project_wrapper_0.sg13g2_IOPadVdd_3.sg13g2_RCClampInverter_noptap_0.out user_project_wrapper_0.sg13g2_IOPadVdd_3.sg13g2_RCClampResistor_0.p2 user_project_wrapper_0.IOVSS1 user_project_wrapper_0.IOVSS1 sg13_hv_pmos ad=1.33p pd=7.38u as=1.33p ps=7.38u w=7u l=0.5u
X6785 a_85155_125209# a_85052_125418# user_project_wrapper_0.IOVSS1 user_project_wrapper_0.IOVSS1 sg13_lv_nmos ad=0.1406p pd=1.12u as=0.2516p ps=2.16u w=0.74u l=0.13u
X6786 user_project_wrapper_0.VDD1 a_87434_129426# a_89114_129426# user_project_wrapper_0.VDD1 sg13_lv_pmos ad=0.3808p pd=2.92u as=0.2128p ps=1.5u w=1.12u l=0.13u
X6787 user_project_wrapper_0.analog_io[1] a_29676_135844# user_project_wrapper_0.IOVSS1 user_project_wrapper_0.IOVSS1 sg13_hv_nmos ad=2.596p pd=5.58u as=1.408p ps=5.04u w=4.4u l=0.6u
X6788 user_project_wrapper_0.IOVSS1 a_194687_324142# user_project_wrapper_0.analog_io[30] user_project_wrapper_0.IOVSS1 sg13_lv_pmos ad=1.824p pd=9.98u as=1.824p ps=9.98u w=9.6u l=0.13u
X6789 user_project_wrapper_0.IOVSS1 user_project_wrapper_0.sg13g2_IOPadVdd_3.sg13g2_RCClampInverter_noptap_0.out user_project_wrapper_0.IOVSS1 user_project_wrapper_0.IOVSS1 sg13_hv_nmos ad=2.596p pd=5.58u as=0 ps=0 w=4.4u l=0.6u
X6790 user_project_wrapper_0.IOVSS1 user_project_wrapper_0.sg13g2_IOPadVdd_3.sg13g2_RCClampInverter_noptap_0.out user_project_wrapper_0.IOVSS1 user_project_wrapper_0.IOVSS1 sg13_hv_nmos ad=2.596p pd=5.58u as=0 ps=0 w=4.4u l=0.6u
X6791 user_project_wrapper_0.IOVDD4 a_237844_355624# user_project_wrapper_0.analog_io[33] user_project_wrapper_0.IOVDD4 sg13_hv_pmos ad=2.1312p pd=7.3u as=3.9294p ps=7.84u w=6.66u l=0.6u
X6792 user_project_wrapper_0.analog_io[28] user_project_wrapper_0.IOVDD4 dpantenna l=1.26u w=27.78u
X6793 user_project_wrapper_0.IOVSS1 a_182931_326125# user_project_wrapper_0.analog_io[27] user_project_wrapper_0.IOVSS1 sg13_lv_nmos ad=0.912p pd=5.18u as=0.912p ps=5.18u w=4.8u l=0.13u
X6794 a_85287_241383# a_82846_243261# user_project_wrapper_0.IOVSS1 user_project_wrapper_0.IOVSS1 sg13_lv_nmos ad=0.2516p pd=2.16u as=0.2516p ps=2.16u w=0.74u l=0.13u
X6795 a_296731_208493# a_296625_208423# VDD3 VDD3 sg13_lv_pmos ad=0.2603p pd=1.75u as=0.4658p ps=3.42u w=1.37u l=0.35u
X6796 VDD3 user_project_wrapper_0.sg13g2_IOPadVdd_0.sg13g2_RCClampResistor_0.p2 user_project_wrapper_0.sg13g2_IOPadVdd_0.sg13g2_RCClampInverter_noptap_0.out VDD3 sg13_hv_pmos ad=1.33p pd=7.38u as=1.33p ps=7.38u w=7u l=0.5u
X6797 a_296731_189665# a_296625_189595# VDD3 VDD3 sg13_lv_pmos ad=0.2603p pd=1.75u as=0.4658p ps=3.42u w=1.37u l=0.35u
X6798 user_project_wrapper_0.IOVSS1 user_project_wrapper_0.sg13g2_IOPadIOVdd_3.sg13g2_RCClampResistor_0.p2 user_project_wrapper_0.IOVSS1 user_project_wrapper_0.IOVSS1 sg13_hv_nmos ad=1.71p pd=9.38u as=0 ps=0 w=9u l=9.5u
X6799 user_project_wrapper_0.IOVSS1 user_project_wrapper_0.sg13g2_IOPadVdd_2.sg13g2_RCClampResistor_0.p2 user_project_wrapper_0.IOVSS1 user_project_wrapper_0.IOVSS1 sg13_hv_nmos ad=1.71p pd=9.38u as=0 ps=0 w=9u l=9.5u
X6800 user_project_wrapper_0.IOVSS1 a_182931_326125# user_project_wrapper_0.analog_io[27] user_project_wrapper_0.IOVSS1 sg13_lv_nmos ad=0.912p pd=5.18u as=0.912p ps=5.18u w=4.8u l=0.13u
X6801 a_208469_329719# a_208367_325263# a_208367_329719# user_project_wrapper_0.IOVSS1 sg13_lv_nmos ad=0.19p pd=1.38u as=0.19p ps=1.38u w=1u l=0.13u
X6802 a_296731_189665# a_296625_189595# VDD3 VDD3 sg13_lv_pmos ad=0.2603p pd=1.75u as=0.2603p ps=1.75u w=1.37u l=0.35u
X6803 VDD3 a_296625_189595# a_296731_189665# VDD3 sg13_lv_pmos ad=0.4658p pd=3.42u as=0.2603p ps=1.75u w=1.37u l=0.35u
X6804 VDD3 a_309516_194555# a_309516_194555# VDD3 sg13_lv_pmos ad=0.19p pd=1.38u as=0.19p ps=1.38u w=1u l=0.7u
X6805 user_project_wrapper_0.VDD1 user_project_wrapper_0.sg13g2_IOPadOut4mA$1_1.c2p a_58798_281249# user_project_wrapper_0.VDD1 sg13_lv_pmos ad=1.615p pd=10.18u as=1.615p ps=10.18u w=4.75u l=0.13u
X6806 user_project_wrapper_0.IOVSS1 user_project_wrapper_0.ui_PAD[2] dantenna l=1.26u w=27.78u
X6807 user_project_wrapper_0.VDD2 user_project_wrapper_0.sg13g2_IOPadVdd_1.sg13g2_RCClampInverter_noptap_0.out user_project_wrapper_0.IOVSS1 user_project_wrapper_0.IOVSS1 sg13_hv_nmos ad=2.596p pd=5.58u as=1.408p ps=5.04u w=4.4u l=0.6u
X6808 VDD3 a_309516_194555# a_309917_199879# VDD3 sg13_lv_pmos ad=0.19p pd=1.38u as=0.19p ps=1.38u w=1u l=0.7u
X6809 analog_io[20] a_311108_179669# VDD3 user_project_wrapper_0.IOVSS1 sg13_lv_nmos ad=3.4p pd=20.68u as=3.4p ps=20.68u w=10u l=0.15u
X6810 user_project_wrapper_0.sg13g2_IOPadVdd_1.sg13g2_RCClampInverter_noptap_0.out user_project_wrapper_0.sg13g2_IOPadVdd_1.sg13g2_RCClampResistor_0.p2 user_project_wrapper_0.IOVSS1 user_project_wrapper_0.IOVSS1 sg13_hv_nmos ad=1.71p pd=9.38u as=1.71p ps=9.38u w=9u l=0.5u
X6811 user_project_wrapper_0.IOVSS1 user_project_wrapper_0.sg13g2_IOPadIOVdd_2.sg13g2_Clamp_N43N43D4R_0.gate user_project_wrapper_0.IOVDD4 user_project_wrapper_0.IOVSS1 sg13_hv_nmos ad=1.408p pd=5.04u as=2.596p ps=5.58u w=4.4u l=0.6u
X6812 user_project_wrapper_0.IOVDD4 a_176644_355624# user_project_wrapper_0.analog_io[30] user_project_wrapper_0.IOVDD4 sg13_hv_pmos ad=2.1312p pd=7.3u as=3.9294p ps=7.84u w=6.66u l=0.6u
X6813 user_project_wrapper_0.analog_io[27] a_182931_326125# user_project_wrapper_0.IOVSS1 user_project_wrapper_0.IOVSS1 sg13_lv_pmos ad=1.824p pd=9.98u as=1.824p ps=9.98u w=9.6u l=0.13u
X6814 QDLL_TOP_0.VOUT a_278644_29676# user_project_wrapper_0.IOVSS1 user_project_wrapper_0.IOVSS1 sg13_hv_nmos ad=2.596p pd=5.58u as=1.408p ps=5.04u w=4.4u l=0.6u
X6815 a_189016_99480# a_188760_99480# user_project_wrapper_0.IOVSS1 user_project_wrapper_0.IOVSS1 sg13_lv_nmos ad=0.1428p pd=1.52u as=0.1323p ps=1.05u w=0.42u l=0.18u
X6816 user_project_wrapper_0.sg13g2_IOPadIOVdd_3.sg13g2_Clamp_N43N43D4R_0.gate user_project_wrapper_0.sg13g2_IOPadIOVdd_3.sg13g2_RCClampResistor_0.p2 IOVDD3 IOVDD3 sg13_hv_pmos ad=1.33p pd=7.38u as=1.33p ps=7.38u w=7u l=0.5u
X6817 a_270512_100118# a_270178_100118# user_project_wrapper_0.IOVSS1 user_project_wrapper_0.IOVSS1 sg13_lv_nmos ad=0.1406p pd=1.12u as=0.1406p ps=1.12u w=0.74u l=0.13u
X6818 a_190297_329719# a_189756_329719# user_project_wrapper_0.IOVSS1 w_188700_330166# sg13_lv_pmos ad=0.68p pd=4.68u as=0.68p ps=4.68u w=2u l=0.13u
X6819 a_296731_189665# a_296625_189595# VDD3 VDD3 sg13_lv_pmos ad=0.2603p pd=1.75u as=0.4658p ps=3.42u w=1.37u l=0.35u
X6820 user_project_wrapper_0.IOVSS1 user_project_wrapper_0.sg13g2_IOPadIOVdd_3.sg13g2_RCClampResistor_0.p2 user_project_wrapper_0.IOVSS1 user_project_wrapper_0.IOVSS1 sg13_hv_nmos ad=1.71p pd=9.38u as=0 ps=0 w=9u l=9.5u
X6821 VDD3 user_project_wrapper_0.sg13g2_IOPadVdd_0.sg13g2_RCClampInverter_noptap_0.out user_project_wrapper_0.IOVSS1 user_project_wrapper_0.IOVSS1 sg13_hv_nmos ad=2.596p pd=5.58u as=1.408p ps=5.04u w=4.4u l=0.6u
X6822 user_project_wrapper_0.IOVSS1 a_176644_369296# user_project_wrapper_0.analog_io[30] user_project_wrapper_0.IOVSS1 sg13_hv_nmos ad=1.408p pd=5.04u as=2.596p ps=5.58u w=4.4u l=0.6u
X6823 user_project_wrapper_0.VDD2 user_project_wrapper_0.sg13g2_IOPadVdd_1.sg13g2_RCClampInverter_noptap_0.out user_project_wrapper_0.IOVSS1 user_project_wrapper_0.IOVSS1 sg13_hv_nmos ad=2.596p pd=5.58u as=1.408p ps=5.04u w=4.4u l=0.6u
X6824 user_project_wrapper_0.IOVSS1 a_314793_197200# analog_io[20] user_project_wrapper_0.IOVSS1 sg13_lv_nmos ad=1.02p pd=6.68u as=1.02p ps=6.68u w=3u l=1u
X6825 user_project_wrapper_0.IOVSS1 user_project_wrapper_0.sg13g2_IOPadVdd_3.sg13g2_RCClampInverter_noptap_0.out user_project_wrapper_0.IOVSS1 user_project_wrapper_0.IOVSS1 sg13_hv_nmos ad=1.408p pd=5.04u as=0 ps=0 w=4.4u l=0.6u
X6826 user_project_wrapper_0.IOVSS1 a_202114_326125# user_project_wrapper_0.analog_io[32] user_project_wrapper_0.IOVSS1 sg13_lv_nmos ad=0.912p pd=5.18u as=0.912p ps=5.18u w=4.8u l=0.13u
X6827 user_project_wrapper_0.ui_PAD[31] user_project_wrapper_0.IOVDD4 dpantenna l=27.78u w=1.26u
X6828 user_project_wrapper_0.analog_io[4] a_41476_197044# user_project_wrapper_0.IOVDD1 user_project_wrapper_0.IOVDD1 sg13_hv_pmos ad=3.9294p pd=7.84u as=2.1312p ps=7.3u w=6.66u l=0.6u
X6829 user_project_wrapper_0.sg13g2_IOPadAnalog_27.padres IOVDD3 dpantenna l=4.98u w=0.64u
X6830 a_90579_129060# a_83492_127455# user_project_wrapper_0.VDD1 user_project_wrapper_0.VDD1 sg13_lv_pmos ad=0.3808p pd=2.92u as=0.3808p ps=2.92u w=1.12u l=0.13u
X6831 user_project_wrapper_0.IOVSS1 a_208017_326341# a_209041_330241# w_207883_330166# sg13_lv_pmos ad=0.68p pd=4.68u as=0.38p ps=2.38u w=2u l=0.13u
X6832 VDD3 a_296625_189595# a_296731_189665# VDD3 sg13_lv_pmos ad=0.2603p pd=1.75u as=0.2603p ps=1.75u w=1.37u l=0.35u
X6833 user_project_wrapper_0.IOVSS1 a_186202_326221# a_182931_326125# user_project_wrapper_0.IOVSS1 sg13_lv_nmos ad=0.912p pd=5.18u as=0.912p ps=5.18u w=4.8u l=0.13u
X6834 user_project_wrapper_0.IOVDD4 user_project_wrapper_0.sg13g2_IOPadIOVdd_2.sg13g2_Clamp_N43N43D4R_0.gate user_project_wrapper_0.IOVSS1 user_project_wrapper_0.IOVSS1 sg13_hv_nmos ad=2.596p pd=5.58u as=1.408p ps=5.04u w=4.4u l=0.6u
X6835 user_project_wrapper_0.analog_io[11] a_156244_41476# user_project_wrapper_0.IOVDD2 user_project_wrapper_0.IOVDD2 sg13_hv_pmos ad=3.9294p pd=7.84u as=2.1312p ps=7.3u w=6.66u l=0.6u
X6836 user_project_wrapper_0.analog_io[6] a_41476_237844# user_project_wrapper_0.IOVDD1 user_project_wrapper_0.IOVDD1 sg13_hv_pmos ad=3.9294p pd=7.84u as=2.1312p ps=7.3u w=6.66u l=0.6u
X6837 user_project_wrapper_0.analog_io[35] a_213870_324142# user_project_wrapper_0.IOVSS1 user_project_wrapper_0.IOVSS1 sg13_lv_nmos ad=0.912p pd=5.18u as=0.912p ps=5.18u w=4.8u l=0.13u
X6838 user_project_wrapper_0.IOVSS1 user_project_wrapper_0.IOVSS1 user_project_wrapper_0.IOVSS1 rppd l=0.5u w=0.5u
X6839 user_project_wrapper_0.IOVSS1 a_182931_326125# user_project_wrapper_0.analog_io[27] user_project_wrapper_0.IOVSS1 sg13_lv_nmos ad=0.912p pd=5.18u as=0.912p ps=5.18u w=4.8u l=0.13u
X6840 user_project_wrapper_0.IOVDD2 user_project_wrapper_0.sg13g2_IOPadIOVdd_0.sg13g2_Clamp_N43N43D4R_0.gate user_project_wrapper_0.IOVSS1 user_project_wrapper_0.IOVSS1 sg13_hv_nmos ad=2.596p pd=5.58u as=1.408p ps=5.04u w=4.4u l=0.6u
X6841 user_project_wrapper_0.IOVDD2 user_project_wrapper_0.sg13g2_IOPadIOVdd_0.sg13g2_Clamp_N43N43D4R_0.gate user_project_wrapper_0.IOVSS1 user_project_wrapper_0.IOVSS1 sg13_hv_nmos ad=2.596p pd=5.58u as=1.408p ps=5.04u w=4.4u l=0.6u
X6842 IOVDD3 a_355624_115444# analog_io[18] IOVDD3 sg13_hv_pmos ad=2.1312p pd=7.3u as=3.9294p ps=7.84u w=6.66u l=0.6u
X6843 a_82846_242854# user_project_wrapper_0.analog_io[4] a_82859_241546# user_project_wrapper_0.VDD1 sg13_lv_pmos ad=1.7p pd=10.68u as=0.95p ps=5.38u w=5u l=0.3u
X6844 a_296625_189595# a_304090_197941# a_304196_197873# user_project_wrapper_0.IOVSS1 sg13_lv_nmos ad=0.361p pd=2.28u as=0.646p ps=4.48u w=1.9u l=0.16u
X6845 user_project_wrapper_0.IOVDD4 user_project_wrapper_0.sg13g2_IOPadIOVdd_2.sg13g2_Clamp_N43N43D4R_0.gate user_project_wrapper_0.IOVSS1 user_project_wrapper_0.IOVSS1 sg13_hv_nmos ad=2.596p pd=5.58u as=1.408p ps=5.04u w=4.4u l=0.6u
X6846 a_189858_329327# a_189756_329719# a_189756_328605# user_project_wrapper_0.IOVSS1 sg13_lv_nmos ad=0.19p pd=1.38u as=0.19p ps=1.38u w=1u l=0.13u
X6847 user_project_wrapper_0.IOVDD2 user_project_wrapper_0.sg13g2_IOPadIOVdd_0.sg13g2_Clamp_N43N43D4R_0.gate user_project_wrapper_0.IOVSS1 user_project_wrapper_0.IOVSS1 sg13_hv_nmos ad=2.596p pd=5.58u as=1.408p ps=5.04u w=4.4u l=0.6u
X6848 user_project_wrapper_0.IOVDD4 user_project_wrapper_0.sg13g2_IOPadIOVdd_2.sg13g2_Clamp_N43N43D4R_0.gate user_project_wrapper_0.IOVSS1 user_project_wrapper_0.IOVSS1 sg13_hv_nmos ad=2.596p pd=5.58u as=1.408p ps=5.04u w=4.4u l=0.6u
X6849 user_project_wrapper_0.IOVDD2 a_258244_41476# user_project_wrapper_0.analog_io[16] user_project_wrapper_0.IOVDD2 sg13_hv_pmos ad=2.1312p pd=7.3u as=3.9294p ps=7.84u w=6.66u l=0.6u
X6850 user_project_wrapper_0.IOVSS1 a_189729_99046# a_190389_99046# user_project_wrapper_0.IOVSS1 sg13_lv_nmos ad=0.1406p pd=1.12u as=0.1406p ps=1.12u w=0.74u l=0.13u
X6851 user_project_wrapper_0.IOVSS1 user_project_wrapper_0.sg13g2_IOPadIOVdd_3.sg13g2_Clamp_N43N43D4R_0.gate IOVDD3 user_project_wrapper_0.IOVSS1 sg13_hv_nmos ad=1.408p pd=5.04u as=2.596p ps=5.58u w=4.4u l=0.6u
X6852 user_project_wrapper_0.sg13g2_IOPadIOVdd_2.sg13g2_Clamp_N43N43D4R_0.gate user_project_wrapper_0.sg13g2_IOPadIOVdd_2.sg13g2_RCClampResistor_0.p2 user_project_wrapper_0.IOVSS1 user_project_wrapper_0.IOVSS1 sg13_hv_nmos ad=1.71p pd=9.38u as=3.06p ps=18.68u w=9u l=0.5u
X6853 user_project_wrapper_0.analog_io[10] a_135844_41476# user_project_wrapper_0.IOVDD2 user_project_wrapper_0.IOVDD2 sg13_hv_pmos ad=3.9294p pd=7.84u as=2.1312p ps=7.3u w=6.66u l=0.6u
X6854 analog_io[25] a_369296_258244# user_project_wrapper_0.IOVSS1 user_project_wrapper_0.IOVSS1 sg13_hv_nmos ad=2.596p pd=5.58u as=2.068p ps=9.74u w=4.4u l=0.6u
X6855 VDD3 a_296625_189595# a_296731_189665# VDD3 sg13_lv_pmos ad=0.2603p pd=1.75u as=0.2603p ps=1.75u w=1.37u l=0.35u
X6856 user_project_wrapper_0.sg13g2_IOPadIOVdd_3.sg13g2_Clamp_N43N43D4R_0.gate user_project_wrapper_0.sg13g2_IOPadIOVdd_3.sg13g2_RCClampResistor_0.p2 IOVDD3 IOVDD3 sg13_hv_pmos ad=1.33p pd=7.38u as=1.33p ps=7.38u w=7u l=0.5u
X6857 user_project_wrapper_0.IOVSS1 user_project_wrapper_0.analog_io[35] dantenna l=1.26u w=27.78u
X6858 a_304196_200821# a_304889_199957# a_304995_198817# user_project_wrapper_0.IOVSS1 sg13_lv_nmos ad=0.209p pd=1.48u as=0.209p ps=1.48u w=1.1u l=0.15u
X6859 user_project_wrapper_0.sg13g2_IOPadVdd_3.sg13g2_RCClampInverter_noptap_0.out user_project_wrapper_0.sg13g2_IOPadVdd_3.sg13g2_RCClampResistor_0.p2 user_project_wrapper_0.IOVSS1 user_project_wrapper_0.IOVSS1 sg13_hv_pmos ad=1.33p pd=7.38u as=1.33p ps=7.38u w=7u l=0.5u
X6860 a_190824_329719# a_190501_329719# a_190722_330241# w_188700_330166# sg13_lv_pmos ad=0.38p pd=2.38u as=0.38p ps=2.38u w=2u l=0.13u
X6861 user_project_wrapper_0.VDD2 user_project_wrapper_0.sg13g2_IOPadVdd_1.sg13g2_RCClampInverter_noptap_0.out user_project_wrapper_0.IOVSS1 user_project_wrapper_0.IOVSS1 sg13_hv_nmos ad=2.596p pd=5.58u as=1.408p ps=5.04u w=4.4u l=0.6u
X6862 user_project_wrapper_0.IOVDD2 user_project_wrapper_0.sg13g2_IOPadIOVdd_0.sg13g2_Clamp_N43N43D4R_0.gate user_project_wrapper_0.IOVSS1 user_project_wrapper_0.IOVSS1 sg13_hv_nmos ad=2.596p pd=5.58u as=1.408p ps=5.04u w=4.4u l=0.6u
X6863 user_project_wrapper_0.IOVSS1 a_301186_192011# a_296731_189665# user_project_wrapper_0.IOVSS1 sg13_lv_nmos ad=0.912p pd=5.18u as=0.912p ps=5.18u w=4.8u l=1.06u
X6864 user_project_wrapper_0.IOVSS1 user_project_wrapper_0.IOVSS1 dantenna l=1.26u w=27.78u
X6865 a_78824_133051# user_project_wrapper_0.sg13g2_IOPadAnalog_8.padres user_project_wrapper_0.IOVSS1 user_project_wrapper_0.IOVSS1 sg13_lv_nmos ad=0.17p pd=1.68u as=0.17p ps=1.68u w=0.5u l=0.15u
X6866 VDD3 a_296625_208423# a_296731_208493# VDD3 sg13_lv_pmos ad=0.4658p pd=3.42u as=0.2603p ps=1.75u w=1.37u l=0.35u
X6867 user_project_wrapper_0.analog_io[4] a_82118_239118# user_project_wrapper_0.IOVSS1 rppd l=2u w=0.5u
X6868 VDD3 a_309516_194555# a_309917_194695# VDD3 sg13_lv_pmos ad=0.19p pd=1.38u as=0.19p ps=1.38u w=1u l=0.7u
X6869 user_project_wrapper_0.IOVSS1 user_project_wrapper_0.sg13g2_IOPadIOVdd_2.sg13g2_Clamp_N43N43D4R_0.gate user_project_wrapper_0.IOVDD4 user_project_wrapper_0.IOVSS1 sg13_hv_nmos ad=1.408p pd=5.04u as=2.596p ps=5.58u w=4.4u l=0.6u
X6870 user_project_wrapper_0.IOVSS1 a_202114_326125# user_project_wrapper_0.analog_io[32] user_project_wrapper_0.IOVSS1 sg13_lv_nmos ad=0.912p pd=5.18u as=0.912p ps=5.18u w=4.8u l=0.13u
X6871 a_309917_194695# a_309516_194555# VDD3 VDD3 sg13_lv_pmos ad=0.19p pd=1.38u as=0.19p ps=1.38u w=1u l=0.7u
X6872 user_project_wrapper_0.IOVSS1 user_project_wrapper_0.sg13g2_IOPadIn$1_2.p2c a_189609_324119# user_project_wrapper_0.IOVSS1 sg13_lv_nmos ad=0.34p pd=2.68u as=0.19p ps=1.38u w=1u l=0.13u
X6873 user_project_wrapper_0.IOVDD4 a_278644_355624# user_project_wrapper_0.analog_io[35] user_project_wrapper_0.IOVDD4 sg13_hv_pmos ad=2.1312p pd=7.3u as=3.9294p ps=7.84u w=6.66u l=0.6u
X6874 a_311846_195517# a_311846_195517# user_project_wrapper_0.IOVSS1 user_project_wrapper_0.IOVSS1 sg13_lv_nmos ad=0.6327p pd=3.71u as=0.6327p ps=3.71u w=3.33u l=0.2u
X6875 user_project_wrapper_0.IOVDD4 a_115444_355624# user_project_wrapper_0.analog_io[27] user_project_wrapper_0.IOVDD4 sg13_hv_pmos ad=2.1312p pd=7.3u as=3.9294p ps=7.84u w=6.66u l=0.6u
X6876 VDD3 a_311108_215937# analog_io[23] user_project_wrapper_0.IOVSS1 sg13_lv_nmos ad=3.4p pd=20.68u as=3.4p ps=20.68u w=10u l=0.15u
X6877 a_78824_128711# user_project_wrapper_0.sg13g2_IOPadAnalog_8.padres user_project_wrapper_0.IOVSS1 user_project_wrapper_0.IOVSS1 sg13_lv_nmos ad=0.17p pd=1.68u as=0.17p ps=1.68u w=0.5u l=0.15u
X6878 user_project_wrapper_0.IOVSS1 a_369296_176644# analog_io[20] user_project_wrapper_0.IOVSS1 sg13_hv_nmos ad=1.408p pd=5.04u as=2.596p ps=5.58u w=4.4u l=0.6u
X6879 user_project_wrapper_0.analog_io[35] a_213870_324142# user_project_wrapper_0.IOVSS1 user_project_wrapper_0.IOVSS1 sg13_lv_pmos ad=1.824p pd=9.98u as=1.824p ps=9.98u w=9.6u l=0.13u
X6880 user_project_wrapper_0.IOVSS1 user_project_wrapper_0.sg13g2_IOPadVdd_3.sg13g2_RCClampInverter_noptap_0.out user_project_wrapper_0.IOVSS1 user_project_wrapper_0.IOVSS1 sg13_hv_nmos ad=2.596p pd=5.58u as=0 ps=0 w=4.4u l=0.6u
X6881 user_project_wrapper_0.analog_io[28] a_135844_355624# user_project_wrapper_0.IOVDD4 user_project_wrapper_0.IOVDD4 sg13_hv_pmos ad=3.9294p pd=7.84u as=2.1312p ps=7.3u w=6.66u l=0.6u
X6882 user_project_wrapper_0.IOVSS1 a_29676_217444# user_project_wrapper_0.analog_io[5] user_project_wrapper_0.IOVSS1 sg13_hv_nmos ad=1.408p pd=5.04u as=2.596p ps=5.58u w=4.4u l=0.6u
X6883 user_project_wrapper_0.IOVSS1 user_project_wrapper_0.sg13g2_IOPadIOVdd_2.sg13g2_RCClampResistor_0.p2 user_project_wrapper_0.IOVSS1 user_project_wrapper_0.IOVSS1 sg13_hv_nmos ad=1.71p pd=9.38u as=0 ps=0 w=9u l=9.5u
X6884 a_208939_326377# user_project_wrapper_0.IOVSS1 user_project_wrapper_0.IOVSS1 w_207887_326203# sg13_lv_pmos ad=0.38p pd=2.38u as=0.68p ps=4.68u w=2u l=0.13u
X6885 a_355624_237844# IOVDD3 IOVDD3 rppd l=12.9u w=0.5u
X6886 user_project_wrapper_0.IOVDD2 user_project_wrapper_0.sg13g2_IOPadIOVdd_0.sg13g2_Clamp_N43N43D4R_0.gate user_project_wrapper_0.IOVSS1 user_project_wrapper_0.IOVSS1 sg13_hv_nmos ad=2.596p pd=5.58u as=1.408p ps=5.04u w=4.4u l=0.6u
X6887 a_360372_298765# a_364458_298435# user_project_wrapper_0.IOVSS1 rppd l=20u w=1u
X6888 user_project_wrapper_0.VDD1 a_79025_127401# a_83164_127820# user_project_wrapper_0.VDD1 sg13_lv_pmos ad=0.3808p pd=2.92u as=0.2128p ps=1.5u w=1.12u l=0.13u
X6889 VDD3 a_311108_179669# analog_io[20] user_project_wrapper_0.IOVSS1 sg13_lv_nmos ad=3.4p pd=20.68u as=3.4p ps=20.68u w=10u l=0.15u
X6890 user_project_wrapper_0.VDD2 user_project_wrapper_0.sg13g2_IOPadVdd_1.sg13g2_RCClampResistor_0.p2 user_project_wrapper_0.sg13g2_IOPadVdd_1.sg13g2_RCClampInverter_noptap_0.out user_project_wrapper_0.VDD2 sg13_hv_pmos ad=1.33p pd=7.38u as=1.33p ps=7.38u w=7u l=0.5u
X6891 user_project_wrapper_0.VDD1 user_project_wrapper_0.sg13g2_IOPadVdd_2.sg13g2_RCClampInverter_noptap_0.out user_project_wrapper_0.IOVSS1 user_project_wrapper_0.IOVSS1 sg13_hv_nmos ad=2.596p pd=5.58u as=1.408p ps=5.04u w=4.4u l=0.6u
X6892 analog_io[26] IOVDD3 dpantenna l=27.78u w=1.26u
X6893 user_project_wrapper_0.analog_io[1] a_41476_135844# user_project_wrapper_0.IOVDD1 user_project_wrapper_0.IOVDD1 sg13_hv_pmos ad=3.9294p pd=7.84u as=2.1312p ps=7.3u w=6.66u l=0.6u
X6894 analog_io[18] a_355624_115444# IOVDD3 IOVDD3 sg13_hv_pmos ad=3.9294p pd=7.84u as=2.1312p ps=7.3u w=6.66u l=0.6u
X6895 a_296732_197880# a_301940_196388# a_296625_189595# VDD3 sg13_lv_pmos ad=1.377p pd=8.78u as=0.7695p ps=4.43u w=4.05u l=0.5u
X6896 user_project_wrapper_0.sg13g2_IOPadIOVdd_0.sg13g2_Clamp_N43N43D4R_0.gate user_project_wrapper_0.sg13g2_IOPadIOVdd_0.sg13g2_RCClampResistor_0.p2 user_project_wrapper_0.IOVDD2 user_project_wrapper_0.IOVDD2 sg13_hv_pmos ad=1.33p pd=7.38u as=1.33p ps=7.38u w=7u l=0.5u
X6897 user_project_wrapper_0.IOVDD2 user_project_wrapper_0.sg13g2_IOPadIOVdd_0.sg13g2_Clamp_N43N43D4R_0.gate user_project_wrapper_0.IOVSS1 user_project_wrapper_0.IOVSS1 sg13_hv_nmos ad=2.596p pd=5.58u as=2.068p ps=9.74u w=4.4u l=0.6u
X6898 user_project_wrapper_0.IOVSS1 a_369296_258244# analog_io[25] user_project_wrapper_0.IOVSS1 sg13_hv_nmos ad=1.408p pd=5.04u as=2.596p ps=5.58u w=4.4u l=0.6u
X6899 a_360372_77665# a_364458_77335# user_project_wrapper_0.IOVSS1 rppd l=20u w=1u
X6900 user_project_wrapper_0.IOVDD1 user_project_wrapper_0.sg13g2_IOPadIOVdd_1.sg13g2_Clamp_N43N43D4R_0.gate user_project_wrapper_0.IOVSS1 user_project_wrapper_0.IOVSS1 sg13_hv_nmos ad=2.596p pd=5.58u as=1.408p ps=5.04u w=4.4u l=0.6u
X6901 user_project_wrapper_0.IOVDD2 a_258244_41476# user_project_wrapper_0.analog_io[16] user_project_wrapper_0.IOVDD2 sg13_hv_pmos ad=2.1312p pd=7.3u as=3.9294p ps=7.84u w=6.66u l=0.6u
X6902 QDLL_TOP_0.VDD a_270512_100118# a_271172_100118# QDLL_TOP_0.VDD sg13_lv_pmos ad=0.3808p pd=2.92u as=0.2184p ps=1.51u w=1.12u l=0.13u
X6903 user_project_wrapper_0.sg13g2_IOPadVdd_0.sg13g2_RCClampInverter_noptap_0.out user_project_wrapper_0.sg13g2_IOPadVdd_0.sg13g2_RCClampResistor_0.p2 user_project_wrapper_0.IOVSS1 user_project_wrapper_0.IOVSS1 sg13_hv_nmos ad=1.71p pd=9.38u as=1.71p ps=9.38u w=9u l=0.5u
X6904 user_project_wrapper_0.analog_io[35] a_213870_324142# user_project_wrapper_0.IOVSS1 user_project_wrapper_0.IOVSS1 sg13_lv_pmos ad=1.824p pd=9.98u as=1.824p ps=9.98u w=9.6u l=0.13u
X6905 user_project_wrapper_0.analog_io[27] a_115444_355624# user_project_wrapper_0.IOVDD4 user_project_wrapper_0.IOVDD4 sg13_hv_pmos ad=3.9294p pd=7.84u as=3.1302p ps=14.26u w=6.66u l=0.6u
X6906 user_project_wrapper_0.IOVSS1 user_project_wrapper_0.sg13g2_IOPadVdd_2.sg13g2_RCClampResistor_0.p2 user_project_wrapper_0.sg13g2_IOPadVdd_2.sg13g2_RCClampInverter_noptap_0.out user_project_wrapper_0.IOVSS1 sg13_hv_nmos ad=1.71p pd=9.38u as=1.71p ps=9.38u w=9u l=0.5u
X6907 user_project_wrapper_0.analog_io[13] a_197044_41476# user_project_wrapper_0.IOVDD2 user_project_wrapper_0.IOVDD2 sg13_hv_pmos ad=3.9294p pd=7.84u as=2.1312p ps=7.3u w=6.66u l=0.6u
X6908 analog_io[20] a_369296_176644# user_project_wrapper_0.IOVSS1 user_project_wrapper_0.IOVSS1 sg13_hv_nmos ad=2.596p pd=5.58u as=1.408p ps=5.04u w=4.4u l=0.6u
X6909 user_project_wrapper_0.VDD1 a_82433_130212# a_83398_130212# user_project_wrapper_0.VDD1 sg13_lv_pmos ad=0.3808p pd=2.92u as=0.2128p ps=1.5u w=1.12u l=0.13u
X6910 a_313884_185173# analog_io[20] a_311108_179669# user_project_wrapper_0.IOVSS1 sg13_lv_nmos ad=1.9p pd=10.38u as=1.9p ps=10.38u w=10u l=0.5u
X6911 a_296625_208423# a_301940_196388# a_296732_200582# VDD3 sg13_lv_pmos ad=0.7695p pd=4.43u as=0.7695p ps=4.43u w=4.05u l=0.5u
X6912 user_project_wrapper_0.IOVSS1 user_project_wrapper_0.sg13g2_IOPadVdd_2.sg13g2_RCClampInverter_noptap_0.out user_project_wrapper_0.VDD1 user_project_wrapper_0.IOVSS1 sg13_hv_nmos ad=1.408p pd=5.04u as=2.596p ps=5.58u w=4.4u l=0.6u
X6913 user_project_wrapper_0.sg13g2_IOPadIOVdd_0.sg13g2_Clamp_N43N43D4R_0.gate user_project_wrapper_0.sg13g2_IOPadIOVdd_0.sg13g2_RCClampResistor_0.p2 user_project_wrapper_0.IOVDD2 user_project_wrapper_0.IOVDD2 sg13_hv_pmos ad=1.33p pd=7.38u as=1.33p ps=7.38u w=7u l=0.5u
X6914 a_369296_197044# user_project_wrapper_0.IOVSS1 user_project_wrapper_0.IOVSS1 rppd l=3.54u w=0.5u
X6915 a_296732_197880# a_301940_196388# a_296625_189595# VDD3 sg13_lv_pmos ad=0.7695p pd=4.43u as=0.7695p ps=4.43u w=4.05u l=0.5u
X6916 user_project_wrapper_0.analog_io[0] a_41476_115444# user_project_wrapper_0.IOVDD1 user_project_wrapper_0.IOVDD1 sg13_hv_pmos ad=3.9294p pd=7.84u as=2.1312p ps=7.3u w=6.66u l=0.6u
X6917 a_309917_194695# a_309516_194555# VDD3 VDD3 sg13_lv_pmos ad=0.19p pd=1.38u as=0.19p ps=1.38u w=1u l=0.7u
X6918 VDD3 user_project_wrapper_0.sg13g2_IOPadVdd_0.sg13g2_RCClampInverter_noptap_0.out user_project_wrapper_0.IOVSS1 user_project_wrapper_0.IOVSS1 sg13_hv_nmos ad=2.596p pd=5.58u as=1.408p ps=5.04u w=4.4u l=0.6u
X6919 a_189729_99046# a_189395_99046# user_project_wrapper_0.IOVSS1 user_project_wrapper_0.IOVSS1 sg13_lv_nmos ad=0.1406p pd=1.12u as=0.1406p ps=1.12u w=0.74u l=0.13u
X6920 a_213870_324142# a_213462_327536# user_project_wrapper_0.IOVSS1 user_project_wrapper_0.IOVSS1 sg13_lv_nmos ad=0.912p pd=5.18u as=0.912p ps=5.18u w=4.8u l=0.13u
X6921 user_project_wrapper_0.VDD2 user_project_wrapper_0.sg13g2_IOPadVdd_1.sg13g2_RCClampInverter_noptap_0.out user_project_wrapper_0.IOVSS1 user_project_wrapper_0.IOVSS1 sg13_hv_nmos ad=2.596p pd=5.58u as=1.408p ps=5.04u w=4.4u l=0.6u
X6922 a_307232_196607# a_296731_208493# a_309917_199879# VDD3 sg13_lv_pmos ad=0.24415p pd=1.665u as=0.24415p ps=1.665u w=1.285u l=0.35u
X6923 user_project_wrapper_0.sg13g2_IOPadIOVdd_3.sg13g2_Clamp_N43N43D4R_0.gate user_project_wrapper_0.sg13g2_IOPadIOVdd_3.sg13g2_RCClampResistor_0.p2 IOVDD3 IOVDD3 sg13_hv_pmos ad=1.33p pd=7.38u as=1.33p ps=7.38u w=7u l=0.5u
X6924 user_project_wrapper_0.IOVSS1 a_190389_99046# user_project_wrapper_0.analog_io[14] user_project_wrapper_0.IOVSS1 sg13_lv_nmos ad=0.1406p pd=1.12u as=0.1406p ps=1.12u w=0.74u l=0.13u
X6925 user_project_wrapper_0.IOVSS1 a_189729_99046# a_190389_99046# user_project_wrapper_0.IOVSS1 sg13_lv_nmos ad=0.1406p pd=1.12u as=0.1406p ps=1.12u w=0.74u l=0.13u
X6926 a_191438_329719# a_191234_329719# user_project_wrapper_0.IOVSS1 user_project_wrapper_0.IOVSS1 sg13_lv_nmos ad=0.34p pd=2.68u as=0.19p ps=1.38u w=1u l=0.13u
X6927 user_project_wrapper_0.VDD2 user_project_wrapper_0.sg13g2_IOPadVdd_1.sg13g2_RCClampInverter_noptap_0.out user_project_wrapper_0.IOVSS1 user_project_wrapper_0.IOVSS1 sg13_hv_nmos ad=2.596p pd=5.58u as=1.408p ps=5.04u w=4.4u l=0.6u
X6928 a_88274_127531# a_86594_127896# user_project_wrapper_0.IOVSS1 user_project_wrapper_0.IOVSS1 sg13_lv_nmos ad=0.1406p pd=1.12u as=0.2516p ps=2.16u w=0.74u l=0.13u
X6929 a_307232_196607# a_296731_189665# a_309917_194695# VDD3 sg13_lv_pmos ad=0.24415p pd=1.665u as=0.24415p ps=1.665u w=1.285u l=0.35u
X6930 user_project_wrapper_0.analog_io[10] a_135844_29676# user_project_wrapper_0.IOVSS1 user_project_wrapper_0.IOVSS1 sg13_hv_nmos ad=2.596p pd=5.58u as=1.408p ps=5.04u w=4.4u l=0.6u
X6931 IOVDD3 a_355624_258244# analog_io[25] IOVDD3 sg13_hv_pmos ad=3.1302p pd=14.26u as=3.9294p ps=7.84u w=6.66u l=0.6u
X6932 user_project_wrapper_0.IOVSS1 a_29676_135844# user_project_wrapper_0.analog_io[1] user_project_wrapper_0.IOVSS1 sg13_hv_nmos ad=1.408p pd=5.04u as=2.596p ps=5.58u w=4.4u l=0.6u
X6933 user_project_wrapper_0.analog_io[4] a_29676_197044# user_project_wrapper_0.IOVSS1 user_project_wrapper_0.IOVSS1 sg13_hv_nmos ad=2.596p pd=5.58u as=1.408p ps=5.04u w=4.4u l=0.6u
X6934 user_project_wrapper_0.IOVSS1 user_project_wrapper_0.sg13g2_IOPadVdd_1.sg13g2_RCClampInverter_noptap_0.out user_project_wrapper_0.VDD2 user_project_wrapper_0.IOVSS1 sg13_hv_nmos ad=1.408p pd=5.04u as=2.596p ps=5.58u w=4.4u l=0.6u
X6935 user_project_wrapper_0.IOVSS1 user_project_wrapper_0.sg13g2_IOPadIn$1_2.p2c a_208792_324119# user_project_wrapper_0.IOVSS1 sg13_lv_nmos ad=0.34p pd=2.68u as=0.19p ps=1.38u w=1u l=0.13u
X6936 user_project_wrapper_0.IOVDD1 a_41476_115444# user_project_wrapper_0.analog_io[0] user_project_wrapper_0.IOVDD1 sg13_hv_pmos ad=2.1312p pd=7.3u as=3.9294p ps=7.84u w=6.66u l=0.6u
X6937 user_project_wrapper_0.IOVDD1 a_41476_135844# user_project_wrapper_0.analog_io[1] user_project_wrapper_0.IOVDD1 sg13_hv_pmos ad=2.1312p pd=7.3u as=3.9294p ps=7.84u w=6.66u l=0.6u
X6938 a_296731_208493# a_301186_192011# user_project_wrapper_0.IOVSS1 user_project_wrapper_0.IOVSS1 sg13_lv_nmos ad=1.632p pd=10.28u as=0.912p ps=5.18u w=4.8u l=1.06u
X6939 a_82846_242854# user_project_wrapper_0.sg13g2_IOPadAnalog_15.padres a_82859_242012# user_project_wrapper_0.VDD1 sg13_lv_pmos ad=1.7p pd=10.68u as=0.95p ps=5.38u w=5u l=0.3u
X6940 user_project_wrapper_0.IOVSS1 a_189395_101343# a_189729_101343# user_project_wrapper_0.IOVSS1 sg13_lv_nmos ad=0.1406p pd=1.12u as=0.1406p ps=1.12u w=0.74u l=0.13u
X6941 user_project_wrapper_0.IOVSS1 user_project_wrapper_0.analog_io[4] dantenna l=27.78u w=1.26u
X6942 IOVDD3 user_project_wrapper_0.sg13g2_IOPadIOVdd_3.sg13g2_Clamp_N43N43D4R_0.gate user_project_wrapper_0.IOVSS1 user_project_wrapper_0.IOVSS1 sg13_hv_nmos ad=2.596p pd=5.58u as=1.408p ps=5.04u w=4.4u l=0.6u
X6943 user_project_wrapper_0.IOVSS1 a_301186_192011# a_296731_189665# user_project_wrapper_0.IOVSS1 sg13_lv_nmos ad=0.912p pd=5.18u as=0.912p ps=5.18u w=4.8u l=1.06u
X6944 analog_io[26] a_355624_278644# IOVDD3 IOVDD3 sg13_hv_pmos ad=3.9294p pd=7.84u as=2.1312p ps=7.3u w=6.66u l=0.6u
X6945 a_296731_189665# a_296625_189595# VDD3 VDD3 sg13_lv_pmos ad=0.2603p pd=1.75u as=0.2603p ps=1.75u w=1.37u l=0.35u
X6946 user_project_wrapper_0.VDD1 a_78824_133051# a_79025_133504# user_project_wrapper_0.VDD1 sg13_lv_pmos ad=1.7p pd=10.68u as=0.95p ps=5.38u w=5u l=0.15u
X6947 user_project_wrapper_0.IOVSS1 user_project_wrapper_0.sg13g2_IOPadVdd_0.sg13g2_RCClampResistor_0.p2 user_project_wrapper_0.IOVSS1 user_project_wrapper_0.IOVSS1 sg13_hv_nmos ad=1.71p pd=9.38u as=0 ps=0 w=9u l=9.5u
X6948 user_project_wrapper_0.analog_io[27] a_182931_326125# user_project_wrapper_0.IOVSS1 user_project_wrapper_0.IOVSS1 sg13_lv_pmos ad=1.824p pd=9.98u as=1.824p ps=9.98u w=9.6u l=0.13u
X6949 user_project_wrapper_0.IOVSS1 a_369296_176644# analog_io[20] user_project_wrapper_0.IOVSS1 sg13_hv_nmos ad=1.408p pd=5.04u as=2.596p ps=5.58u w=4.4u l=0.6u
X6950 user_project_wrapper_0.IOVSS1 user_project_wrapper_0.sg13g2_IOPadIOVdd_0.sg13g2_Clamp_N43N43D4R_0.gate user_project_wrapper_0.IOVDD2 user_project_wrapper_0.IOVSS1 sg13_hv_nmos ad=1.408p pd=5.04u as=2.596p ps=5.58u w=4.4u l=0.6u
X6951 user_project_wrapper_0.IOVSS1 user_project_wrapper_0.sg13g2_IOPadVdd_3.sg13g2_RCClampResistor_0.p2 user_project_wrapper_0.IOVSS1 user_project_wrapper_0.IOVSS1 sg13_hv_nmos ad=1.71p pd=9.38u as=0 ps=0 w=9u l=9.5u
X6952 analog_io[19] a_355624_135844# IOVDD3 IOVDD3 sg13_hv_pmos ad=3.9294p pd=7.84u as=2.1312p ps=7.3u w=6.66u l=0.6u
X6953 user_project_wrapper_0.IOVDD1 user_project_wrapper_0.sg13g2_IOPadIOVdd_1.sg13g2_Clamp_N43N43D4R_0.gate user_project_wrapper_0.IOVSS1 user_project_wrapper_0.IOVSS1 sg13_hv_nmos ad=2.596p pd=5.58u as=1.408p ps=5.04u w=4.4u l=0.6u
X6954 user_project_wrapper_0.sg13g2_IOPadAnalog_6.padres user_project_wrapper_0.IOVDD2 dpantenna l=0.64u w=4.98u
X6955 user_project_wrapper_0.IOVSS1 user_project_wrapper_0.IOVDD1 dpantenna l=1.26u w=27.78u
X6956 a_301735_364458# a_301405_360372# user_project_wrapper_0.IOVSS1 rppd l=20u w=1u
X6957 user_project_wrapper_0.sg13g2_IOPadIOVdd_1.sg13g2_Clamp_N43N43D4R_0.gate user_project_wrapper_0.sg13g2_IOPadIOVdd_1.sg13g2_RCClampResistor_0.p2 user_project_wrapper_0.IOVDD1 user_project_wrapper_0.IOVDD1 sg13_hv_pmos ad=1.33p pd=7.38u as=2.38p ps=14.68u w=7u l=0.5u
X6958 a_309917_194695# a_309516_194555# VDD3 VDD3 sg13_lv_pmos ad=0.19p pd=1.38u as=0.19p ps=1.38u w=1u l=0.7u
X6959 user_project_wrapper_0.analog_io[15] a_237844_41476# user_project_wrapper_0.IOVDD2 user_project_wrapper_0.IOVDD2 sg13_hv_pmos ad=3.9294p pd=7.84u as=2.1312p ps=7.3u w=6.66u l=0.6u
X6960 user_project_wrapper_0.IOVSS1 a_194687_324142# user_project_wrapper_0.analog_io[30] user_project_wrapper_0.IOVSS1 sg13_lv_pmos ad=1.824p pd=9.98u as=1.824p ps=9.98u w=9.6u l=0.13u
X6961 a_188074_110495# a_188632_108410# user_project_wrapper_0.IOVSS1 rppd l=10u w=1u
X6962 user_project_wrapper_0.sg13g2_IOPadIOVdd_3.sg13g2_Clamp_N43N43D4R_0.gate user_project_wrapper_0.sg13g2_IOPadIOVdd_3.sg13g2_RCClampResistor_0.p2 IOVDD3 IOVDD3 sg13_hv_pmos ad=1.33p pd=7.38u as=1.33p ps=7.38u w=7u l=0.5u
X6963 a_309917_199879# a_309516_194555# VDD3 VDD3 sg13_lv_pmos ad=0.19p pd=1.38u as=0.19p ps=1.38u w=1u l=0.7u
X6964 user_project_wrapper_0.analog_io[7] a_41476_258244# user_project_wrapper_0.IOVDD1 user_project_wrapper_0.IOVDD1 sg13_hv_pmos ad=3.9294p pd=7.84u as=2.1312p ps=7.3u w=6.66u l=0.6u
X6965 user_project_wrapper_0.VDD1 user_project_wrapper_0.sg13g2_IOPadVdd_2.sg13g2_RCClampResistor_0.p2 user_project_wrapper_0.sg13g2_IOPadVdd_2.sg13g2_RCClampInverter_noptap_0.out user_project_wrapper_0.VDD1 sg13_hv_pmos ad=1.33p pd=7.38u as=1.33p ps=7.38u w=7u l=0.5u
X6966 a_197044_41476# user_project_wrapper_0.IOVDD2 user_project_wrapper_0.IOVDD2 rppd l=12.9u w=0.5u
X6967 user_project_wrapper_0.IOVSS1 user_project_wrapper_0.sg13g2_IOPadVdd_1.sg13g2_RCClampInverter_noptap_0.out user_project_wrapper_0.VDD2 user_project_wrapper_0.IOVSS1 sg13_hv_nmos ad=1.408p pd=5.04u as=2.596p ps=5.58u w=4.4u l=0.6u
X6968 user_project_wrapper_0.VDD2 user_project_wrapper_0.sg13g2_IOPadVdd_1.sg13g2_RCClampInverter_noptap_0.out user_project_wrapper_0.IOVSS1 user_project_wrapper_0.IOVSS1 sg13_hv_nmos ad=2.596p pd=5.58u as=1.408p ps=5.04u w=4.4u l=0.6u
X6969 IOVDD3 a_355624_197044# analog_io[22] IOVDD3 sg13_hv_pmos ad=2.1312p pd=7.3u as=3.9294p ps=7.84u w=6.66u l=0.6u
X6970 a_296731_189665# a_296625_189595# VDD3 VDD3 sg13_lv_pmos ad=0.2603p pd=1.75u as=0.2603p ps=1.75u w=1.37u l=0.35u
X6971 user_project_wrapper_0.analog_io[33] a_237844_369296# user_project_wrapper_0.IOVSS1 user_project_wrapper_0.IOVSS1 sg13_hv_nmos ad=2.596p pd=5.58u as=1.408p ps=5.04u w=4.4u l=0.6u
X6972 a_78221_125094# a_78220_123062# user_project_wrapper_0.IOVSS1 rppd l=2u w=0.5u
X6973 user_project_wrapper_0.IOVSS1 a_182931_326125# user_project_wrapper_0.analog_io[27] user_project_wrapper_0.IOVSS1 sg13_lv_nmos ad=0.912p pd=5.18u as=0.912p ps=5.18u w=4.8u l=0.13u
X6974 user_project_wrapper_0.IOVDD1 a_41476_237844# user_project_wrapper_0.analog_io[6] user_project_wrapper_0.IOVDD1 sg13_hv_pmos ad=2.1312p pd=7.3u as=3.9294p ps=7.84u w=6.66u l=0.6u
X6975 user_project_wrapper_0.IOVDD2 a_258244_41476# user_project_wrapper_0.analog_io[16] user_project_wrapper_0.IOVDD2 sg13_hv_pmos ad=2.1312p pd=7.3u as=3.9294p ps=7.84u w=6.66u l=0.6u
X6976 user_project_wrapper_0.analog_io[35] a_213870_324142# user_project_wrapper_0.IOVSS1 user_project_wrapper_0.IOVSS1 sg13_lv_nmos ad=0.912p pd=5.18u as=0.912p ps=5.18u w=4.8u l=0.13u
X6977 user_project_wrapper_0.IOVSS1 a_182931_326125# user_project_wrapper_0.analog_io[27] user_project_wrapper_0.IOVSS1 sg13_lv_nmos ad=0.912p pd=5.18u as=0.912p ps=5.18u w=4.8u l=0.13u
X6978 user_project_wrapper_0.IOVSS1 a_188184_99046# a_188296_99070# user_project_wrapper_0.IOVSS1 sg13_lv_nmos ad=0.1426p pd=1.16u as=0.1428p ps=1.52u w=0.42u l=0.5u
X6979 a_313884_211353# a_296731_208493# a_311189_211724# user_project_wrapper_0.IOVSS1 sg13_lv_nmos ad=1.9p pd=10.38u as=1.9p ps=10.38u w=10u l=0.5u
X6980 user_project_wrapper_0.analog_io[35] a_278644_355624# user_project_wrapper_0.IOVDD4 user_project_wrapper_0.IOVDD4 sg13_hv_pmos ad=3.9294p pd=7.84u as=3.1302p ps=14.26u w=6.66u l=0.6u
X6981 user_project_wrapper_0.VDD2 user_project_wrapper_0.sg13g2_IOPadVdd_1.sg13g2_RCClampInverter_noptap_0.out user_project_wrapper_0.IOVSS1 user_project_wrapper_0.IOVSS1 sg13_hv_nmos ad=2.596p pd=5.58u as=1.408p ps=5.04u w=4.4u l=0.6u
X6982 a_296731_208493# a_296625_208423# VDD3 VDD3 sg13_lv_pmos ad=0.2603p pd=1.75u as=0.2603p ps=1.75u w=1.37u l=0.35u
X6983 a_210621_329719# a_210417_329719# user_project_wrapper_0.IOVSS1 user_project_wrapper_0.IOVSS1 sg13_lv_nmos ad=0.34p pd=2.68u as=0.19p ps=1.38u w=1u l=0.13u
X6984 user_project_wrapper_0.IOVDD4 user_project_wrapper_0.sg13g2_IOPadIOVdd_2.sg13g2_Clamp_N43N43D4R_0.gate user_project_wrapper_0.IOVSS1 user_project_wrapper_0.IOVSS1 sg13_hv_nmos ad=2.596p pd=5.58u as=1.408p ps=5.04u w=4.4u l=0.6u
X6985 user_project_wrapper_0.analog_io[13] a_197044_41476# user_project_wrapper_0.IOVDD2 user_project_wrapper_0.IOVDD2 sg13_hv_pmos ad=3.9294p pd=7.84u as=2.1312p ps=7.3u w=6.66u l=0.6u
X6986 user_project_wrapper_0.IOVSS1 user_project_wrapper_0.sg13g2_IOPadIOVdd_0.sg13g2_Clamp_N43N43D4R_0.gate user_project_wrapper_0.IOVDD2 user_project_wrapper_0.IOVSS1 sg13_hv_nmos ad=1.408p pd=5.04u as=2.596p ps=5.58u w=4.4u l=0.6u
X6987 a_309917_194695# user_project_wrapper_0.sg13g2_IOPadAnalog_29.padres a_311846_195517# VDD3 sg13_lv_pmos ad=0.24415p pd=1.665u as=0.24415p ps=1.665u w=1.285u l=0.35u
X6988 user_project_wrapper_0.IOVDD4 a_135844_355624# user_project_wrapper_0.analog_io[28] user_project_wrapper_0.IOVDD4 sg13_hv_pmos ad=2.1312p pd=7.3u as=3.9294p ps=7.84u w=6.66u l=0.6u
X6989 a_296731_208493# a_296625_208423# VDD3 VDD3 sg13_lv_pmos ad=0.2603p pd=1.75u as=0.2603p ps=1.75u w=1.37u l=0.35u
X6990 user_project_wrapper_0.IOVSS1 a_278644_369296# user_project_wrapper_0.IOVSS1 rppd l=3.54u w=0.5u
X6991 user_project_wrapper_0.IOVSS1 user_project_wrapper_0.sg13g2_IOPadIOVdd_0.sg13g2_RCClampResistor_0.p2 user_project_wrapper_0.sg13g2_IOPadIOVdd_0.sg13g2_Clamp_N43N43D4R_0.gate user_project_wrapper_0.IOVSS1 sg13_hv_nmos ad=1.71p pd=9.38u as=1.71p ps=9.38u w=9u l=0.5u
X6992 a_296731_208493# a_296625_208423# VDD3 VDD3 sg13_lv_pmos ad=0.2603p pd=1.75u as=0.2603p ps=1.75u w=1.37u l=0.35u
X6993 IOVDD3 a_355624_278644# analog_io[26] IOVDD3 sg13_hv_pmos ad=2.1312p pd=7.3u as=3.9294p ps=7.84u w=6.66u l=0.6u
X6994 user_project_wrapper_0.IOVDD4 a_237844_355624# user_project_wrapper_0.analog_io[33] user_project_wrapper_0.IOVDD4 sg13_hv_pmos ad=2.1312p pd=7.3u as=3.9294p ps=7.84u w=6.66u l=0.6u
X6995 user_project_wrapper_0.IOVSS1 a_189395_101343# a_189729_101343# user_project_wrapper_0.IOVSS1 sg13_lv_nmos ad=0.2516p pd=2.16u as=0.1406p ps=1.12u w=0.74u l=0.13u
X6996 user_project_wrapper_0.IOVDD2 a_197044_41476# user_project_wrapper_0.analog_io[13] user_project_wrapper_0.IOVDD2 sg13_hv_pmos ad=2.1312p pd=7.3u as=3.9294p ps=7.84u w=6.66u l=0.6u
X6997 user_project_wrapper_0.sg13g2_IOPadIOVdd_1.sg13g2_Clamp_N43N43D4R_0.gate user_project_wrapper_0.sg13g2_IOPadIOVdd_1.sg13g2_RCClampResistor_0.p2 user_project_wrapper_0.IOVDD1 user_project_wrapper_0.IOVDD1 sg13_hv_pmos ad=1.33p pd=7.38u as=1.33p ps=7.38u w=7u l=0.5u
X6998 user_project_wrapper_0.analog_io[27] a_115444_369296# user_project_wrapper_0.IOVSS1 user_project_wrapper_0.IOVSS1 sg13_hv_nmos ad=2.596p pd=5.58u as=1.408p ps=5.04u w=4.4u l=0.6u
X6999 a_302065_39542# a_302395_35456# user_project_wrapper_0.IOVSS1 rppd l=20u w=1u
X7000 VDD3 a_296625_189595# a_296731_189665# VDD3 sg13_lv_pmos ad=0.2603p pd=1.75u as=0.2603p ps=1.75u w=1.37u l=0.35u
X7001 user_project_wrapper_0.analog_io[15] user_project_wrapper_0.IOVDD2 dpantenna l=1.26u w=27.78u
X7002 user_project_wrapper_0.VDD1 a_78824_124371# a_79025_124824# user_project_wrapper_0.VDD1 sg13_lv_pmos ad=1.7p pd=10.68u as=0.95p ps=5.38u w=5u l=0.15u
X7003 user_project_wrapper_0.sg13g2_IOPadIOVdd_0.sg13g2_Clamp_N43N43D4R_0.gate user_project_wrapper_0.sg13g2_IOPadIOVdd_0.sg13g2_RCClampResistor_0.p2 user_project_wrapper_0.IOVDD2 user_project_wrapper_0.IOVDD2 sg13_hv_pmos ad=1.33p pd=7.38u as=1.33p ps=7.38u w=7u l=0.5u
X7004 user_project_wrapper_0.VDD1 user_project_wrapper_0.sg13g2_IOPadVdd_2.sg13g2_RCClampInverter_noptap_0.out user_project_wrapper_0.IOVSS1 user_project_wrapper_0.IOVSS1 sg13_hv_nmos ad=2.596p pd=5.58u as=1.408p ps=5.04u w=4.4u l=0.6u
X7005 user_project_wrapper_0.IOVSS1 user_project_wrapper_0.sg13g2_IOPadVdd_2.sg13g2_RCClampInverter_noptap_0.out user_project_wrapper_0.VDD1 user_project_wrapper_0.IOVSS1 sg13_hv_nmos ad=1.408p pd=5.04u as=2.596p ps=5.58u w=4.4u l=0.6u
X7006 user_project_wrapper_0.IOVSS1 a_202114_326125# user_project_wrapper_0.analog_io[32] user_project_wrapper_0.IOVSS1 sg13_lv_nmos ad=0.912p pd=5.18u as=0.912p ps=5.18u w=4.8u l=0.13u
X7007 a_78824_128711# a_78824_128711# user_project_wrapper_0.VDD1 user_project_wrapper_0.VDD1 sg13_lv_pmos ad=0.95p pd=5.38u as=1.7p ps=10.68u w=5u l=0.15u
X7008 user_project_wrapper_0.IOVSS1 user_project_wrapper_0.sg13g2_IOPadAnalog_19.padres a_189858_327099# user_project_wrapper_0.IOVSS1 sg13_lv_nmos ad=0.34p pd=2.68u as=0.19p ps=1.38u w=1u l=0.13u
X7009 user_project_wrapper_0.IOVSS1 user_project_wrapper_0.sg13g2_IOPadIOVdd_2.sg13g2_Clamp_N43N43D4R_0.gate user_project_wrapper_0.IOVDD4 user_project_wrapper_0.IOVSS1 sg13_hv_nmos ad=1.408p pd=5.04u as=2.596p ps=5.58u w=4.4u l=0.6u
X7010 IOVDD3 user_project_wrapper_0.sg13g2_IOPadIOVdd_3.sg13g2_Clamp_N43N43D4R_0.gate user_project_wrapper_0.IOVSS1 user_project_wrapper_0.IOVSS1 sg13_hv_nmos ad=2.596p pd=5.58u as=1.408p ps=5.04u w=4.4u l=0.6u
X7011 user_project_wrapper_0.IOVDD4 a_176644_355624# user_project_wrapper_0.analog_io[30] user_project_wrapper_0.IOVDD4 sg13_hv_pmos ad=2.1312p pd=7.3u as=3.9294p ps=7.84u w=6.66u l=0.6u
X7012 user_project_wrapper_0.IOVSS1 a_190319_102855# QDLL_TOP_0.CPIN user_project_wrapper_0.IOVSS1 sg13_lv_nmos ad=0.3108p pd=2.32u as=0.1628p ps=1.18u w=0.74u l=0.13u
X7013 user_project_wrapper_0.IOVSS1 a_369296_237844# analog_io[23] user_project_wrapper_0.IOVSS1 sg13_hv_nmos ad=1.408p pd=5.04u as=2.596p ps=5.58u w=4.4u l=0.6u
X7014 IOVDD3 user_project_wrapper_0.sg13g2_IOPadIOVdd_3.sg13g2_Clamp_N43N43D4R_0.gate user_project_wrapper_0.IOVSS1 user_project_wrapper_0.IOVSS1 sg13_hv_nmos ad=2.596p pd=5.58u as=1.408p ps=5.04u w=4.4u l=0.6u
X7015 user_project_wrapper_0.IOVDD1 a_41476_237844# user_project_wrapper_0.analog_io[6] user_project_wrapper_0.IOVDD1 sg13_hv_pmos ad=2.1312p pd=7.3u as=3.9294p ps=7.84u w=6.66u l=0.6u
X7016 user_project_wrapper_0.IOVDD1 a_41476_258244# user_project_wrapper_0.analog_io[7] user_project_wrapper_0.IOVDD1 sg13_hv_pmos ad=2.1312p pd=7.3u as=3.9294p ps=7.84u w=6.66u l=0.6u
X7017 user_project_wrapper_0.IOVSS1 user_project_wrapper_0.sg13g2_IOPadVdd_0.sg13g2_RCClampInverter_noptap_0.out VDD3 user_project_wrapper_0.IOVSS1 sg13_hv_nmos ad=1.408p pd=5.04u as=2.596p ps=5.58u w=4.4u l=0.6u
X7018 a_302065_39542# a_301735_35456# user_project_wrapper_0.IOVSS1 rppd l=20u w=1u
X7019 user_project_wrapper_0.IOVSS1 a_187364_324106# a_187018_328627# user_project_wrapper_0.IOVSS1 sg13_lv_nmos ad=1.632p pd=10.28u as=1.632p ps=10.28u w=4.8u l=0.13u
X7020 a_296731_208493# a_296625_208423# VDD3 VDD3 sg13_lv_pmos ad=0.2603p pd=1.75u as=0.2603p ps=1.75u w=1.37u l=0.35u
X7021 a_296731_189665# a_296625_189595# VDD3 VDD3 sg13_lv_pmos ad=0.2603p pd=1.75u as=0.2603p ps=1.75u w=1.37u l=0.35u
X7022 user_project_wrapper_0.IOVSS1 a_186202_326221# a_182931_326125# user_project_wrapper_0.IOVSS1 sg13_lv_nmos ad=0.912p pd=5.18u as=0.912p ps=5.18u w=4.8u l=0.13u
X7023 VDD3 user_project_wrapper_0.sg13g2_IOPadVdd_0.sg13g2_RCClampInverter_noptap_0.out user_project_wrapper_0.IOVSS1 user_project_wrapper_0.IOVSS1 sg13_hv_nmos ad=2.596p pd=5.58u as=1.408p ps=5.04u w=4.4u l=0.6u
X7024 user_project_wrapper_0.analog_io[29] a_156244_369296# user_project_wrapper_0.IOVSS1 user_project_wrapper_0.IOVSS1 sg13_hv_nmos ad=2.596p pd=5.58u as=1.408p ps=5.04u w=4.4u l=0.6u
X7025 user_project_wrapper_0.VDD2 user_project_wrapper_0.sg13g2_IOPadVdd_1.sg13g2_RCClampInverter_noptap_0.out user_project_wrapper_0.IOVSS1 user_project_wrapper_0.IOVSS1 sg13_hv_nmos ad=2.596p pd=5.58u as=1.408p ps=5.04u w=4.4u l=0.6u
X7026 analog_io[20] a_355624_156244# IOVDD3 IOVDD3 sg13_hv_pmos ad=3.9294p pd=7.84u as=2.1312p ps=7.3u w=6.66u l=0.6u
X7027 user_project_wrapper_0.IOVSS1 a_314793_198352# a_314793_198352# user_project_wrapper_0.IOVSS1 sg13_lv_nmos ad=1.02p pd=6.68u as=1.02p ps=6.68u w=3u l=1u
X7028 a_190319_97955# a_190218_98097# user_project_wrapper_0.IOVSS1 user_project_wrapper_0.IOVSS1 sg13_lv_nmos ad=0.17462p pd=1.185u as=0.374p ps=2.46u w=0.55u l=0.13u
X7029 user_project_wrapper_0.sg13g2_IOPadIOVdd_3.sg13g2_Clamp_N43N43D4R_0.gate user_project_wrapper_0.sg13g2_IOPadIOVdd_3.sg13g2_RCClampResistor_0.p2 IOVDD3 IOVDD3 sg13_hv_pmos ad=1.33p pd=7.38u as=1.33p ps=7.38u w=7u l=0.5u
X7030 analog_io[26] a_355624_278644# IOVDD3 IOVDD3 sg13_hv_pmos ad=3.9294p pd=7.84u as=2.1312p ps=7.3u w=6.66u l=0.6u
X7031 VDD3 a_309516_194555# a_309917_194695# VDD3 sg13_lv_pmos ad=0.19p pd=1.38u as=0.19p ps=1.38u w=1u l=0.7u
X7032 a_309917_194695# a_309516_194555# VDD3 VDD3 sg13_lv_pmos ad=0.19p pd=1.38u as=0.19p ps=1.38u w=1u l=0.7u
X7033 user_project_wrapper_0.IOVSS1 a_188834_327918# a_189286_330241# w_188700_330166# sg13_lv_pmos ad=0.68p pd=4.68u as=0.38p ps=2.38u w=2u l=0.13u
X7034 user_project_wrapper_0.IOVSS1 user_project_wrapper_0.IOVSS1 user_project_wrapper_0.IOVSS1 rppd l=0.5u w=0.5u
X7035 VDD3 user_project_wrapper_0.sg13g2_IOPadVdd_0.sg13g2_RCClampResistor_0.p2 user_project_wrapper_0.sg13g2_IOPadVdd_0.sg13g2_RCClampInverter_noptap_0.out VDD3 sg13_hv_pmos ad=1.33p pd=7.38u as=1.33p ps=7.38u w=7u l=0.5u
X7036 a_116485_39542# a_116155_35456# user_project_wrapper_0.IOVSS1 rppd l=20u w=1u
X7037 user_project_wrapper_0.IOVDD4 a_156244_355624# user_project_wrapper_0.analog_io[29] user_project_wrapper_0.IOVDD4 sg13_hv_pmos ad=2.1312p pd=7.3u as=3.9294p ps=7.84u w=6.66u l=0.6u
X7038 user_project_wrapper_0.IOVSS1 a_237844_369296# user_project_wrapper_0.analog_io[33] user_project_wrapper_0.IOVSS1 sg13_hv_nmos ad=1.408p pd=5.04u as=2.596p ps=5.58u w=4.4u l=0.6u
X7039 user_project_wrapper_0.analog_io[32] a_217444_355624# user_project_wrapper_0.IOVDD4 user_project_wrapper_0.IOVDD4 sg13_hv_pmos ad=3.9294p pd=7.84u as=2.1312p ps=7.3u w=6.66u l=0.6u
X7040 VDD3 a_309516_194555# a_309917_194695# VDD3 sg13_lv_pmos ad=0.19p pd=1.38u as=0.19p ps=1.38u w=1u l=0.7u
X7041 user_project_wrapper_0.IOVSS1 user_project_wrapper_0.IOVSS1 user_project_wrapper_0.IOVSS1 rppd l=0.5u w=0.5u
X7042 user_project_wrapper_0.analog_io[35] a_213870_324142# user_project_wrapper_0.IOVSS1 user_project_wrapper_0.IOVSS1 sg13_lv_pmos ad=1.824p pd=9.98u as=1.824p ps=9.98u w=9.6u l=0.13u
X7043 a_191234_328605# a_190824_328605# user_project_wrapper_0.IOVSS1 w_188704_327938# sg13_lv_pmos ad=0.68p pd=4.68u as=0.68p ps=4.68u w=2u l=0.13u
X7044 user_project_wrapper_0.IOVSS1 user_project_wrapper_0.sg13g2_IOPadVdd_2.sg13g2_RCClampInverter_noptap_0.out user_project_wrapper_0.VDD1 user_project_wrapper_0.IOVSS1 sg13_hv_nmos ad=1.408p pd=5.04u as=2.596p ps=5.58u w=4.4u l=0.6u
X7045 VDD3 a_296625_208423# a_296731_208493# VDD3 sg13_lv_pmos ad=0.2603p pd=1.75u as=0.2603p ps=1.75u w=1.37u l=0.35u
X7046 user_project_wrapper_0.IOVDD1 a_41476_115444# user_project_wrapper_0.analog_io[0] user_project_wrapper_0.IOVDD1 sg13_hv_pmos ad=2.1312p pd=7.3u as=3.9294p ps=7.84u w=6.66u l=0.6u
X7047 user_project_wrapper_0.IOVSS1 user_project_wrapper_0.sg13g2_IOPadVdd_2.sg13g2_RCClampInverter_noptap_0.out user_project_wrapper_0.VDD1 user_project_wrapper_0.IOVSS1 sg13_hv_nmos ad=1.408p pd=5.04u as=2.596p ps=5.58u w=4.4u l=0.6u
X7048 a_74695_364458# a_75025_360372# user_project_wrapper_0.IOVSS1 rppd l=20u w=1u
X7049 user_project_wrapper_0.IOVDD4 user_project_wrapper_0.sg13g2_IOPadIOVdd_2.sg13g2_Clamp_N43N43D4R_0.gate user_project_wrapper_0.IOVSS1 user_project_wrapper_0.IOVSS1 sg13_hv_nmos ad=2.596p pd=5.58u as=1.408p ps=5.04u w=4.4u l=0.6u
X7050 user_project_wrapper_0.IOVSS1 user_project_wrapper_0.sg13g2_IOPadVdd_3.sg13g2_RCClampResistor_0.p2 user_project_wrapper_0.IOVSS1 user_project_wrapper_0.IOVSS1 sg13_hv_nmos ad=1.71p pd=9.38u as=0 ps=0 w=9u l=9.5u
X7051 user_project_wrapper_0.analog_io[35] a_213870_324142# user_project_wrapper_0.IOVSS1 user_project_wrapper_0.IOVSS1 sg13_lv_pmos ad=1.824p pd=9.98u as=1.824p ps=9.98u w=9.6u l=0.13u
X7052 a_115825_39542# a_116155_35456# user_project_wrapper_0.IOVSS1 rppd l=20u w=1u
X7053 a_213462_327536# a_213376_328627# user_project_wrapper_0.IOVSS1 user_project_wrapper_0.IOVSS1 sg13_lv_nmos ad=0.912p pd=5.18u as=1.632p ps=10.28u w=4.8u l=0.13u
X7054 a_188966_92557# a_189524_90472# user_project_wrapper_0.IOVSS1 rppd l=10u w=1u
X7055 user_project_wrapper_0.sg13g2_IOPadIOVdd_1.sg13g2_Clamp_N43N43D4R_0.gate user_project_wrapper_0.sg13g2_IOPadIOVdd_1.sg13g2_RCClampResistor_0.p2 user_project_wrapper_0.IOVDD1 user_project_wrapper_0.IOVDD1 sg13_hv_pmos ad=1.33p pd=7.38u as=1.33p ps=7.38u w=7u l=0.5u
X7056 user_project_wrapper_0.analog_io[29] a_156244_355624# user_project_wrapper_0.IOVDD4 user_project_wrapper_0.IOVDD4 sg13_hv_pmos ad=3.9294p pd=7.84u as=2.1312p ps=7.3u w=6.66u l=0.6u
X7057 a_191438_329719# a_191234_329719# user_project_wrapper_0.IOVSS1 user_project_wrapper_0.IOVSS1 sg13_lv_nmos ad=0.19p pd=1.38u as=0.34p ps=2.68u w=1u l=0.13u
X7058 user_project_wrapper_0.analog_io[13] a_197044_29676# user_project_wrapper_0.IOVSS1 user_project_wrapper_0.IOVSS1 sg13_hv_nmos ad=2.596p pd=5.58u as=1.408p ps=5.04u w=4.4u l=0.6u
X7059 user_project_wrapper_0.IOVSS1 user_project_wrapper_0.sg13g2_IOPadVdd_2.sg13g2_RCClampInverter_noptap_0.out user_project_wrapper_0.VDD1 user_project_wrapper_0.IOVSS1 sg13_hv_nmos ad=1.408p pd=5.04u as=2.596p ps=5.58u w=4.4u l=0.6u
X7060 a_206547_324106# a_209230_324119# user_project_wrapper_0.IOVSS1 w_207989_323975# sg13_lv_pmos ad=0.38p pd=2.38u as=0.38p ps=2.38u w=2u l=0.13u
X7061 user_project_wrapper_0.IOVSS1 a_202114_326125# user_project_wrapper_0.analog_io[32] user_project_wrapper_0.IOVSS1 sg13_lv_pmos ad=1.824p pd=9.98u as=1.824p ps=9.98u w=9.6u l=0.13u
X7062 a_78824_130881# a_78824_130881# user_project_wrapper_0.VDD1 user_project_wrapper_0.VDD1 sg13_lv_pmos ad=0.95p pd=5.38u as=1.7p ps=10.68u w=5u l=0.15u
X7063 user_project_wrapper_0.IOVSS1 a_369296_156244# analog_io[20] user_project_wrapper_0.IOVSS1 sg13_hv_nmos ad=1.408p pd=5.04u as=2.596p ps=5.58u w=4.4u l=0.6u
X7064 user_project_wrapper_0.analog_io[5] a_41476_217444# user_project_wrapper_0.IOVDD1 user_project_wrapper_0.IOVDD1 sg13_hv_pmos ad=3.9294p pd=7.84u as=2.1312p ps=7.3u w=6.66u l=0.6u
X7065 user_project_wrapper_0.analog_io[30] a_194687_324142# user_project_wrapper_0.IOVSS1 user_project_wrapper_0.IOVSS1 sg13_lv_nmos ad=0.912p pd=5.18u as=0.912p ps=5.18u w=4.8u l=0.13u
X7066 VDD3 a_309516_194555# a_309917_194695# VDD3 sg13_lv_pmos ad=0.19p pd=1.38u as=0.19p ps=1.38u w=1u l=0.7u
X7067 user_project_wrapper_0.IOVDD2 a_217444_41476# user_project_wrapper_0.analog_io[14] user_project_wrapper_0.IOVDD2 sg13_hv_pmos ad=2.1312p pd=7.3u as=3.9294p ps=7.84u w=6.66u l=0.6u
X7068 IOVDD3 a_355624_156244# analog_io[20] IOVDD3 sg13_hv_pmos ad=2.1312p pd=7.3u as=3.9294p ps=7.84u w=6.66u l=0.6u
X7069 user_project_wrapper_0.sg13g2_IOPadIOVdd_1.sg13g2_Clamp_N43N43D4R_0.gate user_project_wrapper_0.sg13g2_IOPadIOVdd_1.sg13g2_RCClampResistor_0.p2 user_project_wrapper_0.IOVDD1 user_project_wrapper_0.IOVDD1 sg13_hv_pmos ad=1.33p pd=7.38u as=1.33p ps=7.38u w=7u l=0.5u
X7070 user_project_wrapper_0.IOVSS1 user_project_wrapper_0.sg13g2_IOPadIOVdd_1.sg13g2_Clamp_N43N43D4R_0.gate user_project_wrapper_0.IOVDD1 user_project_wrapper_0.IOVSS1 sg13_hv_nmos ad=1.408p pd=5.04u as=2.596p ps=5.58u w=4.4u l=0.6u
X7071 user_project_wrapper_0.IOVDD1 a_41476_197044# user_project_wrapper_0.analog_io[4] user_project_wrapper_0.IOVDD1 sg13_hv_pmos ad=2.1312p pd=7.3u as=3.9294p ps=7.84u w=6.66u l=0.6u
X7072 user_project_wrapper_0.IOVSS1 a_208792_324119# a_208579_324119# user_project_wrapper_0.IOVSS1 sg13_lv_nmos ad=0.19p pd=1.38u as=0.34p ps=2.68u w=1u l=0.13u
X7073 user_project_wrapper_0.IOVSS1 user_project_wrapper_0.IOVDD1 dpantenna l=1.26u w=27.78u
X7074 user_project_wrapper_0.VDD2 user_project_wrapper_0.sg13g2_IOPadVdd_1.sg13g2_RCClampResistor_0.p2 user_project_wrapper_0.sg13g2_IOPadVdd_1.sg13g2_RCClampInverter_noptap_0.out user_project_wrapper_0.VDD2 sg13_hv_pmos ad=1.33p pd=7.38u as=1.33p ps=7.38u w=7u l=0.5u
X7075 a_304995_198817# a_307232_196607# user_project_wrapper_0.IOVSS1 user_project_wrapper_0.IOVSS1 sg13_lv_nmos ad=0.6327p pd=3.71u as=0.6327p ps=3.71u w=3.33u l=0.2u
X7076 user_project_wrapper_0.analog_io[5] user_project_wrapper_0.IOVDD1 dpantenna l=27.78u w=1.26u
X7077 user_project_wrapper_0.sg13g2_IOPadVdd_0.sg13g2_RCClampInverter_noptap_0.out user_project_wrapper_0.sg13g2_IOPadVdd_0.sg13g2_RCClampResistor_0.p2 user_project_wrapper_0.IOVSS1 user_project_wrapper_0.IOVSS1 sg13_hv_nmos ad=1.71p pd=9.38u as=3.06p ps=18.68u w=9u l=0.5u
X7078 a_87673_125210# a_86507_127725# a_87571_125210# user_project_wrapper_0.VDD1 sg13_lv_pmos ad=0.2128p pd=1.5u as=0.2128p ps=1.5u w=1.12u l=0.13u
X7079 user_project_wrapper_0.IOVDD1 user_project_wrapper_0.sg13g2_IOPadOut4mA$1_1.sg13g2_GateLevelUpInv_noptap$1$1_0.pgate user_project_wrapper_0.uo_PAD[8] user_project_wrapper_0.IOVDD1 sg13_hv_pmos ad=3.1302p pd=14.26u as=3.9294p ps=7.84u w=6.66u l=0.6u
X7080 user_project_wrapper_0.IOVSS1 user_project_wrapper_0.sg13g2_IOPadIOVdd_2.sg13g2_Clamp_N43N43D4R_0.gate user_project_wrapper_0.IOVDD4 user_project_wrapper_0.IOVSS1 sg13_hv_nmos ad=1.408p pd=5.04u as=2.596p ps=5.58u w=4.4u l=0.6u
X7081 user_project_wrapper_0.analog_io[0] a_41476_115444# user_project_wrapper_0.IOVDD1 user_project_wrapper_0.IOVDD1 sg13_hv_pmos ad=3.9294p pd=7.84u as=2.1312p ps=7.3u w=6.66u l=0.6u
X7082 a_296625_208423# a_301940_196388# a_296732_200582# VDD3 sg13_lv_pmos ad=0.7695p pd=4.43u as=0.7695p ps=4.43u w=4.05u l=0.5u
X7083 user_project_wrapper_0.IOVSS1 user_project_wrapper_0.sg13g2_IOPadIOVdd_3.sg13g2_Clamp_N43N43D4R_0.gate IOVDD3 user_project_wrapper_0.IOVSS1 sg13_hv_nmos ad=1.408p pd=5.04u as=2.596p ps=5.58u w=4.4u l=0.6u
X7084 VDD3 a_309516_194555# a_309516_194555# VDD3 sg13_lv_pmos ad=0.19p pd=1.38u as=0.19p ps=1.38u w=1u l=0.7u
X7085 a_296732_197880# a_301940_196388# a_296625_189595# VDD3 sg13_lv_pmos ad=0.7695p pd=4.43u as=0.7695p ps=4.43u w=4.05u l=0.5u
X7086 user_project_wrapper_0.IOVSS1 a_237844_369296# user_project_wrapper_0.analog_io[33] user_project_wrapper_0.IOVSS1 sg13_hv_nmos ad=1.408p pd=5.04u as=2.596p ps=5.58u w=4.4u l=0.6u
X7087 user_project_wrapper_0.IOVSS1 user_project_wrapper_0.sg13g2_IOPadIOVdd_0.sg13g2_RCClampResistor_0.p2 user_project_wrapper_0.sg13g2_IOPadIOVdd_0.sg13g2_Clamp_N43N43D4R_0.gate user_project_wrapper_0.IOVSS1 sg13_hv_nmos ad=1.71p pd=9.38u as=1.71p ps=9.38u w=9u l=0.5u
X7088 user_project_wrapper_0.IOVSS1 user_project_wrapper_0.sg13g2_IOPadAnalog_6.padres a_268697_100118# user_project_wrapper_0.IOVSS1 sg13_lv_nmos ad=79.8f pd=0.8u as=0.1428p ps=1.52u w=0.42u l=0.13u
X7089 user_project_wrapper_0.analog_io[35] a_213870_324142# user_project_wrapper_0.IOVSS1 user_project_wrapper_0.IOVSS1 sg13_lv_nmos ad=0.912p pd=5.18u as=0.912p ps=5.18u w=4.8u l=0.13u
X7090 user_project_wrapper_0.IOVSS1 a_182931_326125# user_project_wrapper_0.analog_io[27] user_project_wrapper_0.IOVSS1 sg13_lv_nmos ad=0.912p pd=5.18u as=0.912p ps=5.18u w=4.8u l=0.13u
X7091 user_project_wrapper_0.IOVDD2 a_176644_41476# user_project_wrapper_0.analog_io[12] user_project_wrapper_0.IOVDD2 sg13_hv_pmos ad=2.1312p pd=7.3u as=3.9294p ps=7.84u w=6.66u l=0.6u
X7092 VDD3 a_296625_189595# a_296731_189665# VDD3 sg13_lv_pmos ad=0.2603p pd=1.75u as=0.2603p ps=1.75u w=1.37u l=0.35u
X7093 user_project_wrapper_0.sg13g2_IOPadAnalog_1.padres IOVDD3 dpantenna l=4.98u w=0.64u
X7094 user_project_wrapper_0.IOVSS1 user_project_wrapper_0.sg13g2_IOPadIOVdd_1.sg13g2_Clamp_N43N43D4R_0.gate user_project_wrapper_0.IOVDD1 user_project_wrapper_0.IOVSS1 sg13_hv_nmos ad=1.408p pd=5.04u as=2.596p ps=5.58u w=4.4u l=0.6u
X7095 user_project_wrapper_0.IOVSS1 a_29676_258244# user_project_wrapper_0.analog_io[7] user_project_wrapper_0.IOVSS1 sg13_hv_nmos ad=2.068p pd=9.74u as=2.596p ps=5.58u w=4.4u l=0.6u
X7096 analog_io[20] IOVDD3 dpantenna l=27.78u w=1.26u
X7097 a_190389_99046# a_189729_99046# QDLL_TOP_0.VDD QDLL_TOP_0.VDD sg13_lv_pmos ad=0.2128p pd=1.5u as=0.2128p ps=1.5u w=1.12u l=0.13u
X7098 a_296731_189665# a_296625_189595# VDD3 VDD3 sg13_lv_pmos ad=0.2603p pd=1.75u as=0.2603p ps=1.75u w=1.37u l=0.35u
X7099 VDD3 a_296625_208423# a_296731_208493# VDD3 sg13_lv_pmos ad=0.2603p pd=1.75u as=0.2603p ps=1.75u w=1.37u l=0.35u
X7100 IOVDD3 a_355624_258244# analog_io[25] IOVDD3 sg13_hv_pmos ad=2.1312p pd=7.3u as=3.9294p ps=7.84u w=6.66u l=0.6u
X7101 a_258244_41476# user_project_wrapper_0.IOVDD2 user_project_wrapper_0.IOVDD2 rppd l=12.9u w=0.5u
X7102 VDD3 user_project_wrapper_0.sg13g2_IOPadVdd_0.sg13g2_RCClampInverter_noptap_0.out user_project_wrapper_0.IOVSS1 user_project_wrapper_0.IOVSS1 sg13_hv_nmos ad=2.596p pd=5.58u as=1.408p ps=5.04u w=4.4u l=0.6u
X7103 a_89953_129061# a_89114_129426# user_project_wrapper_0.IOVSS1 user_project_wrapper_0.IOVSS1 sg13_lv_nmos ad=0.2516p pd=2.16u as=0.2516p ps=2.16u w=0.74u l=0.13u
X7104 user_project_wrapper_0.sg13g2_IOPadIOVdd_1.sg13g2_Clamp_N43N43D4R_0.gate user_project_wrapper_0.sg13g2_IOPadIOVdd_1.sg13g2_RCClampResistor_0.p2 user_project_wrapper_0.IOVDD1 user_project_wrapper_0.IOVDD1 sg13_hv_pmos ad=1.33p pd=7.38u as=1.33p ps=7.38u w=7u l=0.5u
X7105 user_project_wrapper_0.IOVSS1 a_369296_197044# analog_io[22] user_project_wrapper_0.IOVSS1 sg13_hv_nmos ad=1.408p pd=5.04u as=2.596p ps=5.58u w=4.4u l=0.6u
X7106 user_project_wrapper_0.IOVSS1 a_115444_369296# user_project_wrapper_0.analog_io[27] user_project_wrapper_0.IOVSS1 sg13_hv_nmos ad=1.408p pd=5.04u as=2.596p ps=5.58u w=4.4u l=0.6u
X7107 user_project_wrapper_0.sg13g2_IOPadIOVdd_2.sg13g2_Clamp_N43N43D4R_0.gate user_project_wrapper_0.sg13g2_IOPadIOVdd_2.sg13g2_RCClampResistor_0.p2 user_project_wrapper_0.IOVDD4 user_project_wrapper_0.IOVDD4 sg13_hv_pmos ad=1.33p pd=7.38u as=1.33p ps=7.38u w=7u l=0.5u
X7108 user_project_wrapper_0.IOVSS1 a_190297_327491# a_190926_327491# user_project_wrapper_0.IOVSS1 sg13_lv_nmos ad=0.34p pd=2.68u as=0.19p ps=1.38u w=1u l=0.13u
X7109 a_190490_102497# user_project_wrapper_0.analog_io[15] QDLL_TOP_0.VDD QDLL_TOP_0.VDD sg13_lv_pmos ad=0.2128p pd=1.5u as=0.2128p ps=1.5u w=1.12u l=0.13u
X7110 a_83796_129203# a_83389_129203# user_project_wrapper_0.VDD1 user_project_wrapper_0.VDD1 sg13_lv_pmos ad=0.2128p pd=1.5u as=0.3808p ps=2.92u w=1.12u l=0.13u
X7111 user_project_wrapper_0.IOVSS1 user_project_wrapper_0.IOVSS1 user_project_wrapper_0.IOVSS1 rppd l=0.5u w=0.5u
X7112 IOVDD3 a_355624_115444# analog_io[18] IOVDD3 sg13_hv_pmos ad=2.1312p pd=7.3u as=3.9294p ps=7.84u w=6.66u l=0.6u
X7113 a_84707_131750# a_79025_131741# user_project_wrapper_0.VDD1 user_project_wrapper_0.VDD1 sg13_lv_pmos ad=0.3808p pd=2.92u as=0.3808p ps=2.92u w=1.12u l=0.13u
X7114 analog_io[18] a_369296_115444# user_project_wrapper_0.IOVSS1 user_project_wrapper_0.IOVSS1 sg13_hv_nmos ad=2.596p pd=5.58u as=2.068p ps=9.74u w=4.4u l=0.6u
X7115 user_project_wrapper_0.IOVDD2 a_217444_41476# user_project_wrapper_0.analog_io[14] user_project_wrapper_0.IOVDD2 sg13_hv_pmos ad=2.1312p pd=7.3u as=3.9294p ps=7.84u w=6.66u l=0.6u
X7116 a_209684_327491# a_208367_327491# user_project_wrapper_0.IOVSS1 w_207887_327938# sg13_lv_pmos ad=0.68p pd=4.68u as=0.68p ps=4.68u w=2u l=0.13u
X7117 a_309917_194695# a_309516_194555# VDD3 VDD3 sg13_lv_pmos ad=0.19p pd=1.38u as=0.34p ps=2.68u w=1u l=0.7u
X7118 VDD3 user_project_wrapper_0.sg13g2_IOPadVdd_0.sg13g2_RCClampInverter_noptap_0.out user_project_wrapper_0.IOVSS1 user_project_wrapper_0.IOVSS1 sg13_hv_nmos ad=2.596p pd=5.58u as=1.408p ps=5.04u w=4.4u l=0.6u
X7119 user_project_wrapper_0.IOVSS1 user_project_wrapper_0.sg13g2_IOPadVdd_1.sg13g2_RCClampInverter_noptap_0.out user_project_wrapper_0.VDD2 user_project_wrapper_0.IOVSS1 sg13_hv_nmos ad=1.408p pd=5.04u as=2.596p ps=5.58u w=4.4u l=0.6u
X7120 a_296731_189665# a_296625_189595# VDD3 VDD3 sg13_lv_pmos ad=0.2603p pd=1.75u as=0.2603p ps=1.75u w=1.37u l=0.35u
X7121 a_210621_329719# a_210417_329719# user_project_wrapper_0.IOVSS1 user_project_wrapper_0.IOVSS1 sg13_lv_nmos ad=0.19p pd=1.38u as=0.34p ps=2.68u w=1u l=0.13u
X7122 a_79038_132196# a_78220_130691# a_79025_133504# user_project_wrapper_0.VDD1 sg13_lv_pmos ad=0.95p pd=5.38u as=1.7p ps=10.68u w=5u l=0.3u
X7123 a_210007_327491# a_208367_327491# a_209905_327491# user_project_wrapper_0.IOVSS1 sg13_lv_nmos ad=0.19p pd=1.38u as=0.19p ps=1.38u w=1u l=0.13u
X7124 user_project_wrapper_0.IOVDD1 a_41476_115444# user_project_wrapper_0.analog_io[0] user_project_wrapper_0.IOVDD1 sg13_hv_pmos ad=2.1312p pd=7.3u as=3.9294p ps=7.84u w=6.66u l=0.6u
X7125 user_project_wrapper_0.IOVSS1 a_258244_29676# user_project_wrapper_0.analog_io[16] user_project_wrapper_0.IOVSS1 sg13_hv_nmos ad=1.408p pd=5.04u as=2.596p ps=5.58u w=4.4u l=0.6u
X7126 IOVDD3 a_355624_176644# analog_io[20] IOVDD3 sg13_hv_pmos ad=2.1312p pd=7.3u as=3.9294p ps=7.84u w=6.66u l=0.6u
X7127 user_project_wrapper_0.analog_io[1] a_29676_135844# user_project_wrapper_0.IOVSS1 user_project_wrapper_0.IOVSS1 sg13_hv_nmos ad=2.596p pd=5.58u as=1.408p ps=5.04u w=4.4u l=0.6u
X7128 user_project_wrapper_0.IOVSS1 a_156244_369296# user_project_wrapper_0.analog_io[29] user_project_wrapper_0.IOVSS1 sg13_hv_nmos ad=1.408p pd=5.04u as=2.596p ps=5.58u w=4.4u l=0.6u
X7129 a_213870_324142# a_213462_327536# user_project_wrapper_0.IOVSS1 user_project_wrapper_0.IOVSS1 sg13_lv_pmos ad=1.824p pd=9.98u as=3.264p ps=19.88u w=9.6u l=0.13u
X7130 user_project_wrapper_0.IOVDD2 a_258244_41476# user_project_wrapper_0.analog_io[16] user_project_wrapper_0.IOVDD2 sg13_hv_pmos ad=2.1312p pd=7.3u as=3.9294p ps=7.84u w=6.66u l=0.6u
X7131 user_project_wrapper_0.IOVDD4 user_project_wrapper_0.sg13g2_IOPadIOVdd_2.sg13g2_Clamp_N43N43D4R_0.gate user_project_wrapper_0.IOVSS1 user_project_wrapper_0.IOVSS1 sg13_hv_nmos ad=2.596p pd=5.58u as=1.408p ps=5.04u w=4.4u l=0.6u
X7132 IOVDD3 a_355624_197044# analog_io[22] IOVDD3 sg13_hv_pmos ad=2.1312p pd=7.3u as=3.9294p ps=7.84u w=6.66u l=0.6u
X7133 user_project_wrapper_0.IOVSS1 user_project_wrapper_0.sg13g2_IOPadVdd_2.sg13g2_RCClampInverter_noptap_0.out user_project_wrapper_0.VDD1 user_project_wrapper_0.IOVSS1 sg13_hv_nmos ad=1.408p pd=5.04u as=2.596p ps=5.58u w=4.4u l=0.6u
X7134 a_188572_101637# a_188296_101407# QDLL_TOP_0.VDD QDLL_TOP_0.VDD sg13_lv_pmos ad=0.4256p pd=3u as=0.2254p ps=1.53u w=1.12u l=0.13u
X7135 user_project_wrapper_0.VDD2 user_project_wrapper_0.sg13g2_IOPadVdd_1.sg13g2_RCClampInverter_noptap_0.out user_project_wrapper_0.IOVSS1 user_project_wrapper_0.IOVSS1 sg13_hv_nmos ad=2.596p pd=5.58u as=1.408p ps=5.04u w=4.4u l=0.6u
X7136 a_296732_197880# a_296626_197740# VDD3 VDD3 sg13_lv_pmos ad=1.33p pd=7.38u as=1.33p ps=7.38u w=7u l=0.7u
X7137 user_project_wrapper_0.IOVSS1 user_project_wrapper_0.IOVSS1 user_project_wrapper_0.IOVSS1 rhigh l=0.96u w=0.5u
X7138 analog_io[18] a_355624_115444# IOVDD3 IOVDD3 sg13_hv_pmos ad=3.9294p pd=7.84u as=2.1312p ps=7.3u w=6.66u l=0.6u
X7139 a_189756_326377# user_project_wrapper_0.IOVSS1 user_project_wrapper_0.IOVSS1 user_project_wrapper_0.IOVSS1 sg13_lv_nmos ad=0.19p pd=1.38u as=0.34p ps=2.68u w=1u l=0.13u
X7140 user_project_wrapper_0.IOVSS1 user_project_wrapper_0.sg13g2_IOPadIOVdd_3.sg13g2_RCClampResistor_0.p2 user_project_wrapper_0.sg13g2_IOPadIOVdd_3.sg13g2_Clamp_N43N43D4R_0.gate user_project_wrapper_0.IOVSS1 sg13_hv_nmos ad=1.71p pd=9.38u as=1.71p ps=9.38u w=9u l=0.5u
X7141 user_project_wrapper_0.IOVSS1 a_197044_29676# user_project_wrapper_0.analog_io[13] user_project_wrapper_0.IOVSS1 sg13_hv_nmos ad=1.408p pd=5.04u as=2.596p ps=5.58u w=4.4u l=0.6u
X7142 user_project_wrapper_0.IOVSS1 user_project_wrapper_0.IOVSS1 user_project_wrapper_0.IOVSS1 rppd l=0.5u w=0.5u
X7143 analog_io[20] a_369296_176644# user_project_wrapper_0.IOVSS1 user_project_wrapper_0.IOVSS1 sg13_hv_nmos ad=2.596p pd=5.58u as=1.408p ps=5.04u w=4.4u l=0.6u
X7144 user_project_wrapper_0.IOVDD4 a_217444_355624# user_project_wrapper_0.analog_io[32] user_project_wrapper_0.IOVDD4 sg13_hv_pmos ad=2.1312p pd=7.3u as=3.9294p ps=7.84u w=6.66u l=0.6u
X7145 user_project_wrapper_0.analog_io[11] a_156244_41476# user_project_wrapper_0.IOVDD2 user_project_wrapper_0.IOVDD2 sg13_hv_pmos ad=3.9294p pd=7.84u as=2.1312p ps=7.3u w=6.66u l=0.6u
X7146 a_304196_197873# a_304090_197941# a_296625_189595# user_project_wrapper_0.IOVSS1 sg13_lv_nmos ad=0.646p pd=4.48u as=0.361p ps=2.28u w=1.9u l=0.16u
X7147 user_project_wrapper_0.IOVDD2 user_project_wrapper_0.sg13g2_IOPadIOVdd_0.sg13g2_Clamp_N43N43D4R_0.gate user_project_wrapper_0.IOVSS1 user_project_wrapper_0.IOVSS1 sg13_hv_nmos ad=2.596p pd=5.58u as=1.408p ps=5.04u w=4.4u l=0.6u
X7148 user_project_wrapper_0.IOVSS1 a_186202_326221# a_182931_326125# user_project_wrapper_0.IOVSS1 sg13_lv_nmos ad=0.912p pd=5.18u as=0.912p ps=5.18u w=4.8u l=0.13u
X7149 a_296731_208493# a_296625_208423# VDD3 VDD3 sg13_lv_pmos ad=0.2603p pd=1.75u as=0.2603p ps=1.75u w=1.37u l=0.35u
X7150 analog_io[23] a_355624_217444# IOVDD3 IOVDD3 sg13_hv_pmos ad=3.9294p pd=7.84u as=3.1302p ps=14.26u w=6.66u l=0.6u
X7151 IOVDD3 user_project_wrapper_0.sg13g2_IOPadIOVdd_3.sg13g2_Clamp_N43N43D4R_0.gate user_project_wrapper_0.IOVSS1 user_project_wrapper_0.IOVSS1 sg13_hv_nmos ad=2.596p pd=5.58u as=1.408p ps=5.04u w=4.4u l=0.6u
X7152 user_project_wrapper_0.sg13g2_IOPadAnalog_13.padres user_project_wrapper_0.IOVDD1 dpantenna l=4.98u w=0.64u
X7153 user_project_wrapper_0.IOVSS1 user_project_wrapper_0.sg13g2_IOPadIOVdd_3.sg13g2_Clamp_N43N43D4R_0.gate IOVDD3 user_project_wrapper_0.IOVSS1 sg13_hv_nmos ad=1.408p pd=5.04u as=2.596p ps=5.58u w=4.4u l=0.6u
X7154 a_79025_125231# a_79038_123982# user_project_wrapper_0.IOVSS1 user_project_wrapper_0.IOVSS1 sg13_lv_nmos ad=0.1428p pd=1.52u as=0.1428p ps=1.52u w=0.42u l=0.56u
X7155 user_project_wrapper_0.IOVSS1 user_project_wrapper_0.sg13g2_IOPadIOVdd_3.sg13g2_Clamp_N43N43D4R_0.gate IOVDD3 user_project_wrapper_0.IOVSS1 sg13_hv_nmos ad=1.408p pd=5.04u as=2.596p ps=5.58u w=4.4u l=0.6u
X7156 VDD3 a_309516_194555# a_309917_194695# VDD3 sg13_lv_pmos ad=0.19p pd=1.38u as=0.19p ps=1.38u w=1u l=0.7u
X7157 user_project_wrapper_0.sg13g2_IOPadIOVdd_0.sg13g2_Clamp_N43N43D4R_0.gate user_project_wrapper_0.sg13g2_IOPadIOVdd_0.sg13g2_RCClampResistor_0.p2 user_project_wrapper_0.IOVDD2 user_project_wrapper_0.IOVDD2 sg13_hv_pmos ad=1.33p pd=7.38u as=1.33p ps=7.38u w=7u l=0.5u
X7158 a_309917_194695# a_296731_189665# a_307232_196607# VDD3 sg13_lv_pmos ad=0.24415p pd=1.665u as=0.24415p ps=1.665u w=1.285u l=0.35u
X7159 a_360372_74365# a_364458_74035# user_project_wrapper_0.IOVSS1 rppd l=20u w=1u
X7160 QDLL_TOP_0.VDD a_189395_99046# a_189729_99046# QDLL_TOP_0.VDD sg13_lv_pmos ad=0.2128p pd=1.5u as=0.2128p ps=1.5u w=1.12u l=0.13u
X7161 user_project_wrapper_0.sg13g2_IOPadIOVdd_1.sg13g2_Clamp_N43N43D4R_0.gate user_project_wrapper_0.sg13g2_IOPadIOVdd_1.sg13g2_RCClampResistor_0.p2 user_project_wrapper_0.IOVDD1 user_project_wrapper_0.IOVDD1 sg13_hv_pmos ad=1.33p pd=7.38u as=1.33p ps=7.38u w=7u l=0.5u
X7162 user_project_wrapper_0.sg13g2_IOPadVdd_3.sg13g2_RCClampInverter_noptap_0.out user_project_wrapper_0.sg13g2_IOPadVdd_3.sg13g2_RCClampResistor_0.p2 user_project_wrapper_0.IOVSS1 user_project_wrapper_0.IOVSS1 sg13_hv_pmos ad=1.33p pd=7.38u as=2.38p ps=14.68u w=7u l=0.5u
X7163 a_35456_298435# a_39542_298105# user_project_wrapper_0.IOVSS1 rppd l=20u w=1u
X7164 user_project_wrapper_0.IOVSS1 user_project_wrapper_0.sg13g2_IOPadIOVdd_2.sg13g2_Clamp_N43N43D4R_0.gate user_project_wrapper_0.IOVDD4 user_project_wrapper_0.IOVSS1 sg13_hv_nmos ad=1.408p pd=5.04u as=2.596p ps=5.58u w=4.4u l=0.6u
X7165 user_project_wrapper_0.IOVDD2 user_project_wrapper_0.sg13g2_IOPadIOVdd_0.sg13g2_Clamp_N43N43D4R_0.gate user_project_wrapper_0.IOVSS1 user_project_wrapper_0.IOVSS1 sg13_hv_nmos ad=2.596p pd=5.58u as=1.408p ps=5.04u w=4.4u l=0.6u
X7166 a_190389_99046# a_189729_99046# QDLL_TOP_0.VDD QDLL_TOP_0.VDD sg13_lv_pmos ad=0.2128p pd=1.5u as=0.3808p ps=2.92u w=1.12u l=0.13u
X7167 user_project_wrapper_0.IOVSS1 user_project_wrapper_0.sg13g2_IOPadIOVdd_3.sg13g2_RCClampResistor_0.p2 user_project_wrapper_0.sg13g2_IOPadIOVdd_3.sg13g2_Clamp_N43N43D4R_0.gate user_project_wrapper_0.IOVSS1 sg13_hv_nmos ad=1.71p pd=9.38u as=1.71p ps=9.38u w=9u l=0.5u
X7168 VDD3 user_project_wrapper_0.sg13g2_IOPadVdd_0.sg13g2_RCClampInverter_noptap_0.out user_project_wrapper_0.IOVSS1 user_project_wrapper_0.IOVSS1 sg13_hv_nmos ad=2.596p pd=5.58u as=1.408p ps=5.04u w=4.4u l=0.6u
X7169 user_project_wrapper_0.sg13g2_IOPadIOVdd_2.sg13g2_Clamp_N43N43D4R_0.gate user_project_wrapper_0.sg13g2_IOPadIOVdd_2.sg13g2_RCClampResistor_0.p2 user_project_wrapper_0.IOVDD4 user_project_wrapper_0.IOVDD4 sg13_hv_pmos ad=1.33p pd=7.38u as=1.33p ps=7.38u w=7u l=0.5u
X7170 user_project_wrapper_0.IOVDD2 user_project_wrapper_0.sg13g2_IOPadIOVdd_0.sg13g2_Clamp_N43N43D4R_0.gate user_project_wrapper_0.IOVSS1 user_project_wrapper_0.IOVSS1 sg13_hv_nmos ad=2.596p pd=5.58u as=1.408p ps=5.04u w=4.4u l=0.6u
X7171 user_project_wrapper_0.IOVSS1 user_project_wrapper_0.sg13g2_IOPadVdd_1.sg13g2_RCClampInverter_noptap_0.out user_project_wrapper_0.VDD2 user_project_wrapper_0.IOVSS1 sg13_hv_nmos ad=1.408p pd=5.04u as=2.596p ps=5.58u w=4.4u l=0.6u
X7172 user_project_wrapper_0.IOVSS1 a_209480_327491# a_210109_327491# user_project_wrapper_0.IOVSS1 sg13_lv_nmos ad=0.34p pd=2.68u as=0.19p ps=1.38u w=1u l=0.13u
X7173 user_project_wrapper_0.analog_io[35] a_278644_355624# user_project_wrapper_0.IOVDD4 user_project_wrapper_0.IOVDD4 sg13_hv_pmos ad=3.9294p pd=7.84u as=2.1312p ps=7.3u w=6.66u l=0.6u
X7174 user_project_wrapper_0.analog_io[27] a_115444_355624# user_project_wrapper_0.IOVDD4 user_project_wrapper_0.IOVDD4 sg13_hv_pmos ad=3.9294p pd=7.84u as=2.1312p ps=7.3u w=6.66u l=0.6u
X7175 VDD3 a_296625_189595# a_296731_189665# VDD3 sg13_lv_pmos ad=0.2603p pd=1.75u as=0.2603p ps=1.75u w=1.37u l=0.35u
X7176 user_project_wrapper_0.IOVSS1 user_project_wrapper_0.sg13g2_IOPadIOVdd_1.sg13g2_Clamp_N43N43D4R_0.gate user_project_wrapper_0.IOVDD1 user_project_wrapper_0.IOVSS1 sg13_hv_nmos ad=1.408p pd=5.04u as=2.596p ps=5.58u w=4.4u l=0.6u
X7177 a_360372_300745# a_364458_300415# user_project_wrapper_0.IOVSS1 rppd l=20u w=1u
X7178 user_project_wrapper_0.IOVSS1 a_190455_324119# a_190047_324119# user_project_wrapper_0.IOVSS1 sg13_lv_nmos ad=0.34p pd=2.68u as=0.34p ps=2.68u w=1u l=0.13u
X7179 IOVDD3 a_355624_115444# analog_io[18] IOVDD3 sg13_hv_pmos ad=3.1302p pd=14.26u as=3.9294p ps=7.84u w=6.66u l=0.6u
X7180 a_209905_325785# a_208939_325263# user_project_wrapper_0.IOVSS1 w_207887_326203# sg13_lv_pmos ad=0.38p pd=2.38u as=0.68p ps=4.68u w=2u l=0.13u
X7181 analog_io[26] a_355624_278644# IOVDD3 IOVDD3 sg13_hv_pmos ad=3.9294p pd=7.84u as=2.1312p ps=7.3u w=6.66u l=0.6u
X7182 user_project_wrapper_0.IOVDD2 a_217444_41476# user_project_wrapper_0.analog_io[14] user_project_wrapper_0.IOVDD2 sg13_hv_pmos ad=2.1312p pd=7.3u as=3.9294p ps=7.84u w=6.66u l=0.6u
X7183 a_210621_326377# TOP_ROILIFNEURON_0.MEM user_project_wrapper_0.IOVSS1 rppd l=0.5u w=0.5u
X7184 user_project_wrapper_0.analog_io[27] a_115444_369296# user_project_wrapper_0.IOVSS1 user_project_wrapper_0.IOVSS1 sg13_hv_nmos ad=2.596p pd=5.58u as=1.408p ps=5.04u w=4.4u l=0.6u
X7185 user_project_wrapper_0.IOVSS1 a_191462_324119# a_191124_324119# w_188806_323975# sg13_lv_pmos ad=0.68p pd=4.68u as=0.68p ps=4.68u w=2u l=0.65u
X7186 user_project_wrapper_0.IOVSS1 user_project_wrapper_0.sg13g2_IOPadVdd_2.sg13g2_RCClampResistor_0.p2 user_project_wrapper_0.IOVSS1 user_project_wrapper_0.IOVSS1 sg13_hv_nmos ad=1.71p pd=9.38u as=0 ps=0 w=9u l=9.5u
X7187 a_296731_189665# a_301186_192011# user_project_wrapper_0.IOVSS1 user_project_wrapper_0.IOVSS1 sg13_lv_nmos ad=0.912p pd=5.18u as=0.912p ps=5.18u w=4.8u l=1.06u
X7188 a_191438_325263# TOP_ROILIFNEURON_0.MEM user_project_wrapper_0.IOVSS1 rppd l=0.5u w=0.5u
X7189 IOVDD3 a_355624_217444# analog_io[23] IOVDD3 sg13_hv_pmos ad=2.1312p pd=7.3u as=3.9294p ps=7.84u w=6.66u l=0.6u
X7190 user_project_wrapper_0.IOVSS1 user_project_wrapper_0.IOVSS1 dantenna l=27.78u w=1.26u
X7191 user_project_wrapper_0.IOVDD2 a_278644_41476# QDLL_TOP_0.VOUT user_project_wrapper_0.IOVDD2 sg13_hv_pmos ad=2.1312p pd=7.3u as=3.9294p ps=7.84u w=6.66u l=0.6u
X7192 a_210109_328605# a_208367_328605# a_210007_328605# w_207887_327938# sg13_lv_pmos ad=0.38p pd=2.38u as=0.38p ps=2.38u w=2u l=0.13u
X7193 a_309516_194555# a_309516_194555# VDD3 VDD3 sg13_lv_pmos ad=0.19p pd=1.38u as=0.19p ps=1.38u w=1u l=0.7u
X7194 user_project_wrapper_0.VDD1 user_project_wrapper_0.sg13g2_IOPadVdd_2.sg13g2_RCClampResistor_0.p2 user_project_wrapper_0.sg13g2_IOPadVdd_2.sg13g2_RCClampInverter_noptap_0.out user_project_wrapper_0.VDD1 sg13_hv_pmos ad=1.33p pd=7.38u as=1.33p ps=7.38u w=7u l=0.5u
X7195 user_project_wrapper_0.analog_io[11] a_156244_41476# user_project_wrapper_0.IOVDD2 user_project_wrapper_0.IOVDD2 sg13_hv_pmos ad=3.9294p pd=7.84u as=2.1312p ps=7.3u w=6.66u l=0.6u
X7196 a_35456_303715# a_39542_303385# user_project_wrapper_0.IOVSS1 rppd l=20u w=1u
X7197 user_project_wrapper_0.IOVDD2 user_project_wrapper_0.sg13g2_IOPadIOVdd_0.sg13g2_Clamp_N43N43D4R_0.gate user_project_wrapper_0.IOVSS1 user_project_wrapper_0.IOVSS1 sg13_hv_nmos ad=2.596p pd=5.58u as=1.408p ps=5.04u w=4.4u l=0.6u
X7198 analog_io[19] a_355624_135844# IOVDD3 IOVDD3 sg13_hv_pmos ad=3.9294p pd=7.84u as=2.1312p ps=7.3u w=6.66u l=0.6u
X7199 VDD3 a_296625_189595# a_296731_189665# VDD3 sg13_lv_pmos ad=0.2603p pd=1.75u as=0.2603p ps=1.75u w=1.37u l=0.35u
X7200 a_296732_197880# a_301940_196388# a_296625_189595# VDD3 sg13_lv_pmos ad=0.7695p pd=4.43u as=0.7695p ps=4.43u w=4.05u l=0.5u
X7201 a_210051_330987# a_210937_330987# user_project_wrapper_0.IOVSS1 rhigh l=4u w=0.5u
X7202 user_project_wrapper_0.IOVSS1 user_project_wrapper_0.IOVSS1 dantenna l=1.26u w=27.78u
X7203 user_project_wrapper_0.analog_io[7] a_41476_258244# user_project_wrapper_0.IOVDD1 user_project_wrapper_0.IOVDD1 sg13_hv_pmos ad=3.9294p pd=7.84u as=2.1312p ps=7.3u w=6.66u l=0.6u
X7204 user_project_wrapper_0.VDD1 user_project_wrapper_0.sg13g2_IOPadVdd_2.sg13g2_RCClampInverter_noptap_0.out user_project_wrapper_0.IOVSS1 user_project_wrapper_0.IOVSS1 sg13_hv_nmos ad=2.596p pd=5.58u as=1.408p ps=5.04u w=4.4u l=0.6u
X7205 user_project_wrapper_0.IOVSS1 user_project_wrapper_0.sg13g2_IOPadIOVdd_3.sg13g2_Clamp_N43N43D4R_0.gate IOVDD3 user_project_wrapper_0.IOVSS1 sg13_hv_nmos ad=1.408p pd=5.04u as=2.596p ps=5.58u w=4.4u l=0.6u
X7206 user_project_wrapper_0.analog_io[29] a_156244_369296# user_project_wrapper_0.IOVSS1 user_project_wrapper_0.IOVSS1 sg13_hv_nmos ad=2.596p pd=5.58u as=1.408p ps=5.04u w=4.4u l=0.6u
X7207 analog_io[20] a_311108_179669# VDD3 user_project_wrapper_0.IOVSS1 sg13_lv_nmos ad=3.4p pd=20.68u as=3.4p ps=20.68u w=10u l=0.15u
X7208 a_189184_326377# user_project_wrapper_0.IOVSS1 user_project_wrapper_0.IOVSS1 user_project_wrapper_0.IOVSS1 sg13_lv_nmos ad=0.19p pd=1.38u as=0.34p ps=2.68u w=1u l=0.13u
X7209 user_project_wrapper_0.IOVSS1 user_project_wrapper_0.sg13g2_IOPadIOVdd_0.sg13g2_RCClampResistor_0.p2 user_project_wrapper_0.IOVSS1 user_project_wrapper_0.IOVSS1 sg13_hv_nmos ad=1.71p pd=9.38u as=0 ps=0 w=9u l=9.5u
X7210 a_313884_211353# analog_io[23] a_311108_215937# user_project_wrapper_0.IOVSS1 sg13_lv_nmos ad=1.9p pd=10.38u as=1.9p ps=10.38u w=10u l=0.5u
X7211 user_project_wrapper_0.analog_io[35] a_213870_324142# user_project_wrapper_0.IOVSS1 user_project_wrapper_0.IOVSS1 sg13_lv_pmos ad=1.824p pd=9.98u as=1.824p ps=9.98u w=9.6u l=0.13u
X7212 a_309917_199879# a_309516_194555# VDD3 VDD3 sg13_lv_pmos ad=0.19p pd=1.38u as=0.19p ps=1.38u w=1u l=0.7u
X7213 user_project_wrapper_0.VDD1 a_59490_159238# user_project_wrapper_0.sg13g2_IOPadIn$1_0.p2c user_project_wrapper_0.VDD1 sg13_lv_pmos ad=1.615p pd=10.18u as=1.615p ps=10.18u w=4.75u l=0.13u
X7214 a_307232_196607# a_307232_196607# user_project_wrapper_0.IOVSS1 user_project_wrapper_0.IOVSS1 sg13_lv_nmos ad=0.6327p pd=3.71u as=0.6327p ps=3.71u w=3.33u l=0.2u
X7215 user_project_wrapper_0.VDD1 a_78824_128711# a_78824_128711# user_project_wrapper_0.VDD1 sg13_lv_pmos ad=1.7p pd=10.68u as=0.95p ps=5.38u w=5u l=0.15u
X7216 user_project_wrapper_0.IOVSS1 user_project_wrapper_0.sg13g2_IOPadIOVdd_2.sg13g2_Clamp_N43N43D4R_0.gate user_project_wrapper_0.IOVDD4 user_project_wrapper_0.IOVSS1 sg13_hv_nmos ad=1.408p pd=5.04u as=2.596p ps=5.58u w=4.4u l=0.6u
X7217 VDD3 a_296625_189595# a_296731_189665# VDD3 sg13_lv_pmos ad=0.2603p pd=1.75u as=0.2603p ps=1.75u w=1.37u l=0.35u
X7218 user_project_wrapper_0.IOVSS1 a_202114_326125# user_project_wrapper_0.analog_io[32] user_project_wrapper_0.IOVSS1 sg13_lv_pmos ad=1.824p pd=9.98u as=1.824p ps=9.98u w=9.6u l=0.13u
X7219 VDD3 a_296626_197740# a_296626_197740# VDD3 sg13_lv_pmos ad=0.266p pd=1.78u as=0.266p ps=1.78u w=1.4u l=0.35u
X7220 VDD3 a_296625_208423# a_296731_208493# VDD3 sg13_lv_pmos ad=0.4658p pd=3.42u as=0.2603p ps=1.75u w=1.37u l=0.35u
X7221 user_project_wrapper_0.sg13g2_IOPadIOVdd_1.sg13g2_Clamp_N43N43D4R_0.gate user_project_wrapper_0.sg13g2_IOPadIOVdd_1.sg13g2_RCClampResistor_0.p2 user_project_wrapper_0.IOVDD1 user_project_wrapper_0.IOVDD1 sg13_hv_pmos ad=1.33p pd=7.38u as=1.33p ps=7.38u w=7u l=0.5u
X7222 a_92512_129061# a_89953_129061# user_project_wrapper_0.IOVSS1 user_project_wrapper_0.IOVSS1 sg13_lv_nmos ad=0.1406p pd=1.12u as=0.2516p ps=2.16u w=0.74u l=0.13u
X7223 user_project_wrapper_0.IOVSS1 a_182931_326125# user_project_wrapper_0.analog_io[27] user_project_wrapper_0.IOVSS1 sg13_lv_nmos ad=0.912p pd=5.18u as=0.912p ps=5.18u w=4.8u l=0.13u
X7224 a_311846_195517# user_project_wrapper_0.sg13g2_IOPadAnalog_29.padres a_309917_194695# VDD3 sg13_lv_pmos ad=0.24415p pd=1.665u as=0.24415p ps=1.665u w=1.285u l=0.35u
X7225 a_213870_324142# a_213462_327536# user_project_wrapper_0.IOVSS1 user_project_wrapper_0.IOVSS1 sg13_lv_nmos ad=0.912p pd=5.18u as=0.912p ps=5.18u w=4.8u l=0.13u
X7226 user_project_wrapper_0.IOVSS1 a_369296_278644# analog_io[26] user_project_wrapper_0.IOVSS1 sg13_hv_nmos ad=2.068p pd=9.74u as=2.596p ps=5.58u w=4.4u l=0.6u
X7227 user_project_wrapper_0.IOVSS1 a_237844_369296# user_project_wrapper_0.analog_io[33] user_project_wrapper_0.IOVSS1 sg13_hv_nmos ad=1.408p pd=5.04u as=2.596p ps=5.58u w=4.4u l=0.6u
X7228 user_project_wrapper_0.analog_io[32] a_217444_355624# user_project_wrapper_0.IOVDD4 user_project_wrapper_0.IOVDD4 sg13_hv_pmos ad=3.9294p pd=7.84u as=2.1312p ps=7.3u w=6.66u l=0.6u
X7229 a_311846_195517# user_project_wrapper_0.sg13g2_IOPadAnalog_29.padres a_309917_194695# VDD3 sg13_lv_pmos ad=0.24415p pd=1.665u as=0.24415p ps=1.665u w=1.285u l=0.35u
X7230 user_project_wrapper_0.IOVSS1 a_205385_326221# a_202114_326125# user_project_wrapper_0.IOVSS1 sg13_lv_pmos ad=3.264p pd=19.88u as=1.824p ps=9.98u w=9.6u l=0.13u
X7231 user_project_wrapper_0.IOVSS1 user_project_wrapper_0.sg13g2_IOPadVdd_1.sg13g2_RCClampInverter_noptap_0.out user_project_wrapper_0.VDD2 user_project_wrapper_0.IOVSS1 sg13_hv_nmos ad=1.408p pd=5.04u as=2.596p ps=5.58u w=4.4u l=0.6u
X7232 VDD3 a_296625_208423# a_296731_208493# VDD3 sg13_lv_pmos ad=0.2603p pd=1.75u as=0.2603p ps=1.75u w=1.37u l=0.35u
X7233 IOVDD3 a_355624_156244# analog_io[20] IOVDD3 sg13_hv_pmos ad=2.1312p pd=7.3u as=3.9294p ps=7.84u w=6.66u l=0.6u
X7234 user_project_wrapper_0.analog_io[30] a_194687_324142# user_project_wrapper_0.IOVSS1 user_project_wrapper_0.IOVSS1 sg13_lv_nmos ad=0.912p pd=5.18u as=0.912p ps=5.18u w=4.8u l=0.13u
X7235 user_project_wrapper_0.IOVSS1 user_project_wrapper_0.sg13g2_IOPadIOVdd_0.sg13g2_Clamp_N43N43D4R_0.gate user_project_wrapper_0.IOVDD2 user_project_wrapper_0.IOVSS1 sg13_hv_nmos ad=1.408p pd=5.04u as=2.596p ps=5.58u w=4.4u l=0.6u
X7236 a_82667_125418# a_83490_125209# user_project_wrapper_0.IOVSS1 user_project_wrapper_0.IOVSS1 sg13_lv_nmos ad=0.2516p pd=2.16u as=0.2516p ps=2.16u w=0.74u l=0.13u
X7237 user_project_wrapper_0.IOVSS1 a_82433_130212# a_83492_130212# user_project_wrapper_0.IOVSS1 sg13_lv_nmos ad=0.2516p pd=2.16u as=0.1406p ps=1.12u w=0.74u l=0.13u
X7238 a_311189_185546# a_296731_189665# a_313884_185173# user_project_wrapper_0.IOVSS1 sg13_lv_nmos ad=1.9p pd=10.38u as=1.9p ps=10.38u w=10u l=0.5u
X7239 IOVDD3 user_project_wrapper_0.sg13g2_IOPadIOVdd_3.sg13g2_Clamp_N43N43D4R_0.gate user_project_wrapper_0.IOVSS1 user_project_wrapper_0.IOVSS1 sg13_hv_nmos ad=2.596p pd=5.58u as=1.408p ps=5.04u w=4.4u l=0.6u
X7240 IOVDD3 user_project_wrapper_0.sg13g2_IOPadIOVdd_3.sg13g2_Clamp_N43N43D4R_0.gate user_project_wrapper_0.IOVSS1 user_project_wrapper_0.IOVSS1 sg13_hv_nmos ad=2.596p pd=5.58u as=1.408p ps=5.04u w=4.4u l=0.6u
X7241 IOVDD3 a_355624_135844# analog_io[19] IOVDD3 sg13_hv_pmos ad=2.1312p pd=7.3u as=3.9294p ps=7.84u w=6.66u l=0.6u
X7242 a_74695_364458# a_74365_360372# user_project_wrapper_0.IOVSS1 rppd l=20u w=1u
X7243 a_209480_327491# a_208939_327491# user_project_wrapper_0.IOVSS1 w_207887_327938# sg13_lv_pmos ad=0.68p pd=4.68u as=0.68p ps=4.68u w=2u l=0.13u
X7244 user_project_wrapper_0.IOVSS1 user_project_wrapper_0.sg13g2_IOPadIOVdd_0.sg13g2_Clamp_N43N43D4R_0.gate user_project_wrapper_0.IOVDD2 user_project_wrapper_0.IOVSS1 sg13_hv_nmos ad=1.408p pd=5.04u as=2.596p ps=5.58u w=4.4u l=0.6u
X7245 user_project_wrapper_0.analog_io[34] a_258244_355624# user_project_wrapper_0.IOVDD4 user_project_wrapper_0.IOVDD4 sg13_hv_pmos ad=3.9294p pd=7.84u as=2.1312p ps=7.3u w=6.66u l=0.6u
X7246 VDD3 user_project_wrapper_0.sg13g2_IOPadVdd_0.sg13g2_RCClampResistor_0.p2 user_project_wrapper_0.sg13g2_IOPadVdd_0.sg13g2_RCClampInverter_noptap_0.out VDD3 sg13_hv_pmos ad=1.33p pd=7.38u as=1.33p ps=7.38u w=7u l=0.5u
X7247 analog_io[20] a_369296_156244# user_project_wrapper_0.IOVSS1 user_project_wrapper_0.IOVSS1 sg13_hv_nmos ad=2.596p pd=5.58u as=1.408p ps=5.04u w=4.4u l=0.6u
X7248 a_210417_329719# a_210007_329719# user_project_wrapper_0.IOVSS1 user_project_wrapper_0.IOVSS1 sg13_lv_nmos ad=0.34p pd=2.68u as=0.34p ps=2.68u w=1u l=0.13u
X7249 user_project_wrapper_0.analog_io[16] a_258244_41476# user_project_wrapper_0.IOVDD2 user_project_wrapper_0.IOVDD2 sg13_hv_pmos ad=3.9294p pd=7.84u as=2.1312p ps=7.3u w=6.66u l=0.6u
X7250 user_project_wrapper_0.IOVDD1 user_project_wrapper_0.sg13g2_IOPadIOVdd_1.sg13g2_Clamp_N43N43D4R_0.gate user_project_wrapper_0.IOVSS1 user_project_wrapper_0.IOVSS1 sg13_hv_nmos ad=2.596p pd=5.58u as=1.408p ps=5.04u w=4.4u l=0.6u
X7251 IOVDD3 a_355624_237844# analog_io[23] IOVDD3 sg13_hv_pmos ad=2.1312p pd=7.3u as=3.9294p ps=7.84u w=6.66u l=0.6u
X7252 a_270178_100118# a_269931_100182# QDLL_TOP_0.VDD QDLL_TOP_0.VDD sg13_lv_pmos ad=0.3808p pd=2.92u as=0.2245p ps=1.53u w=1.12u l=0.13u
X7253 user_project_wrapper_0.VDD1 user_project_wrapper_0.sg13g2_IOPadVdd_2.sg13g2_RCClampResistor_0.p2 user_project_wrapper_0.sg13g2_IOPadVdd_2.sg13g2_RCClampInverter_noptap_0.out user_project_wrapper_0.VDD1 sg13_hv_pmos ad=1.33p pd=7.38u as=1.33p ps=7.38u w=7u l=0.5u
X7254 a_309917_194695# a_309516_194555# VDD3 VDD3 sg13_lv_pmos ad=0.19p pd=1.38u as=0.19p ps=1.38u w=1u l=0.7u
X7255 user_project_wrapper_0.IOVSS1 user_project_wrapper_0.sg13g2_IOPadVdd_2.sg13g2_RCClampInverter_noptap_0.out user_project_wrapper_0.VDD1 user_project_wrapper_0.IOVSS1 sg13_hv_nmos ad=1.408p pd=5.04u as=2.596p ps=5.58u w=4.4u l=0.6u
X7256 VDD3 a_296625_208423# a_296731_208493# VDD3 sg13_lv_pmos ad=0.2603p pd=1.75u as=0.2603p ps=1.75u w=1.37u l=0.35u
X7257 user_project_wrapper_0.analog_io[35] a_213870_324142# user_project_wrapper_0.IOVSS1 user_project_wrapper_0.IOVSS1 sg13_lv_nmos ad=0.912p pd=5.18u as=0.912p ps=5.18u w=4.8u l=0.13u
X7258 user_project_wrapper_0.VDD1 a_86507_129255# a_87105_130835# user_project_wrapper_0.VDD1 sg13_lv_pmos ad=0.3808p pd=2.92u as=0.2128p ps=1.5u w=1.12u l=0.13u
X7259 user_project_wrapper_0.analog_io[30] a_194687_324142# user_project_wrapper_0.IOVSS1 user_project_wrapper_0.IOVSS1 sg13_lv_pmos ad=1.824p pd=9.98u as=1.824p ps=9.98u w=9.6u l=0.13u
X7260 user_project_wrapper_0.VDD1 user_project_wrapper_0.sg13g2_IOPadVdd_2.sg13g2_RCClampInverter_noptap_0.out user_project_wrapper_0.IOVSS1 user_project_wrapper_0.IOVSS1 sg13_hv_nmos ad=2.596p pd=5.58u as=1.408p ps=5.04u w=4.4u l=0.6u
X7261 user_project_wrapper_0.analog_io[28] a_135844_355624# user_project_wrapper_0.IOVDD4 user_project_wrapper_0.IOVDD4 sg13_hv_pmos ad=3.9294p pd=7.84u as=2.1312p ps=7.3u w=6.66u l=0.6u
X7262 user_project_wrapper_0.IOVSS1 a_258244_29676# user_project_wrapper_0.analog_io[16] user_project_wrapper_0.IOVSS1 sg13_hv_nmos ad=1.408p pd=5.04u as=2.596p ps=5.58u w=4.4u l=0.6u
X7263 a_79038_132662# user_project_wrapper_0.sg13g2_IOPadAnalog_9.padres a_79025_133504# user_project_wrapper_0.VDD1 sg13_lv_pmos ad=0.95p pd=5.38u as=1.7p ps=10.68u w=5u l=0.3u
X7264 analog_io[23] a_369296_237844# user_project_wrapper_0.IOVSS1 user_project_wrapper_0.IOVSS1 sg13_hv_nmos ad=2.596p pd=5.58u as=1.408p ps=5.04u w=4.4u l=0.6u
X7265 user_project_wrapper_0.sg13g2_IOPadIOVdd_0.sg13g2_Clamp_N43N43D4R_0.gate user_project_wrapper_0.sg13g2_IOPadIOVdd_0.sg13g2_RCClampResistor_0.p2 user_project_wrapper_0.IOVDD2 user_project_wrapper_0.IOVDD2 sg13_hv_pmos ad=1.33p pd=7.38u as=1.33p ps=7.38u w=7u l=0.5u
X7266 user_project_wrapper_0.IOVSS1 a_29676_115444# user_project_wrapper_0.analog_io[0] user_project_wrapper_0.IOVSS1 sg13_hv_nmos ad=1.408p pd=5.04u as=2.596p ps=5.58u w=4.4u l=0.6u
X7267 a_79038_130492# a_79038_130026# user_project_wrapper_0.IOVSS1 user_project_wrapper_0.IOVSS1 sg13_lv_nmos ad=0.1428p pd=1.52u as=0.1428p ps=1.52u w=0.42u l=0.56u
X7268 a_296731_208493# a_301186_192011# user_project_wrapper_0.IOVSS1 user_project_wrapper_0.IOVSS1 sg13_lv_nmos ad=0.912p pd=5.18u as=0.912p ps=5.18u w=4.8u l=1.06u
X7269 user_project_wrapper_0.IOVSS1 user_project_wrapper_0.sg13g2_IOPadVdd_1.sg13g2_RCClampInverter_noptap_0.out user_project_wrapper_0.VDD2 user_project_wrapper_0.IOVSS1 sg13_hv_nmos ad=1.408p pd=5.04u as=2.596p ps=5.58u w=4.4u l=0.6u
X7270 user_project_wrapper_0.IOVDD4 a_278644_355624# user_project_wrapper_0.analog_io[35] user_project_wrapper_0.IOVDD4 sg13_hv_pmos ad=2.1312p pd=7.3u as=3.9294p ps=7.84u w=6.66u l=0.6u
X7271 user_project_wrapper_0.IOVDD4 a_115444_355624# user_project_wrapper_0.analog_io[27] user_project_wrapper_0.IOVDD4 sg13_hv_pmos ad=2.1312p pd=7.3u as=3.9294p ps=7.84u w=6.66u l=0.6u
X7272 a_296731_208493# a_296625_208423# VDD3 VDD3 sg13_lv_pmos ad=0.2603p pd=1.75u as=0.2603p ps=1.75u w=1.37u l=0.35u
X7273 a_79038_128322# user_project_wrapper_0.sg13g2_IOPadAnalog_9.padres a_79025_129164# user_project_wrapper_0.VDD1 sg13_lv_pmos ad=0.95p pd=5.38u as=1.7p ps=10.68u w=5u l=0.3u
X7274 a_296731_189665# a_296625_189595# VDD3 VDD3 sg13_lv_pmos ad=0.2603p pd=1.75u as=0.2603p ps=1.75u w=1.37u l=0.35u
X7275 a_213870_324142# a_213462_327536# user_project_wrapper_0.IOVSS1 user_project_wrapper_0.IOVSS1 sg13_lv_pmos ad=1.824p pd=9.98u as=1.824p ps=9.98u w=9.6u l=0.13u
X7276 a_296731_189665# a_296625_189595# VDD3 VDD3 sg13_lv_pmos ad=0.2603p pd=1.75u as=0.2603p ps=1.75u w=1.37u l=0.35u
X7277 user_project_wrapper_0.IOVSS1 a_190297_326377# a_190926_326377# w_188704_326203# sg13_lv_pmos ad=0.68p pd=4.68u as=0.38p ps=2.38u w=2u l=0.13u
X7278 user_project_wrapper_0.analog_io[34] a_258244_369296# user_project_wrapper_0.IOVSS1 user_project_wrapper_0.IOVSS1 sg13_hv_nmos ad=2.596p pd=5.58u as=2.068p ps=9.74u w=4.4u l=0.6u
X7279 a_303055_364458# a_303385_360372# user_project_wrapper_0.IOVSS1 rppd l=20u w=1u
X7280 user_project_wrapper_0.IOVSS1 a_115444_369296# user_project_wrapper_0.analog_io[27] user_project_wrapper_0.IOVSS1 sg13_hv_nmos ad=1.408p pd=5.04u as=2.596p ps=5.58u w=4.4u l=0.6u
X7281 user_project_wrapper_0.analog_io[35] a_213870_324142# user_project_wrapper_0.IOVSS1 user_project_wrapper_0.IOVSS1 sg13_lv_pmos ad=1.824p pd=9.98u as=1.824p ps=9.98u w=9.6u l=0.13u
X7282 user_project_wrapper_0.IOVSS1 a_29676_197044# user_project_wrapper_0.analog_io[4] user_project_wrapper_0.IOVSS1 sg13_hv_nmos ad=1.408p pd=5.04u as=2.596p ps=5.58u w=4.4u l=0.6u
X7283 user_project_wrapper_0.IOVSS1 user_project_wrapper_0.IOVSS1 user_project_wrapper_0.IOVSS1 rppd l=0.5u w=0.5u
X7284 user_project_wrapper_0.IOVDD2 a_135844_41476# user_project_wrapper_0.analog_io[10] user_project_wrapper_0.IOVDD2 sg13_hv_pmos ad=2.1312p pd=7.3u as=3.9294p ps=7.84u w=6.66u l=0.6u
X7285 a_189672_324776# a_192745_324776# user_project_wrapper_0.IOVSS1 user_project_wrapper_0.IOVSS1 sg13_lv_nmos ad=0.19p pd=1.38u as=0.34p ps=2.68u w=1u l=0.13u
X7286 a_296625_189595# a_301940_196388# a_296732_197880# VDD3 sg13_lv_pmos ad=0.7695p pd=4.43u as=0.7695p ps=4.43u w=4.05u l=0.5u
X7287 user_project_wrapper_0.IOVSS1 user_project_wrapper_0.sg13g2_IOPadIOVdd_0.sg13g2_Clamp_N43N43D4R_0.gate user_project_wrapper_0.IOVDD2 user_project_wrapper_0.IOVSS1 sg13_hv_nmos ad=1.408p pd=5.04u as=2.596p ps=5.58u w=4.4u l=0.6u
X7288 a_210007_326377# a_209684_326377# a_209905_326377# w_207887_326203# sg13_lv_pmos ad=0.38p pd=2.38u as=0.38p ps=2.38u w=2u l=0.13u
X7289 user_project_wrapper_0.IOVSS1 user_project_wrapper_0.sg13g2_IOPadIOVdd_0.sg13g2_RCClampResistor_0.p2 user_project_wrapper_0.IOVSS1 user_project_wrapper_0.IOVSS1 sg13_hv_nmos ad=1.71p pd=9.38u as=0 ps=0 w=9u l=9.5u
X7290 a_296731_189665# a_296625_189595# VDD3 VDD3 sg13_lv_pmos ad=0.2603p pd=1.75u as=0.2603p ps=1.75u w=1.37u l=0.35u
X7291 user_project_wrapper_0.analog_io[16] a_258244_41476# user_project_wrapper_0.IOVDD2 user_project_wrapper_0.IOVDD2 sg13_hv_pmos ad=3.9294p pd=7.84u as=2.1312p ps=7.3u w=6.66u l=0.6u
X7292 user_project_wrapper_0.analog_io[0] a_29676_115444# user_project_wrapper_0.IOVSS1 user_project_wrapper_0.IOVSS1 sg13_hv_nmos ad=2.596p pd=5.58u as=1.408p ps=5.04u w=4.4u l=0.6u
X7293 a_309917_199879# a_309516_194555# VDD3 VDD3 sg13_lv_pmos ad=0.19p pd=1.38u as=0.19p ps=1.38u w=1u l=0.7u
X7294 a_296731_189665# a_296625_189595# VDD3 VDD3 sg13_lv_pmos ad=0.2603p pd=1.75u as=0.2603p ps=1.75u w=1.37u l=0.35u
X7295 user_project_wrapper_0.IOVSS1 a_213870_324142# user_project_wrapper_0.analog_io[35] user_project_wrapper_0.IOVSS1 sg13_lv_nmos ad=0.912p pd=5.18u as=0.912p ps=5.18u w=4.8u l=0.13u
X7296 a_217444_41476# user_project_wrapper_0.IOVDD2 user_project_wrapper_0.IOVDD2 rppd l=12.9u w=0.5u
X7297 a_296731_189665# a_296625_189595# VDD3 VDD3 sg13_lv_pmos ad=0.2603p pd=1.75u as=0.2603p ps=1.75u w=1.37u l=0.35u
X7298 user_project_wrapper_0.IOVSS1 a_190047_324119# a_187364_324106# user_project_wrapper_0.IOVSS1 sg13_lv_nmos ad=0.34p pd=2.68u as=0.19p ps=1.38u w=1u l=0.13u
X7299 a_296731_189665# a_296625_189595# VDD3 VDD3 sg13_lv_pmos ad=0.2603p pd=1.75u as=0.4658p ps=3.42u w=1.37u l=0.35u
X7300 user_project_wrapper_0.IOVSS1 a_156244_369296# user_project_wrapper_0.analog_io[29] user_project_wrapper_0.IOVSS1 sg13_hv_nmos ad=1.408p pd=5.04u as=2.596p ps=5.58u w=4.4u l=0.6u
X7301 user_project_wrapper_0.IOVSS1 user_project_wrapper_0.sg13g2_IOPadVdd_2.sg13g2_RCClampInverter_noptap_0.out user_project_wrapper_0.VDD1 user_project_wrapper_0.IOVSS1 sg13_hv_nmos ad=1.408p pd=5.04u as=2.596p ps=5.58u w=4.4u l=0.6u
X7302 QDLL_TOP_0.VDD QDLL_TOP_0.VOUT a_187914_99087# QDLL_TOP_0.VDD sg13_lv_pmos ad=0.1523p pd=1.38u as=0.1428p ps=1.52u w=0.42u l=0.13u
X7303 a_360372_304045# a_364458_303715# user_project_wrapper_0.IOVSS1 rppd l=20u w=1u
X7304 VDD3 a_296625_189595# a_296731_189665# VDD3 sg13_lv_pmos ad=0.4658p pd=3.42u as=0.2603p ps=1.75u w=1.37u l=0.35u
X7305 a_300415_364458# a_300085_360372# user_project_wrapper_0.IOVSS1 rppd l=20u w=1u
X7306 user_project_wrapper_0.IOVSS1 user_project_wrapper_0.analog_io[32] dantenna l=1.26u w=27.78u
X7307 a_296731_208493# a_296625_208423# VDD3 VDD3 sg13_lv_pmos ad=0.2603p pd=1.75u as=0.2603p ps=1.75u w=1.37u l=0.35u
X7308 analog_io[20] a_369296_156244# user_project_wrapper_0.IOVSS1 user_project_wrapper_0.IOVSS1 sg13_hv_nmos ad=2.596p pd=5.58u as=1.408p ps=5.04u w=4.4u l=0.6u
X7309 user_project_wrapper_0.IOVSS1 user_project_wrapper_0.sg13g2_IOPadVdd_2.sg13g2_RCClampInverter_noptap_0.out user_project_wrapper_0.VDD1 user_project_wrapper_0.IOVSS1 sg13_hv_nmos ad=1.408p pd=5.04u as=2.596p ps=5.58u w=4.4u l=0.6u
X7310 a_296731_189665# a_296625_189595# VDD3 VDD3 sg13_lv_pmos ad=0.2603p pd=1.75u as=0.2603p ps=1.75u w=1.37u l=0.35u
X7311 a_191417_110495# a_191975_108410# user_project_wrapper_0.IOVSS1 rppd l=10u w=1u
X7312 VDD3 a_309516_194555# a_309917_199879# VDD3 sg13_lv_pmos ad=0.19p pd=1.38u as=0.19p ps=1.38u w=1u l=0.7u
X7313 VDD3 user_project_wrapper_0.sg13g2_IOPadVdd_0.sg13g2_RCClampInverter_noptap_0.out user_project_wrapper_0.IOVSS1 user_project_wrapper_0.IOVSS1 sg13_hv_nmos ad=2.596p pd=5.58u as=1.408p ps=5.04u w=4.4u l=0.6u
X7314 user_project_wrapper_0.VDD2 user_project_wrapper_0.sg13g2_IOPadVdd_1.sg13g2_RCClampResistor_0.p2 user_project_wrapper_0.sg13g2_IOPadVdd_1.sg13g2_RCClampInverter_noptap_0.out user_project_wrapper_0.VDD2 sg13_hv_pmos ad=1.33p pd=7.38u as=1.33p ps=7.38u w=7u l=0.5u
X7315 user_project_wrapper_0.VDD2 user_project_wrapper_0.sg13g2_IOPadVdd_1.sg13g2_RCClampInverter_noptap_0.out user_project_wrapper_0.IOVSS1 user_project_wrapper_0.IOVSS1 sg13_hv_nmos ad=3.256p pd=10.28u as=1.408p ps=5.04u w=4.4u l=0.6u
X7316 user_project_wrapper_0.VDD2 user_project_wrapper_0.sg13g2_IOPadVdd_1.sg13g2_RCClampInverter_noptap_0.out user_project_wrapper_0.IOVSS1 user_project_wrapper_0.IOVSS1 sg13_hv_nmos ad=2.596p pd=5.58u as=1.408p ps=5.04u w=4.4u l=0.6u
X7317 user_project_wrapper_0.IOVSS1 a_217444_29676# user_project_wrapper_0.analog_io[14] user_project_wrapper_0.IOVSS1 sg13_hv_nmos ad=1.408p pd=5.04u as=2.596p ps=5.58u w=4.4u l=0.6u
X7318 a_296731_208493# a_296625_208423# VDD3 VDD3 sg13_lv_pmos ad=0.2603p pd=1.75u as=0.2603p ps=1.75u w=1.37u l=0.35u
X7319 a_270512_100118# a_270178_100118# QDLL_TOP_0.VDD QDLL_TOP_0.VDD sg13_lv_pmos ad=0.2128p pd=1.5u as=0.2128p ps=1.5u w=1.12u l=0.13u
X7320 VDD3 a_296625_189595# a_296731_189665# VDD3 sg13_lv_pmos ad=0.2603p pd=1.75u as=0.2603p ps=1.75u w=1.37u l=0.35u
X7321 user_project_wrapper_0.IOVDD4 a_217444_355624# user_project_wrapper_0.analog_io[32] user_project_wrapper_0.IOVDD4 sg13_hv_pmos ad=2.1312p pd=7.3u as=3.9294p ps=7.84u w=6.66u l=0.6u
X7322 user_project_wrapper_0.IOVDD2 a_217444_41476# user_project_wrapper_0.analog_io[14] user_project_wrapper_0.IOVDD2 sg13_hv_pmos ad=2.1312p pd=7.3u as=3.9294p ps=7.84u w=6.66u l=0.6u
X7323 user_project_wrapper_0.IOVSS1 analog_io[19] dantenna l=27.78u w=1.26u
X7324 user_project_wrapper_0.VDD1 user_project_wrapper_0.sg13g2_IOPadVdd_2.sg13g2_RCClampInverter_noptap_0.out user_project_wrapper_0.IOVSS1 user_project_wrapper_0.IOVSS1 sg13_hv_nmos ad=2.596p pd=5.58u as=1.408p ps=5.04u w=4.4u l=0.6u
X7325 user_project_wrapper_0.analog_io[4] a_41476_197044# user_project_wrapper_0.IOVDD1 user_project_wrapper_0.IOVDD1 sg13_hv_pmos ad=3.9294p pd=7.84u as=3.1302p ps=14.26u w=6.66u l=0.6u
X7326 a_296731_208493# a_296625_208423# VDD3 VDD3 sg13_lv_pmos ad=0.2603p pd=1.75u as=0.4658p ps=3.42u w=1.37u l=0.35u
X7327 analog_io[20] a_355624_176644# IOVDD3 IOVDD3 sg13_hv_pmos ad=3.9294p pd=7.84u as=2.1312p ps=7.3u w=6.66u l=0.6u
X7328 user_project_wrapper_0.analog_io[16] user_project_wrapper_0.IOVDD2 dpantenna l=1.26u w=27.78u
X7329 user_project_wrapper_0.IOVSS1 user_project_wrapper_0.sg13g2_IOPadIOVdd_0.sg13g2_Clamp_N43N43D4R_0.gate user_project_wrapper_0.IOVDD2 user_project_wrapper_0.IOVSS1 sg13_hv_nmos ad=1.408p pd=5.04u as=2.596p ps=5.58u w=4.4u l=0.6u
X7330 VDD3 a_309516_194555# a_309516_194555# VDD3 sg13_lv_pmos ad=0.19p pd=1.38u as=0.19p ps=1.38u w=1u l=0.7u
X7331 user_project_wrapper_0.IOVSS1 user_project_wrapper_0.sg13g2_IOPadVdd_1.sg13g2_RCClampResistor_0.p2 user_project_wrapper_0.IOVSS1 user_project_wrapper_0.IOVSS1 sg13_hv_nmos ad=1.71p pd=9.38u as=0 ps=0 w=9u l=9.5u
X7332 user_project_wrapper_0.IOVDD2 a_278644_41476# QDLL_TOP_0.VOUT user_project_wrapper_0.IOVDD2 sg13_hv_pmos ad=2.1312p pd=7.3u as=3.9294p ps=7.84u w=6.66u l=0.6u
X7333 a_296731_208493# a_296625_208423# VDD3 VDD3 sg13_lv_pmos ad=0.2603p pd=1.75u as=0.2603p ps=1.75u w=1.37u l=0.35u
X7334 user_project_wrapper_0.analog_io[5] a_41476_217444# user_project_wrapper_0.IOVDD1 user_project_wrapper_0.IOVDD1 sg13_hv_pmos ad=3.9294p pd=7.84u as=2.1312p ps=7.3u w=6.66u l=0.6u
X7335 user_project_wrapper_0.IOVDD1 user_project_wrapper_0.sg13g2_IOPadIOVdd_1.sg13g2_Clamp_N43N43D4R_0.gate user_project_wrapper_0.IOVSS1 user_project_wrapper_0.IOVSS1 sg13_hv_nmos ad=2.596p pd=5.58u as=2.068p ps=9.74u w=4.4u l=0.6u
X7336 user_project_wrapper_0.IOVSS1 a_29676_115444# user_project_wrapper_0.analog_io[0] user_project_wrapper_0.IOVSS1 sg13_hv_nmos ad=2.068p pd=9.74u as=2.596p ps=5.58u w=4.4u l=0.6u
X7337 a_188572_99046# a_188296_99070# QDLL_TOP_0.VDD QDLL_TOP_0.VDD sg13_lv_pmos ad=0.4256p pd=3u as=0.2254p ps=1.53u w=1.12u l=0.13u
X7338 user_project_wrapper_0.IOVSS1 a_209480_326377# a_210109_326377# w_207887_326203# sg13_lv_pmos ad=0.68p pd=4.68u as=0.38p ps=2.38u w=2u l=0.13u
X7339 a_190926_327099# a_190501_326377# a_190824_326377# user_project_wrapper_0.IOVSS1 sg13_lv_nmos ad=0.19p pd=1.38u as=0.19p ps=1.38u w=1u l=0.13u
X7340 user_project_wrapper_0.IOVSS1 a_182931_326125# user_project_wrapper_0.analog_io[27] user_project_wrapper_0.IOVSS1 sg13_lv_nmos ad=0.912p pd=5.18u as=0.912p ps=5.18u w=4.8u l=0.13u
X7341 a_82846_241091# a_82859_239842# user_project_wrapper_0.IOVSS1 user_project_wrapper_0.IOVSS1 sg13_lv_nmos ad=0.1428p pd=1.52u as=0.1428p ps=1.52u w=0.42u l=0.56u
X7342 user_project_wrapper_0.IOVDD4 a_258244_355624# user_project_wrapper_0.analog_io[34] user_project_wrapper_0.IOVDD4 sg13_hv_pmos ad=2.1312p pd=7.3u as=3.9294p ps=7.84u w=6.66u l=0.6u
X7343 a_213870_324142# a_213462_327536# user_project_wrapper_0.IOVSS1 user_project_wrapper_0.IOVSS1 sg13_lv_nmos ad=0.912p pd=5.18u as=0.912p ps=5.18u w=4.8u l=0.13u
X7344 user_project_wrapper_0.IOVSS1 user_project_wrapper_0.sg13g2_IOPadVdd_2.sg13g2_RCClampResistor_0.p2 user_project_wrapper_0.sg13g2_IOPadVdd_2.sg13g2_RCClampInverter_noptap_0.out user_project_wrapper_0.IOVSS1 sg13_hv_nmos ad=1.71p pd=9.38u as=1.71p ps=9.38u w=9u l=0.5u
X7345 VDD3 a_296625_189595# a_296731_189665# VDD3 sg13_lv_pmos ad=0.2603p pd=1.75u as=0.2603p ps=1.75u w=1.37u l=0.35u
X7346 user_project_wrapper_0.analog_io[28] a_135844_369296# user_project_wrapper_0.IOVSS1 user_project_wrapper_0.IOVSS1 sg13_hv_nmos ad=2.596p pd=5.58u as=1.408p ps=5.04u w=4.4u l=0.6u
X7347 a_91911_127530# a_91090_127895# user_project_wrapper_0.VDD1 user_project_wrapper_0.VDD1 sg13_lv_pmos ad=0.3808p pd=2.92u as=0.3808p ps=2.92u w=1.12u l=0.13u
X7348 user_project_wrapper_0.IOVSS1 a_307232_196607# a_304995_198817# user_project_wrapper_0.IOVSS1 sg13_lv_nmos ad=0.6327p pd=3.71u as=0.6327p ps=3.71u w=3.33u l=0.2u
X7349 analog_io[25] a_355624_258244# IOVDD3 IOVDD3 sg13_hv_pmos ad=3.9294p pd=7.84u as=2.1312p ps=7.3u w=6.66u l=0.6u
X7350 a_208855_324776# a_211928_324776# user_project_wrapper_0.IOVSS1 user_project_wrapper_0.IOVSS1 sg13_lv_nmos ad=0.19p pd=1.38u as=0.34p ps=2.68u w=1u l=0.13u
X7351 user_project_wrapper_0.analog_io[27] a_115444_355624# user_project_wrapper_0.IOVDD4 user_project_wrapper_0.IOVDD4 sg13_hv_pmos ad=3.9294p pd=7.84u as=2.1312p ps=7.3u w=6.66u l=0.6u
X7352 user_project_wrapper_0.IOVSS1 user_project_wrapper_0.sg13g2_IOPadVdd_1.sg13g2_RCClampInverter_noptap_0.out user_project_wrapper_0.VDD2 user_project_wrapper_0.IOVSS1 sg13_hv_nmos ad=1.408p pd=5.04u as=2.596p ps=5.58u w=4.4u l=0.6u
X7353 user_project_wrapper_0.sg13g2_IOPadVdd_3.sg13g2_RCClampInverter_noptap_0.out user_project_wrapper_0.sg13g2_IOPadVdd_3.sg13g2_RCClampResistor_0.p2 user_project_wrapper_0.IOVSS1 user_project_wrapper_0.IOVSS1 sg13_hv_pmos ad=1.33p pd=7.38u as=1.33p ps=7.38u w=7u l=0.5u
X7354 a_296732_197880# a_301940_196388# a_296625_189595# VDD3 sg13_lv_pmos ad=0.7695p pd=4.43u as=0.7695p ps=4.43u w=4.05u l=0.5u
X7355 user_project_wrapper_0.VDD2 user_project_wrapper_0.sg13g2_IOPadVdd_1.sg13g2_RCClampInverter_noptap_0.out user_project_wrapper_0.IOVSS1 user_project_wrapper_0.IOVSS1 sg13_hv_nmos ad=2.596p pd=5.58u as=1.408p ps=5.04u w=4.4u l=0.6u
X7356 user_project_wrapper_0.IOVSS1 user_project_wrapper_0.uo_PAD[3] dantenna l=27.78u w=1.26u
X7357 user_project_wrapper_0.IOVSS1 user_project_wrapper_0.sg13g2_IOPadIOVdd_2.sg13g2_Clamp_N43N43D4R_0.gate user_project_wrapper_0.IOVDD4 user_project_wrapper_0.IOVSS1 sg13_hv_nmos ad=1.408p pd=5.04u as=2.596p ps=5.58u w=4.4u l=0.6u
X7358 user_project_wrapper_0.IOVSS1 user_project_wrapper_0.sg13g2_IOPadVdd_3.sg13g2_RCClampInverter_noptap_0.out user_project_wrapper_0.IOVSS1 user_project_wrapper_0.IOVSS1 sg13_hv_nmos ad=2.596p pd=5.58u as=0 ps=0 w=4.4u l=0.6u
X7359 user_project_wrapper_0.analog_io[30] a_194687_324142# user_project_wrapper_0.IOVSS1 user_project_wrapper_0.IOVSS1 sg13_lv_nmos ad=0.912p pd=5.18u as=0.912p ps=5.18u w=4.8u l=0.13u
X7360 user_project_wrapper_0.IOVDD1 a_41476_135844# user_project_wrapper_0.analog_io[1] user_project_wrapper_0.IOVDD1 sg13_hv_pmos ad=2.1312p pd=7.3u as=3.9294p ps=7.84u w=6.66u l=0.6u
X7361 user_project_wrapper_0.IOVSS1 user_project_wrapper_0.sg13g2_IOPadIOVdd_3.sg13g2_RCClampResistor_0.p2 user_project_wrapper_0.sg13g2_IOPadIOVdd_3.sg13g2_Clamp_N43N43D4R_0.gate user_project_wrapper_0.IOVSS1 sg13_hv_nmos ad=1.71p pd=9.38u as=1.71p ps=9.38u w=9u l=0.5u
X7362 user_project_wrapper_0.IOVSS1 user_project_wrapper_0.sg13g2_IOPadIOVdd_3.sg13g2_Clamp_N43N43D4R_0.gate IOVDD3 user_project_wrapper_0.IOVSS1 sg13_hv_nmos ad=1.408p pd=5.04u as=2.596p ps=5.58u w=4.4u l=0.6u
X7363 user_project_wrapper_0.IOVSS1 user_project_wrapper_0.sg13g2_IOPadIOVdd_3.sg13g2_Clamp_N43N43D4R_0.gate IOVDD3 user_project_wrapper_0.IOVSS1 sg13_hv_nmos ad=1.408p pd=5.04u as=2.596p ps=5.58u w=4.4u l=0.6u
X7364 user_project_wrapper_0.IOVSS1 user_project_wrapper_0.IOVSS1 user_project_wrapper_0.IOVSS1 rppd l=0.5u w=0.5u
X7365 user_project_wrapper_0.IOVSS1 user_project_wrapper_0.sg13g2_IOPadVdd_3.sg13g2_RCClampInverter_noptap_0.out user_project_wrapper_0.IOVSS1 user_project_wrapper_0.IOVSS1 sg13_hv_nmos ad=2.596p pd=5.58u as=0 ps=0 w=4.4u l=0.6u
X7366 user_project_wrapper_0.IOVDD4 a_135844_355624# user_project_wrapper_0.analog_io[28] user_project_wrapper_0.IOVDD4 sg13_hv_pmos ad=2.1312p pd=7.3u as=3.9294p ps=7.84u w=6.66u l=0.6u
X7367 a_82746_130212# a_79025_127401# user_project_wrapper_0.VDD1 user_project_wrapper_0.VDD1 sg13_lv_pmos ad=0.3808p pd=2.92u as=0.3808p ps=2.92u w=1.12u l=0.13u
X7368 analog_io[23] a_369296_217444# user_project_wrapper_0.IOVSS1 user_project_wrapper_0.IOVSS1 sg13_hv_nmos ad=2.596p pd=5.58u as=1.408p ps=5.04u w=4.4u l=0.6u
X7369 user_project_wrapper_0.IOVSS1 user_project_wrapper_0.sg13g2_IOPadVdd_0.sg13g2_RCClampInverter_noptap_0.out VDD3 user_project_wrapper_0.IOVSS1 sg13_hv_nmos ad=1.408p pd=5.04u as=2.596p ps=5.58u w=4.4u l=0.6u
X7370 user_project_wrapper_0.analog_io[6] a_41476_237844# user_project_wrapper_0.IOVDD1 user_project_wrapper_0.IOVDD1 sg13_hv_pmos ad=3.9294p pd=7.84u as=2.1312p ps=7.3u w=6.66u l=0.6u
X7371 a_296731_208493# a_301186_192011# user_project_wrapper_0.IOVSS1 user_project_wrapper_0.IOVSS1 sg13_lv_nmos ad=1.632p pd=10.28u as=0.912p ps=5.18u w=4.8u l=1.06u
X7372 user_project_wrapper_0.IOVSS1 user_project_wrapper_0.sg13g2_IOPadIOVdd_1.sg13g2_Clamp_N43N43D4R_0.gate user_project_wrapper_0.IOVDD1 user_project_wrapper_0.IOVSS1 sg13_hv_nmos ad=1.408p pd=5.04u as=2.596p ps=5.58u w=4.4u l=0.6u
X7373 VDD3 a_296625_189595# a_296731_189665# VDD3 sg13_lv_pmos ad=0.2603p pd=1.75u as=0.2603p ps=1.75u w=1.37u l=0.35u
X7374 user_project_wrapper_0.IOVSS1 a_205385_326221# a_202114_326125# user_project_wrapper_0.IOVSS1 sg13_lv_pmos ad=1.824p pd=9.98u as=1.824p ps=9.98u w=9.6u l=0.13u
X7375 user_project_wrapper_0.IOVSS1 user_project_wrapper_0.sg13g2_IOPadVdd_0.sg13g2_RCClampInverter_noptap_0.out VDD3 user_project_wrapper_0.IOVSS1 sg13_hv_nmos ad=1.408p pd=5.04u as=2.596p ps=5.58u w=4.4u l=0.6u
X7376 a_304995_198817# a_307232_196607# user_project_wrapper_0.IOVSS1 user_project_wrapper_0.IOVSS1 sg13_lv_nmos ad=0.6327p pd=3.71u as=0.6327p ps=3.71u w=3.33u l=0.2u
X7377 a_309917_199879# a_296731_208493# a_307232_196607# VDD3 sg13_lv_pmos ad=0.24415p pd=1.665u as=0.24415p ps=1.665u w=1.285u l=0.35u
X7378 user_project_wrapper_0.IOVDD1 a_41476_217444# user_project_wrapper_0.analog_io[5] user_project_wrapper_0.IOVDD1 sg13_hv_pmos ad=3.1302p pd=14.26u as=3.9294p ps=7.84u w=6.66u l=0.6u
X7379 a_307232_196607# a_296731_208493# a_309917_199879# VDD3 sg13_lv_pmos ad=0.24415p pd=1.665u as=0.24415p ps=1.665u w=1.285u l=0.35u
X7380 user_project_wrapper_0.analog_io[13] a_197044_41476# user_project_wrapper_0.IOVDD2 user_project_wrapper_0.IOVDD2 sg13_hv_pmos ad=3.9294p pd=7.84u as=2.1312p ps=7.3u w=6.66u l=0.6u
X7381 user_project_wrapper_0.IOVSS1 user_project_wrapper_0.sg13g2_IOPadIOVdd_3.sg13g2_RCClampResistor_0.p2 user_project_wrapper_0.sg13g2_IOPadIOVdd_3.sg13g2_Clamp_N43N43D4R_0.gate user_project_wrapper_0.IOVSS1 sg13_hv_nmos ad=1.71p pd=9.38u as=1.71p ps=9.38u w=9u l=0.5u
X7382 user_project_wrapper_0.analog_io[35] a_213870_324142# user_project_wrapper_0.IOVSS1 user_project_wrapper_0.IOVSS1 sg13_lv_nmos ad=0.912p pd=5.18u as=0.912p ps=5.18u w=4.8u l=0.13u
X7383 user_project_wrapper_0.IOVSS1 a_182931_326125# user_project_wrapper_0.analog_io[27] user_project_wrapper_0.IOVSS1 sg13_lv_nmos ad=0.912p pd=5.18u as=0.912p ps=5.18u w=4.8u l=0.13u
X7384 user_project_wrapper_0.IOVSS1 user_project_wrapper_0.sg13g2_IOPadAnalog_19.padres a_189858_327491# user_project_wrapper_0.IOVSS1 sg13_lv_nmos ad=0.34p pd=2.68u as=0.19p ps=1.38u w=1u l=0.13u
X7385 a_307232_196607# a_296731_189665# a_309917_194695# VDD3 sg13_lv_pmos ad=0.24415p pd=1.665u as=0.24415p ps=1.665u w=1.285u l=0.35u
X7386 user_project_wrapper_0.IOVSS1 user_project_wrapper_0.IOVSS1 user_project_wrapper_0.IOVSS1 rppd l=0.5u w=0.5u
X7387 user_project_wrapper_0.IOVSS1 user_project_wrapper_0.sg13g2_IOPadVdd_3.sg13g2_RCClampInverter_noptap_0.out user_project_wrapper_0.IOVSS1 user_project_wrapper_0.IOVSS1 sg13_hv_nmos ad=1.408p pd=5.04u as=0 ps=0 w=4.4u l=0.6u
X7388 user_project_wrapper_0.VDD1 user_project_wrapper_0.sg13g2_IOPadVdd_2.sg13g2_RCClampInverter_noptap_0.out user_project_wrapper_0.IOVSS1 user_project_wrapper_0.IOVSS1 sg13_hv_nmos ad=2.596p pd=5.58u as=1.408p ps=5.04u w=4.4u l=0.6u
X7389 analog_io[22] a_355624_197044# IOVDD3 IOVDD3 sg13_hv_pmos ad=3.9294p pd=7.84u as=2.1312p ps=7.3u w=6.66u l=0.6u
X7390 VDD3 a_309516_194555# a_309917_194695# VDD3 sg13_lv_pmos ad=0.19p pd=1.38u as=0.19p ps=1.38u w=1u l=0.7u
X7391 user_project_wrapper_0.IOVSS1 a_301186_192011# a_296731_208493# user_project_wrapper_0.IOVSS1 sg13_lv_nmos ad=0.912p pd=5.18u as=0.912p ps=5.18u w=4.8u l=1.06u
X7392 user_project_wrapper_0.VDD1 a_83925_130212# a_84598_130577# user_project_wrapper_0.VDD1 sg13_lv_pmos ad=0.3808p pd=2.92u as=0.2128p ps=1.5u w=1.12u l=0.13u
X7393 user_project_wrapper_0.sg13g2_IOPadAnalog_8.padres user_project_wrapper_0.IOVDD1 dpantenna l=4.98u w=0.64u
X7394 a_314697_196700# a_314793_201808# a_315347_192648# user_project_wrapper_0.IOVSS1 sg13_lv_nmos ad=1.14p pd=6.38u as=1.14p ps=6.38u w=6u l=6.4u
X7395 user_project_wrapper_0.IOVSS1 analog_io[23] dantenna l=0.64u w=3.1u
X7396 a_85989_241748# a_85591_241748# user_project_wrapper_0.VDD1 user_project_wrapper_0.VDD1 sg13_lv_pmos ad=0.2128p pd=1.5u as=0.3808p ps=2.92u w=1.12u l=0.13u
X7397 user_project_wrapper_0.analog_io[30] a_194687_324142# user_project_wrapper_0.IOVSS1 user_project_wrapper_0.IOVSS1 sg13_lv_pmos ad=1.824p pd=9.98u as=1.824p ps=9.98u w=9.6u l=0.13u
X7398 user_project_wrapper_0.IOVDD4 a_176644_355624# user_project_wrapper_0.analog_io[30] user_project_wrapper_0.IOVDD4 sg13_hv_pmos ad=2.1312p pd=7.3u as=3.9294p ps=7.84u w=6.66u l=0.6u
X7399 user_project_wrapper_0.IOVDD2 a_237844_41476# user_project_wrapper_0.analog_io[15] user_project_wrapper_0.IOVDD2 sg13_hv_pmos ad=2.1312p pd=7.3u as=3.9294p ps=7.84u w=6.66u l=0.6u
X7400 VDD3 a_309516_194555# a_309917_199879# VDD3 sg13_lv_pmos ad=0.19p pd=1.38u as=0.19p ps=1.38u w=1u l=0.7u
X7401 user_project_wrapper_0.sg13g2_IOPadVdd_1.sg13g2_RCClampInverter_noptap_0.out user_project_wrapper_0.sg13g2_IOPadVdd_1.sg13g2_RCClampResistor_0.p2 user_project_wrapper_0.IOVSS1 user_project_wrapper_0.IOVSS1 sg13_hv_nmos ad=1.71p pd=9.38u as=1.71p ps=9.38u w=9u l=0.5u
X7402 VDD3 a_296625_208423# a_296731_208493# VDD3 sg13_lv_pmos ad=0.2603p pd=1.75u as=0.2603p ps=1.75u w=1.37u l=0.35u
X7403 a_309917_194695# a_309516_194555# VDD3 VDD3 sg13_lv_pmos ad=0.19p pd=1.38u as=0.19p ps=1.38u w=1u l=0.7u
X7404 user_project_wrapper_0.IOVDD1 user_project_wrapper_0.sg13g2_IOPadIOVdd_1.sg13g2_Clamp_N43N43D4R_0.gate user_project_wrapper_0.IOVSS1 user_project_wrapper_0.IOVSS1 sg13_hv_nmos ad=2.596p pd=5.58u as=1.408p ps=5.04u w=4.4u l=0.6u
X7405 a_213462_327536# a_213376_328627# user_project_wrapper_0.IOVSS1 user_project_wrapper_0.IOVSS1 sg13_lv_pmos ad=1.824p pd=9.98u as=1.824p ps=9.98u w=9.6u l=0.13u
X7406 user_project_wrapper_0.analog_io[11] a_156244_41476# user_project_wrapper_0.IOVDD2 user_project_wrapper_0.IOVDD2 sg13_hv_pmos ad=3.9294p pd=7.84u as=2.1312p ps=7.3u w=6.66u l=0.6u
X7407 a_307232_196607# a_307232_196607# user_project_wrapper_0.IOVSS1 user_project_wrapper_0.IOVSS1 sg13_lv_nmos ad=0.6327p pd=3.71u as=0.6327p ps=3.71u w=3.33u l=0.2u
X7408 user_project_wrapper_0.IOVSS1 a_29676_237844# user_project_wrapper_0.analog_io[6] user_project_wrapper_0.IOVSS1 sg13_hv_nmos ad=1.408p pd=5.04u as=2.596p ps=5.58u w=4.4u l=0.6u
X7409 a_80635_364458# a_80965_360372# user_project_wrapper_0.IOVSS1 rppd l=20u w=1u
X7410 a_189858_328605# a_189756_329719# a_189756_328605# w_188704_327938# sg13_lv_pmos ad=0.38p pd=2.38u as=0.38p ps=2.38u w=2u l=0.13u
X7411 user_project_wrapper_0.IOVSS1 user_project_wrapper_0.sg13g2_IOPadVdd_2.sg13g2_RCClampResistor_0.p2 user_project_wrapper_0.IOVSS1 user_project_wrapper_0.IOVSS1 sg13_hv_nmos ad=1.71p pd=9.38u as=0 ps=0 w=9u l=9.5u
X7412 user_project_wrapper_0.IOVSS1 a_271172_100118# QDLL_TOP_0.VOUT user_project_wrapper_0.IOVSS1 sg13_lv_nmos ad=0.1406p pd=1.12u as=0.1406p ps=1.12u w=0.74u l=0.13u
X7413 user_project_wrapper_0.IOVSS1 a_369296_217444# analog_io[23] user_project_wrapper_0.IOVSS1 sg13_hv_nmos ad=1.408p pd=5.04u as=2.596p ps=5.58u w=4.4u l=0.6u
X7414 user_project_wrapper_0.IOVSS1 user_project_wrapper_0.sg13g2_IOPadIOVdd_3.sg13g2_Clamp_N43N43D4R_0.gate IOVDD3 user_project_wrapper_0.IOVSS1 sg13_hv_nmos ad=1.408p pd=5.04u as=2.596p ps=5.58u w=4.4u l=0.6u
X7415 a_309917_199879# a_309516_194555# VDD3 VDD3 sg13_lv_pmos ad=0.19p pd=1.38u as=0.19p ps=1.38u w=1u l=0.7u
X7416 user_project_wrapper_0.analog_io[35] a_213870_324142# user_project_wrapper_0.IOVSS1 user_project_wrapper_0.IOVSS1 sg13_lv_pmos ad=1.824p pd=9.98u as=1.824p ps=9.98u w=9.6u l=0.13u
X7417 user_project_wrapper_0.IOVSS1 user_project_wrapper_0.sg13g2_IOPadVdd_3.sg13g2_RCClampInverter_noptap_0.out user_project_wrapper_0.IOVSS1 user_project_wrapper_0.IOVSS1 sg13_hv_nmos ad=1.408p pd=5.04u as=0 ps=0 w=4.4u l=0.6u
X7418 user_project_wrapper_0.analog_io[30] a_194687_324142# user_project_wrapper_0.IOVSS1 user_project_wrapper_0.IOVSS1 sg13_lv_pmos ad=1.824p pd=9.98u as=1.824p ps=9.98u w=9.6u l=0.13u
X7419 user_project_wrapper_0.IOVDD2 a_197044_41476# user_project_wrapper_0.analog_io[13] user_project_wrapper_0.IOVDD2 sg13_hv_pmos ad=2.1312p pd=7.3u as=3.9294p ps=7.84u w=6.66u l=0.6u
X7420 user_project_wrapper_0.IOVSS1 user_project_wrapper_0.sg13g2_IOPadVdd_1.sg13g2_RCClampInverter_noptap_0.out user_project_wrapper_0.VDD2 user_project_wrapper_0.IOVSS1 sg13_hv_nmos ad=1.408p pd=5.04u as=2.596p ps=5.58u w=4.4u l=0.6u
X7421 user_project_wrapper_0.IOVSS1 user_project_wrapper_0.sg13g2_IOPadIOVdd_0.sg13g2_Clamp_N43N43D4R_0.gate user_project_wrapper_0.IOVDD2 user_project_wrapper_0.IOVSS1 sg13_hv_nmos ad=1.408p pd=5.04u as=2.596p ps=5.58u w=4.4u l=0.6u
X7422 analog_io[19] a_369296_135844# user_project_wrapper_0.IOVSS1 user_project_wrapper_0.IOVSS1 sg13_hv_nmos ad=2.596p pd=5.58u as=1.408p ps=5.04u w=4.4u l=0.6u
X7423 user_project_wrapper_0.analog_io[1] a_41476_135844# user_project_wrapper_0.IOVDD1 user_project_wrapper_0.IOVDD1 sg13_hv_pmos ad=3.9294p pd=7.84u as=2.1312p ps=7.3u w=6.66u l=0.6u
X7424 analog_io[19] a_355624_135844# IOVDD3 IOVDD3 sg13_hv_pmos ad=3.9294p pd=7.84u as=2.1312p ps=7.3u w=6.66u l=0.6u
X7425 user_project_wrapper_0.IOVDD1 user_project_wrapper_0.sg13g2_IOPadIOVdd_1.sg13g2_Clamp_N43N43D4R_0.gate user_project_wrapper_0.IOVSS1 user_project_wrapper_0.IOVSS1 sg13_hv_nmos ad=2.596p pd=5.58u as=1.408p ps=5.04u w=4.4u l=0.6u
X7426 VDD3 user_project_wrapper_0.sg13g2_IOPadVdd_0.sg13g2_RCClampInverter_noptap_0.out user_project_wrapper_0.IOVSS1 user_project_wrapper_0.IOVSS1 sg13_hv_nmos ad=2.596p pd=5.58u as=1.408p ps=5.04u w=4.4u l=0.6u
X7427 user_project_wrapper_0.IOVSS1 user_project_wrapper_0.sg13g2_IOPadVdd_1.sg13g2_RCClampResistor_0.p2 user_project_wrapper_0.IOVSS1 user_project_wrapper_0.IOVSS1 sg13_hv_nmos ad=1.71p pd=9.38u as=0 ps=0 w=9u l=9.5u
X7428 a_311108_215937# analog_io[23] a_313884_211353# user_project_wrapper_0.IOVSS1 sg13_lv_nmos ad=1.9p pd=10.38u as=1.9p ps=10.38u w=10u l=0.5u
X7429 user_project_wrapper_0.analog_io[30] a_194687_324142# user_project_wrapper_0.IOVSS1 user_project_wrapper_0.IOVSS1 sg13_lv_pmos ad=1.824p pd=9.98u as=1.824p ps=9.98u w=9.6u l=0.13u
X7430 a_278644_41476# user_project_wrapper_0.IOVDD2 user_project_wrapper_0.IOVDD2 rppd l=12.9u w=0.5u
X7431 user_project_wrapper_0.IOVDD1 a_41476_258244# user_project_wrapper_0.analog_io[7] user_project_wrapper_0.IOVDD1 sg13_hv_pmos ad=2.1312p pd=7.3u as=3.9294p ps=7.84u w=6.66u l=0.6u
X7432 a_209041_329719# a_208939_325263# a_208939_329719# user_project_wrapper_0.IOVSS1 sg13_lv_nmos ad=0.19p pd=1.38u as=0.19p ps=1.38u w=1u l=0.13u
X7433 user_project_wrapper_0.analog_io[32] a_217444_355624# user_project_wrapper_0.IOVDD4 user_project_wrapper_0.IOVDD4 sg13_hv_pmos ad=3.9294p pd=7.84u as=3.1302p ps=14.26u w=6.66u l=0.6u
X7434 a_296731_189665# a_296625_189595# VDD3 VDD3 sg13_lv_pmos ad=0.2603p pd=1.75u as=0.2603p ps=1.75u w=1.37u l=0.35u
X7435 user_project_wrapper_0.IOVSS1 user_project_wrapper_0.sg13g2_IOPadVdd_2.sg13g2_RCClampInverter_noptap_0.out user_project_wrapper_0.VDD1 user_project_wrapper_0.IOVSS1 sg13_hv_nmos ad=1.408p pd=5.04u as=2.596p ps=5.58u w=4.4u l=0.6u
X7436 IOVDD3 user_project_wrapper_0.sg13g2_IOPadIOVdd_3.sg13g2_Clamp_N43N43D4R_0.gate user_project_wrapper_0.IOVSS1 user_project_wrapper_0.IOVSS1 sg13_hv_nmos ad=2.596p pd=5.58u as=1.408p ps=5.04u w=4.4u l=0.6u
X7437 a_191438_326377# TOP_ROILIFNEURON_0.MEM user_project_wrapper_0.IOVSS1 rppd l=0.5u w=0.5u
X7438 a_85127_131750# a_84707_131750# user_project_wrapper_0.VDD1 user_project_wrapper_0.VDD1 sg13_lv_pmos ad=0.3808p pd=2.92u as=0.3808p ps=2.92u w=1.12u l=0.13u
X7439 user_project_wrapper_0.IOVSS1 a_217444_369296# user_project_wrapper_0.IOVSS1 rppd l=3.54u w=0.5u
X7440 user_project_wrapper_0.analog_io[0] a_41476_115444# user_project_wrapper_0.IOVDD1 user_project_wrapper_0.IOVDD1 sg13_hv_pmos ad=3.9294p pd=7.84u as=2.1312p ps=7.3u w=6.66u l=0.6u
X7441 a_35456_300415# a_39542_300085# user_project_wrapper_0.IOVSS1 rppd l=20u w=1u
X7442 user_project_wrapper_0.IOVSS1 user_project_wrapper_0.sg13g2_IOPadVdd_2.sg13g2_RCClampInverter_noptap_0.out user_project_wrapper_0.VDD1 user_project_wrapper_0.IOVSS1 sg13_hv_nmos ad=1.408p pd=5.04u as=2.596p ps=5.58u w=4.4u l=0.6u
X7443 analog_io[23] a_369296_217444# user_project_wrapper_0.IOVSS1 user_project_wrapper_0.IOVSS1 sg13_hv_nmos ad=2.596p pd=5.58u as=1.408p ps=5.04u w=4.4u l=0.6u
X7444 user_project_wrapper_0.sg13g2_IOPadIOVdd_0.sg13g2_Clamp_N43N43D4R_0.gate user_project_wrapper_0.sg13g2_IOPadIOVdd_0.sg13g2_RCClampResistor_0.p2 user_project_wrapper_0.IOVDD2 user_project_wrapper_0.IOVDD2 sg13_hv_pmos ad=1.33p pd=7.38u as=1.33p ps=7.38u w=7u l=0.5u
X7445 user_project_wrapper_0.analog_io[35] a_213870_324142# user_project_wrapper_0.IOVSS1 user_project_wrapper_0.IOVSS1 sg13_lv_pmos ad=1.824p pd=9.98u as=1.824p ps=9.98u w=9.6u l=0.13u
X7446 user_project_wrapper_0.IOVSS1 user_project_wrapper_0.sg13g2_IOPadVdd_3.sg13g2_RCClampResistor_0.p2 user_project_wrapper_0.sg13g2_IOPadVdd_3.sg13g2_RCClampInverter_noptap_0.out user_project_wrapper_0.IOVSS1 sg13_hv_pmos ad=1.33p pd=7.38u as=1.33p ps=7.38u w=7u l=0.5u
X7447 analog_io[19] a_355624_135844# IOVDD3 IOVDD3 sg13_hv_pmos ad=3.9294p pd=7.84u as=2.1312p ps=7.3u w=6.66u l=0.6u
X7448 a_35456_77335# a_39542_77665# user_project_wrapper_0.IOVSS1 rppd l=20u w=1u
X7449 a_309516_194555# a_309516_194555# VDD3 VDD3 sg13_lv_pmos ad=0.19p pd=1.38u as=0.19p ps=1.38u w=1u l=0.7u
X7450 user_project_wrapper_0.analog_io[28] a_135844_355624# user_project_wrapper_0.IOVDD4 user_project_wrapper_0.IOVDD4 sg13_hv_pmos ad=3.9294p pd=7.84u as=2.1312p ps=7.3u w=6.66u l=0.6u
X7451 a_309917_199879# a_309516_194555# VDD3 VDD3 sg13_lv_pmos ad=0.19p pd=1.38u as=0.19p ps=1.38u w=1u l=0.7u
X7452 VDD3 a_296626_197740# a_296732_200582# VDD3 sg13_lv_pmos ad=1.33p pd=7.38u as=1.33p ps=7.38u w=7u l=0.7u
X7453 VDD3 a_311108_215937# analog_io[23] user_project_wrapper_0.IOVSS1 sg13_lv_nmos ad=3.4p pd=20.68u as=3.4p ps=20.68u w=10u l=0.15u
X7454 a_309917_194695# user_project_wrapper_0.sg13g2_IOPadAnalog_29.padres a_311846_195517# VDD3 sg13_lv_pmos ad=0.24415p pd=1.665u as=0.24415p ps=1.665u w=1.285u l=0.35u
X7455 user_project_wrapper_0.analog_io[4] user_project_wrapper_0.sg13g2_IOPadAnalog_28.padres user_project_wrapper_0.IOVSS1 rppd l=2u w=1u
X7456 a_190722_329719# a_189756_329719# user_project_wrapper_0.IOVSS1 user_project_wrapper_0.IOVSS1 sg13_lv_nmos ad=0.19p pd=1.38u as=0.34p ps=2.68u w=1u l=0.13u
X7457 user_project_wrapper_0.IOVDD4 user_project_wrapper_0.sg13g2_IOPadIOVdd_2.sg13g2_RCClampResistor_0.p2 user_project_wrapper_0.sg13g2_IOPadIOVdd_2.sg13g2_Clamp_N43N43D4R_0.gate user_project_wrapper_0.IOVDD4 sg13_hv_pmos ad=1.33p pd=7.38u as=1.33p ps=7.38u w=7u l=0.5u
X7458 user_project_wrapper_0.analog_io[35] a_213870_324142# user_project_wrapper_0.IOVSS1 user_project_wrapper_0.IOVSS1 sg13_lv_pmos ad=1.824p pd=9.98u as=1.824p ps=9.98u w=9.6u l=0.13u
X7459 user_project_wrapper_0.IOVDD2 a_278644_41476# QDLL_TOP_0.VOUT user_project_wrapper_0.IOVDD2 sg13_hv_pmos ad=2.1312p pd=7.3u as=3.9294p ps=7.84u w=6.66u l=0.6u
X7460 analog_io[23] a_355624_237844# IOVDD3 IOVDD3 sg13_hv_pmos ad=3.9294p pd=7.84u as=2.1312p ps=7.3u w=6.66u l=0.6u
X7461 user_project_wrapper_0.IOVSS1 a_208855_324776# a_211321_324119# w_207989_323975# sg13_lv_pmos ad=0.68p pd=4.68u as=0.68p ps=4.68u w=2u l=0.65u
X7462 user_project_wrapper_0.IOVDD4 a_115444_355624# user_project_wrapper_0.analog_io[27] user_project_wrapper_0.IOVDD4 sg13_hv_pmos ad=2.1312p pd=7.3u as=3.9294p ps=7.84u w=6.66u l=0.6u
X7463 a_208103_324155# a_208171_324119# user_project_wrapper_0.IOVSS1 user_project_wrapper_0.IOVSS1 sg13_lv_nmos ad=0.19p pd=1.38u as=0.19p ps=1.38u w=1u l=0.13u
X7464 user_project_wrapper_0.IOVSS1 user_project_wrapper_0.sg13g2_IOPadIOVdd_1.sg13g2_Clamp_N43N43D4R_0.gate user_project_wrapper_0.IOVDD1 user_project_wrapper_0.IOVSS1 sg13_hv_nmos ad=1.408p pd=5.04u as=2.596p ps=5.58u w=4.4u l=0.6u
X7465 user_project_wrapper_0.IOVSS1 a_369296_135844# analog_io[19] user_project_wrapper_0.IOVSS1 sg13_hv_nmos ad=2.068p pd=9.74u as=2.596p ps=5.58u w=4.4u l=0.6u
X7466 user_project_wrapper_0.IOVDD1 a_41476_135844# user_project_wrapper_0.analog_io[1] user_project_wrapper_0.IOVDD1 sg13_hv_pmos ad=2.1312p pd=7.3u as=3.9294p ps=7.84u w=6.66u l=0.6u
X7467 user_project_wrapper_0.analog_io[34] a_258244_369296# user_project_wrapper_0.IOVSS1 user_project_wrapper_0.IOVSS1 sg13_hv_nmos ad=2.596p pd=5.58u as=1.408p ps=5.04u w=4.4u l=0.6u
X7468 user_project_wrapper_0.IOVSS1 a_213870_324142# user_project_wrapper_0.analog_io[35] user_project_wrapper_0.IOVSS1 sg13_lv_nmos ad=1.632p pd=10.28u as=0.912p ps=5.18u w=4.8u l=0.13u
X7469 user_project_wrapper_0.IOVSS1 user_project_wrapper_0.sg13g2_IOPadVdd_3.sg13g2_RCClampInverter_noptap_0.out user_project_wrapper_0.IOVSS1 user_project_wrapper_0.IOVSS1 sg13_hv_nmos ad=1.408p pd=5.04u as=0 ps=0 w=4.4u l=0.6u
X7470 user_project_wrapper_0.IOVSS1 a_301186_192011# a_296731_208493# user_project_wrapper_0.IOVSS1 sg13_lv_nmos ad=0.912p pd=5.18u as=0.912p ps=5.18u w=4.8u l=1.06u
X7471 user_project_wrapper_0.IOVSS1 user_project_wrapper_0.sg13g2_IOPadVdd_1.sg13g2_RCClampInverter_noptap_0.out user_project_wrapper_0.VDD2 user_project_wrapper_0.IOVSS1 sg13_hv_nmos ad=1.408p pd=5.04u as=2.596p ps=5.58u w=4.4u l=0.6u
X7472 user_project_wrapper_0.IOVSS1 a_217444_29676# user_project_wrapper_0.analog_io[14] user_project_wrapper_0.IOVSS1 sg13_hv_nmos ad=1.408p pd=5.04u as=2.596p ps=5.58u w=4.4u l=0.6u
X7473 a_296625_189595# a_304090_197941# a_304196_197873# user_project_wrapper_0.IOVSS1 sg13_lv_nmos ad=0.361p pd=2.28u as=0.361p ps=2.28u w=1.9u l=0.16u
X7474 user_project_wrapper_0.analog_io[12] a_176644_41476# user_project_wrapper_0.IOVDD2 user_project_wrapper_0.IOVDD2 sg13_hv_pmos ad=3.9294p pd=7.84u as=2.1312p ps=7.3u w=6.66u l=0.6u
X7475 user_project_wrapper_0.IOVSS1 analog_io[20] dantenna l=27.78u w=1.26u
X7476 user_project_wrapper_0.analog_io[6] a_41476_237844# user_project_wrapper_0.IOVDD1 user_project_wrapper_0.IOVDD1 sg13_hv_pmos ad=3.9294p pd=7.84u as=2.1312p ps=7.3u w=6.66u l=0.6u
X7477 VDD3 a_314697_196700# a_314793_201808# VDD3 sg13_lv_pmos ad=2.04p pd=12.68u as=1.14p ps=6.38u w=6u l=2.5u
X7478 VDD3 user_project_wrapper_0.sg13g2_IOPadVdd_0.sg13g2_RCClampResistor_0.p2 user_project_wrapper_0.sg13g2_IOPadVdd_0.sg13g2_RCClampInverter_noptap_0.out VDD3 sg13_hv_pmos ad=1.33p pd=7.38u as=1.33p ps=7.38u w=7u l=0.5u
X7479 VDD3 a_296626_197740# a_296732_200582# VDD3 sg13_lv_pmos ad=1.33p pd=7.38u as=1.33p ps=7.38u w=7u l=0.7u
X7480 IOVDD3 user_project_wrapper_0.sg13g2_IOPadIOVdd_3.sg13g2_RCClampResistor_0.p2 user_project_wrapper_0.sg13g2_IOPadIOVdd_3.sg13g2_Clamp_N43N43D4R_0.gate IOVDD3 sg13_hv_pmos ad=1.33p pd=7.38u as=1.33p ps=7.38u w=7u l=0.5u
X7481 a_309917_199879# a_309516_194555# VDD3 VDD3 sg13_lv_pmos ad=0.19p pd=1.38u as=0.19p ps=1.38u w=1u l=0.7u
X7482 a_311189_211724# a_296731_208493# a_313884_211353# user_project_wrapper_0.IOVSS1 sg13_lv_nmos ad=1.9p pd=10.38u as=3.4p ps=20.68u w=10u l=0.5u
X7483 user_project_wrapper_0.sg13g2_IOPadVdd_1.sg13g2_RCClampInverter_noptap_0.out user_project_wrapper_0.sg13g2_IOPadVdd_1.sg13g2_RCClampResistor_0.p2 user_project_wrapper_0.IOVSS1 user_project_wrapper_0.IOVSS1 sg13_hv_nmos ad=1.71p pd=9.38u as=1.71p ps=9.38u w=9u l=0.5u
X7484 a_296731_208493# a_296625_208423# VDD3 VDD3 sg13_lv_pmos ad=0.2603p pd=1.75u as=0.4658p ps=3.42u w=1.37u l=0.35u
X7485 a_304196_197873# a_304889_198885# a_304995_198817# user_project_wrapper_0.IOVSS1 sg13_lv_nmos ad=0.209p pd=1.48u as=0.374p ps=2.88u w=1.1u l=0.15u
X7486 user_project_wrapper_0.analog_io[30] a_194687_324142# user_project_wrapper_0.IOVSS1 user_project_wrapper_0.IOVSS1 sg13_lv_nmos ad=0.912p pd=5.18u as=0.912p ps=5.18u w=4.8u l=0.13u
X7487 VDD3 a_309516_194555# a_309917_194695# VDD3 sg13_lv_pmos ad=0.19p pd=1.38u as=0.19p ps=1.38u w=1u l=0.7u
X7488 user_project_wrapper_0.IOVSS1 user_project_wrapper_0.sg13g2_IOPadIOVdd_3.sg13g2_Clamp_N43N43D4R_0.gate IOVDD3 user_project_wrapper_0.IOVSS1 sg13_hv_nmos ad=1.408p pd=5.04u as=2.596p ps=5.58u w=4.4u l=0.6u
X7489 a_296731_208493# a_296625_208423# VDD3 VDD3 sg13_lv_pmos ad=0.2603p pd=1.75u as=0.2603p ps=1.75u w=1.37u l=0.35u
X7490 user_project_wrapper_0.uo_PAD[3] user_project_wrapper_0.sg13g2_IOPadOut4mA$1_0.sg13g2_GateLevelUpInv_noptap$1$1_0.ngate user_project_wrapper_0.IOVSS1 user_project_wrapper_0.IOVSS1 sg13_hv_nmos ad=2.596p pd=5.58u as=2.068p ps=9.74u w=4.4u l=0.6u
X7491 user_project_wrapper_0.VDD2 user_project_wrapper_0.sg13g2_IOPadVdd_1.sg13g2_RCClampResistor_0.p2 user_project_wrapper_0.sg13g2_IOPadVdd_1.sg13g2_RCClampInverter_noptap_0.out user_project_wrapper_0.VDD2 sg13_hv_pmos ad=1.33p pd=7.38u as=1.33p ps=7.38u w=7u l=0.5u
X7492 a_87434_127896# a_86594_127896# user_project_wrapper_0.VDD1 user_project_wrapper_0.VDD1 sg13_lv_pmos ad=0.2128p pd=1.5u as=0.3808p ps=2.92u w=1.12u l=0.13u
X7493 user_project_wrapper_0.IOVDD1 a_41476_237844# user_project_wrapper_0.analog_io[6] user_project_wrapper_0.IOVDD1 sg13_hv_pmos ad=2.1312p pd=7.3u as=3.9294p ps=7.84u w=6.66u l=0.6u
X7494 user_project_wrapper_0.IOVSS1 user_project_wrapper_0.sg13g2_IOPadIOVdd_1.sg13g2_Clamp_N43N43D4R_0.gate user_project_wrapper_0.IOVDD1 user_project_wrapper_0.IOVSS1 sg13_hv_nmos ad=1.408p pd=5.04u as=2.596p ps=5.58u w=4.4u l=0.6u
X7495 user_project_wrapper_0.IOVDD1 a_41476_258244# user_project_wrapper_0.analog_io[7] user_project_wrapper_0.IOVDD1 sg13_hv_pmos ad=2.1312p pd=7.3u as=3.9294p ps=7.84u w=6.66u l=0.6u
X7496 user_project_wrapper_0.IOVSS1 user_project_wrapper_0.sg13g2_IOPadVdd_3.sg13g2_RCClampInverter_noptap_0.out user_project_wrapper_0.IOVSS1 user_project_wrapper_0.IOVSS1 sg13_hv_nmos ad=2.596p pd=5.58u as=0 ps=0 w=4.4u l=0.6u
X7497 IOVDD3 a_355624_237844# analog_io[23] IOVDD3 sg13_hv_pmos ad=3.1302p pd=14.26u as=3.9294p ps=7.84u w=6.66u l=0.6u
X7498 user_project_wrapper_0.IOVSS1 user_project_wrapper_0.sg13g2_IOPadIOVdd_3.sg13g2_Clamp_N43N43D4R_0.gate IOVDD3 user_project_wrapper_0.IOVSS1 sg13_hv_nmos ad=1.408p pd=5.04u as=2.596p ps=5.58u w=4.4u l=0.6u
X7499 user_project_wrapper_0.IOVSS1 user_project_wrapper_0.sg13g2_IOPadVdd_3.sg13g2_RCClampInverter_noptap_0.out user_project_wrapper_0.IOVSS1 user_project_wrapper_0.IOVSS1 sg13_hv_nmos ad=2.596p pd=5.58u as=0 ps=0 w=4.4u l=0.6u
X7500 VDD3 a_296625_208423# a_296731_208493# VDD3 sg13_lv_pmos ad=0.4658p pd=3.42u as=0.2603p ps=1.75u w=1.37u l=0.35u
X7501 user_project_wrapper_0.sg13g2_IOPadIOVdd_0.sg13g2_Clamp_N43N43D4R_0.gate user_project_wrapper_0.sg13g2_IOPadIOVdd_0.sg13g2_RCClampResistor_0.p2 user_project_wrapper_0.IOVDD2 user_project_wrapper_0.IOVDD2 sg13_hv_pmos ad=1.33p pd=7.38u as=1.33p ps=7.38u w=7u l=0.5u
X7502 user_project_wrapper_0.IOVSS1 a_188988_324119# a_188920_324155# w_188806_323975# sg13_lv_pmos ad=0.38p pd=2.38u as=0.68p ps=4.68u w=2u l=0.13u
X7503 user_project_wrapper_0.sg13g2_IOPadIOVdd_2.sg13g2_Clamp_N43N43D4R_0.gate user_project_wrapper_0.sg13g2_IOPadIOVdd_2.sg13g2_RCClampResistor_0.p2 user_project_wrapper_0.IOVDD4 user_project_wrapper_0.IOVDD4 sg13_hv_pmos ad=1.33p pd=7.38u as=1.33p ps=7.38u w=7u l=0.5u
X7504 user_project_wrapper_0.sg13g2_IOPadVdd_0.sg13g2_RCClampInverter_noptap_0.out user_project_wrapper_0.sg13g2_IOPadVdd_0.sg13g2_RCClampResistor_0.p2 user_project_wrapper_0.IOVSS1 user_project_wrapper_0.IOVSS1 sg13_hv_nmos ad=1.71p pd=9.38u as=1.71p ps=9.38u w=9u l=0.5u
X7505 VDD3 a_296626_197740# a_296732_197880# VDD3 sg13_lv_pmos ad=1.33p pd=7.38u as=1.33p ps=7.38u w=7u l=0.7u
X7506 VDD3 a_309516_194555# a_309917_199879# VDD3 sg13_lv_pmos ad=0.19p pd=1.38u as=0.19p ps=1.38u w=1u l=0.7u
X7507 user_project_wrapper_0.analog_io[30] a_176644_369296# user_project_wrapper_0.IOVSS1 user_project_wrapper_0.IOVSS1 sg13_hv_nmos ad=2.596p pd=5.58u as=2.068p ps=9.74u w=4.4u l=0.6u
X7508 user_project_wrapper_0.IOVSS1 user_project_wrapper_0.sg13g2_IOPadVdd_2.sg13g2_RCClampResistor_0.p2 user_project_wrapper_0.sg13g2_IOPadVdd_2.sg13g2_RCClampInverter_noptap_0.out user_project_wrapper_0.IOVSS1 sg13_hv_nmos ad=1.71p pd=9.38u as=1.71p ps=9.38u w=9u l=0.5u
X7509 user_project_wrapper_0.analog_io[16] a_258244_41476# user_project_wrapper_0.IOVDD2 user_project_wrapper_0.IOVDD2 sg13_hv_pmos ad=3.9294p pd=7.84u as=2.1312p ps=7.3u w=6.66u l=0.6u
X7510 user_project_wrapper_0.analog_io[35] a_213870_324142# user_project_wrapper_0.IOVSS1 user_project_wrapper_0.IOVSS1 sg13_lv_nmos ad=0.912p pd=5.18u as=0.912p ps=5.18u w=4.8u l=0.13u
X7511 user_project_wrapper_0.IOVSS1 a_182931_326125# user_project_wrapper_0.analog_io[27] user_project_wrapper_0.IOVSS1 sg13_lv_nmos ad=0.912p pd=5.18u as=0.912p ps=5.18u w=4.8u l=0.13u
X7512 a_189756_327491# a_188920_324155# user_project_wrapper_0.IOVSS1 user_project_wrapper_0.IOVSS1 sg13_lv_nmos ad=0.19p pd=1.38u as=0.34p ps=2.68u w=1u l=0.13u
X7513 analog_io[25] a_355624_258244# IOVDD3 IOVDD3 sg13_hv_pmos ad=3.9294p pd=7.84u as=3.1302p ps=14.26u w=6.66u l=0.6u
X7514 user_project_wrapper_0.analog_io[28] a_135844_355624# user_project_wrapper_0.IOVDD4 user_project_wrapper_0.IOVDD4 sg13_hv_pmos ad=3.9294p pd=7.84u as=2.1312p ps=7.3u w=6.66u l=0.6u
X7515 user_project_wrapper_0.analog_io[30] a_194687_324142# user_project_wrapper_0.IOVSS1 user_project_wrapper_0.IOVSS1 sg13_lv_nmos ad=0.912p pd=5.18u as=0.912p ps=5.18u w=4.8u l=0.13u
X7516 user_project_wrapper_0.VDD1 user_project_wrapper_0.sg13g2_IOPadVdd_2.sg13g2_RCClampInverter_noptap_0.out user_project_wrapper_0.IOVSS1 user_project_wrapper_0.IOVSS1 sg13_hv_nmos ad=2.596p pd=5.58u as=1.408p ps=5.04u w=4.4u l=0.6u
X7517 user_project_wrapper_0.IOVDD1 a_41476_237844# user_project_wrapper_0.IOVDD1 rppd l=12.9u w=0.5u
X7518 user_project_wrapper_0.analog_io[13] a_197044_29676# user_project_wrapper_0.IOVSS1 user_project_wrapper_0.IOVSS1 sg13_hv_nmos ad=2.596p pd=5.58u as=1.408p ps=5.04u w=4.4u l=0.6u
X7519 analog_io[19] IOVDD3 dpantenna l=27.78u w=1.26u
X7520 user_project_wrapper_0.IOVSS1 user_project_wrapper_0.analog_io[15] a_190319_102855# user_project_wrapper_0.IOVSS1 sg13_lv_nmos ad=0.15245p pd=1.17u as=0.17462p ps=1.185u w=0.55u l=0.13u
X7521 analog_io[18] a_355624_115444# IOVDD3 IOVDD3 sg13_hv_pmos ad=3.9294p pd=7.84u as=2.1312p ps=7.3u w=6.66u l=0.6u
X7522 user_project_wrapper_0.IOVSS1 a_314793_197200# a_313884_185173# user_project_wrapper_0.IOVSS1 sg13_lv_nmos ad=0.57p pd=3.38u as=1.02p ps=6.68u w=3u l=1u
X7523 user_project_wrapper_0.IOVSS1 user_project_wrapper_0.sg13g2_IOPadVdd_3.sg13g2_RCClampInverter_noptap_0.out user_project_wrapper_0.IOVSS1 user_project_wrapper_0.IOVSS1 sg13_hv_nmos ad=1.408p pd=5.04u as=0 ps=0 w=4.4u l=0.6u
X7524 user_project_wrapper_0.IOVSS1 a_307232_196607# a_304995_198817# user_project_wrapper_0.IOVSS1 sg13_lv_nmos ad=0.6327p pd=3.71u as=0.6327p ps=3.71u w=3.33u l=0.2u
X7525 user_project_wrapper_0.IOVSS1 user_project_wrapper_0.sg13g2_IOPadVdd_3.sg13g2_RCClampInverter_noptap_0.out user_project_wrapper_0.IOVSS1 user_project_wrapper_0.IOVSS1 sg13_hv_nmos ad=1.408p pd=5.04u as=0 ps=0 w=4.4u l=0.6u
X7526 user_project_wrapper_0.sg13g2_IOPadVdd_1.sg13g2_RCClampInverter_noptap_0.out user_project_wrapper_0.sg13g2_IOPadVdd_1.sg13g2_RCClampResistor_0.p2 user_project_wrapper_0.VDD2 user_project_wrapper_0.VDD2 sg13_hv_pmos ad=1.33p pd=7.38u as=1.33p ps=7.38u w=7u l=0.5u
X7527 user_project_wrapper_0.IOVSS1 a_79038_130026# a_79038_130026# user_project_wrapper_0.IOVSS1 sg13_lv_nmos ad=0.1428p pd=1.52u as=0.1428p ps=1.52u w=0.42u l=0.56u
X7528 a_309917_194695# a_309516_194555# VDD3 VDD3 sg13_lv_pmos ad=0.19p pd=1.38u as=0.19p ps=1.38u w=1u l=0.7u
X7529 user_project_wrapper_0.IOVSS1 a_369296_258244# analog_io[25] user_project_wrapper_0.IOVSS1 sg13_hv_nmos ad=1.408p pd=5.04u as=2.596p ps=5.58u w=4.4u l=0.6u
X7530 user_project_wrapper_0.IOVDD1 user_project_wrapper_0.sg13g2_IOPadIOVdd_1.sg13g2_Clamp_N43N43D4R_0.gate user_project_wrapper_0.IOVSS1 user_project_wrapper_0.IOVSS1 sg13_hv_nmos ad=2.596p pd=5.58u as=1.408p ps=5.04u w=4.4u l=0.6u
X7531 user_project_wrapper_0.analog_io[14] user_project_wrapper_0.IOVDD2 dpantenna l=1.26u w=27.78u
X7532 IOVDD3 a_355624_176644# analog_io[20] IOVDD3 sg13_hv_pmos ad=2.1312p pd=7.3u as=3.9294p ps=7.84u w=6.66u l=0.6u
X7533 IOVDD3 user_project_wrapper_0.sg13g2_IOPadIOVdd_3.sg13g2_RCClampResistor_0.p2 user_project_wrapper_0.sg13g2_IOPadIOVdd_3.sg13g2_Clamp_N43N43D4R_0.gate IOVDD3 sg13_hv_pmos ad=1.33p pd=7.38u as=1.33p ps=7.38u w=7u l=0.5u
X7534 user_project_wrapper_0.IOVSS1 a_213462_327536# a_213870_324142# user_project_wrapper_0.IOVSS1 sg13_lv_nmos ad=0.912p pd=5.18u as=0.912p ps=5.18u w=4.8u l=0.13u
X7535 user_project_wrapper_0.IOVDD2 a_237844_41476# user_project_wrapper_0.analog_io[15] user_project_wrapper_0.IOVDD2 sg13_hv_pmos ad=2.1312p pd=7.3u as=3.9294p ps=7.84u w=6.66u l=0.6u
X7536 a_85155_125209# a_85052_125418# user_project_wrapper_0.VDD1 user_project_wrapper_0.VDD1 sg13_lv_pmos ad=0.2128p pd=1.5u as=0.3808p ps=2.92u w=1.12u l=0.13u
X7537 user_project_wrapper_0.IOVSS1 user_project_wrapper_0.sg13g2_IOPadVdd_3.sg13g2_RCClampInverter_noptap_0.out user_project_wrapper_0.IOVSS1 user_project_wrapper_0.IOVSS1 sg13_hv_nmos ad=2.596p pd=5.58u as=0 ps=0 w=4.4u l=0.6u
X7538 a_296625_189595# a_304090_197941# a_304196_197873# user_project_wrapper_0.IOVSS1 sg13_lv_nmos ad=0.361p pd=2.28u as=0.361p ps=2.28u w=1.9u l=0.16u
X7539 user_project_wrapper_0.IOVSS1 user_project_wrapper_0.sg13g2_IOPadVdd_2.sg13g2_RCClampInverter_noptap_0.out user_project_wrapper_0.VDD1 user_project_wrapper_0.IOVSS1 sg13_hv_nmos ad=1.408p pd=5.04u as=2.596p ps=5.58u w=4.4u l=0.6u
X7540 user_project_wrapper_0.VDD2 user_project_wrapper_0.sg13g2_IOPadVdd_1.sg13g2_RCClampInverter_noptap_0.out user_project_wrapper_0.IOVSS1 user_project_wrapper_0.IOVSS1 sg13_hv_nmos ad=2.596p pd=5.58u as=1.408p ps=5.04u w=4.4u l=0.6u
X7541 user_project_wrapper_0.analog_io[30] a_194687_324142# user_project_wrapper_0.IOVSS1 user_project_wrapper_0.IOVSS1 sg13_lv_pmos ad=1.824p pd=9.98u as=1.824p ps=9.98u w=9.6u l=0.13u
X7542 VDD3 a_296625_208423# a_296731_208493# VDD3 sg13_lv_pmos ad=0.2603p pd=1.75u as=0.2603p ps=1.75u w=1.37u l=0.35u
X7543 user_project_wrapper_0.analog_io[35] a_278644_355624# user_project_wrapper_0.IOVDD4 user_project_wrapper_0.IOVDD4 sg13_hv_pmos ad=3.9294p pd=7.84u as=3.1302p ps=14.26u w=6.66u l=0.6u
X7544 analog_io[22] a_355624_197044# IOVDD3 IOVDD3 sg13_hv_pmos ad=3.9294p pd=7.84u as=2.1312p ps=7.3u w=6.66u l=0.6u
X7545 IOVDD3 a_355624_135844# analog_io[19] IOVDD3 sg13_hv_pmos ad=2.1312p pd=7.3u as=3.9294p ps=7.84u w=6.66u l=0.6u
X7546 VDD3 a_296625_189595# a_296731_189665# VDD3 sg13_lv_pmos ad=0.2603p pd=1.75u as=0.2603p ps=1.75u w=1.37u l=0.35u
X7547 VDD3 a_309516_194555# a_309917_199879# VDD3 sg13_lv_pmos ad=0.19p pd=1.38u as=0.19p ps=1.38u w=1u l=0.7u
X7548 user_project_wrapper_0.analog_io[35] a_213870_324142# user_project_wrapper_0.IOVSS1 user_project_wrapper_0.IOVSS1 sg13_lv_nmos ad=0.912p pd=5.18u as=0.912p ps=5.18u w=4.8u l=0.13u
X7549 user_project_wrapper_0.analog_io[11] a_156244_29676# user_project_wrapper_0.IOVSS1 user_project_wrapper_0.IOVSS1 sg13_hv_nmos ad=2.596p pd=5.58u as=1.408p ps=5.04u w=4.4u l=0.6u
X7550 user_project_wrapper_0.analog_io[4] a_29676_197044# user_project_wrapper_0.IOVSS1 user_project_wrapper_0.IOVSS1 sg13_hv_nmos ad=2.596p pd=5.58u as=1.408p ps=5.04u w=4.4u l=0.6u
X7551 user_project_wrapper_0.IOVDD4 a_135844_355624# user_project_wrapper_0.analog_io[28] user_project_wrapper_0.IOVDD4 sg13_hv_pmos ad=2.1312p pd=7.3u as=3.9294p ps=7.84u w=6.66u l=0.6u
X7552 VDD3 user_project_wrapper_0.sg13g2_IOPadVdd_0.sg13g2_RCClampInverter_noptap_0.out user_project_wrapper_0.IOVSS1 user_project_wrapper_0.IOVSS1 sg13_hv_nmos ad=3.256p pd=10.28u as=1.408p ps=5.04u w=4.4u l=0.6u
X7553 user_project_wrapper_0.IOVDD2 a_135844_41476# user_project_wrapper_0.analog_io[10] user_project_wrapper_0.IOVDD2 sg13_hv_pmos ad=2.1312p pd=7.3u as=3.9294p ps=7.84u w=6.66u l=0.6u
X7554 VDD3 a_301940_196388# a_304090_197941# VDD3 sg13_lv_pmos ad=0.3895p pd=2.43u as=0.697p ps=4.78u w=2.05u l=0.35u
X7555 user_project_wrapper_0.VDD2 user_project_wrapper_0.sg13g2_IOPadVdd_1.sg13g2_RCClampResistor_0.p2 user_project_wrapper_0.sg13g2_IOPadVdd_1.sg13g2_RCClampInverter_noptap_0.out user_project_wrapper_0.VDD2 sg13_hv_pmos ad=1.33p pd=7.38u as=1.33p ps=7.38u w=7u l=0.5u
X7556 VDD3 a_296625_208423# a_296731_208493# VDD3 sg13_lv_pmos ad=0.2603p pd=1.75u as=0.2603p ps=1.75u w=1.37u l=0.35u
X7557 user_project_wrapper_0.analog_io[30] a_194687_324142# user_project_wrapper_0.IOVSS1 user_project_wrapper_0.IOVSS1 sg13_lv_pmos ad=1.824p pd=9.98u as=1.824p ps=9.98u w=9.6u l=0.13u
X7558 user_project_wrapper_0.IOVDD4 a_258244_355624# user_project_wrapper_0.analog_io[34] user_project_wrapper_0.IOVDD4 sg13_hv_pmos ad=2.1312p pd=7.3u as=3.9294p ps=7.84u w=6.66u l=0.6u
X7559 user_project_wrapper_0.IOVSS1 user_project_wrapper_0.sg13g2_IOPadVdd_2.sg13g2_RCClampResistor_0.p2 user_project_wrapper_0.IOVSS1 user_project_wrapper_0.IOVSS1 sg13_hv_nmos ad=1.71p pd=9.38u as=0 ps=0 w=9u l=9.5u
X7560 a_296625_208423# a_301940_196388# a_296732_200582# VDD3 sg13_lv_pmos ad=0.7695p pd=4.43u as=0.7695p ps=4.43u w=4.05u l=0.5u
X7561 VDD3 a_296625_208423# a_296731_208493# VDD3 sg13_lv_pmos ad=0.2603p pd=1.75u as=0.2603p ps=1.75u w=1.37u l=0.35u
X7562 IOVDD3 a_355624_258244# analog_io[25] IOVDD3 sg13_hv_pmos ad=2.1312p pd=7.3u as=3.9294p ps=7.84u w=6.66u l=0.6u
X7563 VDD3 a_311108_179669# analog_io[20] user_project_wrapper_0.IOVSS1 sg13_lv_nmos ad=3.4p pd=20.68u as=3.4p ps=20.68u w=10u l=0.15u
X7564 VDD3 a_311108_215937# analog_io[23] user_project_wrapper_0.IOVSS1 sg13_lv_nmos ad=3.4p pd=20.68u as=3.4p ps=20.68u w=10u l=0.15u
X7565 user_project_wrapper_0.IOVSS1 a_188834_326341# a_189858_326377# w_188704_326203# sg13_lv_pmos ad=0.68p pd=4.68u as=0.38p ps=2.38u w=2u l=0.13u
X7566 user_project_wrapper_0.IOVSS1 a_311846_195517# a_311846_195517# user_project_wrapper_0.IOVSS1 sg13_lv_nmos ad=0.6327p pd=3.71u as=0.6327p ps=3.71u w=3.33u l=0.2u
X7567 user_project_wrapper_0.sg13g2_IOPadIOVdd_0.sg13g2_Clamp_N43N43D4R_0.gate user_project_wrapper_0.sg13g2_IOPadIOVdd_0.sg13g2_RCClampResistor_0.p2 user_project_wrapper_0.IOVDD2 user_project_wrapper_0.IOVDD2 sg13_hv_pmos ad=1.33p pd=7.38u as=1.33p ps=7.38u w=7u l=0.5u
X7568 user_project_wrapper_0.IOVSS1 user_project_wrapper_0.sg13g2_IOPadIOVdd_1.sg13g2_Clamp_N43N43D4R_0.gate user_project_wrapper_0.IOVDD1 user_project_wrapper_0.IOVSS1 sg13_hv_nmos ad=1.408p pd=5.04u as=2.596p ps=5.58u w=4.4u l=0.6u
X7569 analog_io[20] a_355624_176644# IOVDD3 IOVDD3 sg13_hv_pmos ad=3.9294p pd=7.84u as=2.1312p ps=7.3u w=6.66u l=0.6u
X7570 user_project_wrapper_0.IOVSS1 user_project_wrapper_0.sg13g2_IOPadVdd_0.sg13g2_RCClampInverter_noptap_0.out VDD3 user_project_wrapper_0.IOVSS1 sg13_hv_nmos ad=1.408p pd=5.04u as=2.596p ps=5.58u w=4.4u l=0.6u
X7571 user_project_wrapper_0.IOVDD1 a_41476_115444# user_project_wrapper_0.analog_io[0] user_project_wrapper_0.IOVDD1 sg13_hv_pmos ad=2.1312p pd=7.3u as=3.9294p ps=7.84u w=6.66u l=0.6u
X7572 user_project_wrapper_0.IOVSS1 a_258244_369296# user_project_wrapper_0.analog_io[34] user_project_wrapper_0.IOVSS1 sg13_hv_nmos ad=1.408p pd=5.04u as=2.596p ps=5.58u w=4.4u l=0.6u
X7573 VDD3 a_296625_208423# a_296731_208493# VDD3 sg13_lv_pmos ad=0.2603p pd=1.75u as=0.2603p ps=1.75u w=1.37u l=0.35u
X7574 user_project_wrapper_0.IOVSS1 user_project_wrapper_0.sg13g2_IOPadVdd_3.sg13g2_RCClampInverter_noptap_0.out user_project_wrapper_0.IOVSS1 user_project_wrapper_0.IOVSS1 sg13_hv_nmos ad=2.596p pd=5.58u as=0 ps=0 w=4.4u l=0.6u
X7575 user_project_wrapper_0.analog_io[35] a_213870_324142# user_project_wrapper_0.IOVSS1 user_project_wrapper_0.IOVSS1 sg13_lv_pmos ad=1.824p pd=9.98u as=1.824p ps=9.98u w=9.6u l=0.13u
X7576 VDD3 a_309516_194555# a_309516_194555# VDD3 sg13_lv_pmos ad=0.19p pd=1.38u as=0.19p ps=1.38u w=1u l=0.7u
X7577 user_project_wrapper_0.IOVSS1 user_project_wrapper_0.IOVSS1 user_project_wrapper_0.IOVSS1 rppd l=0.5u w=0.5u
X7578 user_project_wrapper_0.IOVDD4 a_176644_355624# user_project_wrapper_0.analog_io[30] user_project_wrapper_0.IOVDD4 sg13_hv_pmos ad=2.1312p pd=7.3u as=3.9294p ps=7.84u w=6.66u l=0.6u
X7579 a_79025_135674# user_project_wrapper_0.sg13g2_IOPadAnalog_9.padres a_79038_134832# user_project_wrapper_0.VDD1 sg13_lv_pmos ad=1.7p pd=10.68u as=0.95p ps=5.38u w=5u l=0.3u
X7580 VDD3 a_296625_208423# a_296731_208493# VDD3 sg13_lv_pmos ad=0.2603p pd=1.75u as=0.2603p ps=1.75u w=1.37u l=0.35u
X7581 QDLL_TOP_0.VOUT a_278644_41476# user_project_wrapper_0.IOVDD2 user_project_wrapper_0.IOVDD2 sg13_hv_pmos ad=3.9294p pd=7.84u as=2.1312p ps=7.3u w=6.66u l=0.6u
X7582 a_296731_189665# a_296625_189595# VDD3 VDD3 sg13_lv_pmos ad=0.2603p pd=1.75u as=0.2603p ps=1.75u w=1.37u l=0.35u
X7583 user_project_wrapper_0.IOVSS1 a_271172_100118# QDLL_TOP_0.VOUT user_project_wrapper_0.IOVSS1 sg13_lv_nmos ad=0.1406p pd=1.12u as=0.1406p ps=1.12u w=0.74u l=0.13u
X7584 user_project_wrapper_0.IOVSS1 user_project_wrapper_0.sg13g2_IOPadVdd_3.sg13g2_RCClampResistor_0.p2 user_project_wrapper_0.sg13g2_IOPadVdd_3.sg13g2_RCClampInverter_noptap_0.out user_project_wrapper_0.IOVSS1 sg13_hv_pmos ad=1.33p pd=7.38u as=1.33p ps=7.38u w=7u l=0.5u
X7585 a_189184_327491# a_188920_324155# user_project_wrapper_0.IOVSS1 user_project_wrapper_0.IOVSS1 sg13_lv_nmos ad=0.19p pd=1.38u as=0.34p ps=2.68u w=1u l=0.13u
X7586 user_project_wrapper_0.IOVSS1 user_project_wrapper_0.analog_io[5] dantenna l=27.78u w=1.26u
X7587 user_project_wrapper_0.analog_io[35] a_213870_324142# user_project_wrapper_0.IOVSS1 user_project_wrapper_0.IOVSS1 sg13_lv_pmos ad=1.824p pd=9.98u as=1.824p ps=9.98u w=9.6u l=0.13u
X7588 user_project_wrapper_0.analog_io[30] a_194687_324142# user_project_wrapper_0.IOVSS1 user_project_wrapper_0.IOVSS1 sg13_lv_pmos ad=1.824p pd=9.98u as=1.824p ps=9.98u w=9.6u l=0.13u
X7589 user_project_wrapper_0.IOVDD1 user_project_wrapper_0.sg13g2_IOPadIOVdd_1.sg13g2_Clamp_N43N43D4R_0.gate user_project_wrapper_0.IOVSS1 user_project_wrapper_0.IOVSS1 sg13_hv_nmos ad=2.596p pd=5.58u as=1.408p ps=5.04u w=4.4u l=0.6u
X7590 a_311108_215937# analog_io[23] a_313884_211353# user_project_wrapper_0.IOVSS1 sg13_lv_nmos ad=1.9p pd=10.38u as=1.9p ps=10.38u w=10u l=0.5u
X7591 user_project_wrapper_0.IOVSS1 user_project_wrapper_0.IOVSS1 user_project_wrapper_0.IOVSS1 rppd l=0.5u w=0.5u
X7592 user_project_wrapper_0.VDD1 user_project_wrapper_0.sg13g2_IOPadVdd_2.sg13g2_RCClampInverter_noptap_0.out user_project_wrapper_0.IOVSS1 user_project_wrapper_0.IOVSS1 sg13_hv_nmos ad=2.596p pd=5.58u as=1.408p ps=5.04u w=4.4u l=0.6u
X7593 user_project_wrapper_0.VDD1 user_project_wrapper_0.sg13g2_IOPadVdd_2.sg13g2_RCClampResistor_0.p2 user_project_wrapper_0.sg13g2_IOPadVdd_2.sg13g2_RCClampInverter_noptap_0.out user_project_wrapper_0.VDD1 sg13_hv_pmos ad=1.33p pd=7.38u as=1.33p ps=7.38u w=7u l=0.5u
X7594 user_project_wrapper_0.IOVSS1 a_369296_197044# analog_io[22] user_project_wrapper_0.IOVSS1 sg13_hv_nmos ad=1.408p pd=5.04u as=2.596p ps=5.58u w=4.4u l=0.6u
X7595 user_project_wrapper_0.IOVDD1 a_41476_197044# user_project_wrapper_0.analog_io[4] user_project_wrapper_0.IOVDD1 sg13_hv_pmos ad=2.1312p pd=7.3u as=3.9294p ps=7.84u w=6.66u l=0.6u
X7596 a_73375_364458# user_project_wrapper_0.IOVSS1 user_project_wrapper_0.IOVSS1 rppd l=20u w=1u
X7597 a_209684_328605# a_208367_328605# user_project_wrapper_0.IOVSS1 user_project_wrapper_0.IOVSS1 sg13_lv_nmos ad=0.34p pd=2.68u as=0.34p ps=2.68u w=1u l=0.13u
X7598 user_project_wrapper_0.IOVSS1 a_202114_326125# user_project_wrapper_0.analog_io[32] user_project_wrapper_0.IOVSS1 sg13_lv_pmos ad=1.824p pd=9.98u as=1.824p ps=9.98u w=9.6u l=0.13u
X7599 user_project_wrapper_0.IOVSS1 user_project_wrapper_0.IOVSS1 dantenna l=1.26u w=27.78u
X7600 a_296732_200582# a_296626_197740# VDD3 VDD3 sg13_lv_pmos ad=1.33p pd=7.38u as=2.38p ps=14.68u w=7u l=0.7u
X7601 a_194687_324142# a_194279_327536# user_project_wrapper_0.IOVSS1 user_project_wrapper_0.IOVSS1 sg13_lv_nmos ad=0.912p pd=5.18u as=0.912p ps=5.18u w=4.8u l=0.13u
X7602 user_project_wrapper_0.VDD2 user_project_wrapper_0.sg13g2_IOPadVdd_1.sg13g2_RCClampInverter_noptap_0.out user_project_wrapper_0.IOVSS1 user_project_wrapper_0.IOVSS1 sg13_hv_nmos ad=2.596p pd=5.58u as=1.408p ps=5.04u w=4.4u l=0.6u
X7603 VDD3 a_309516_194555# a_309917_199879# VDD3 sg13_lv_pmos ad=0.19p pd=1.38u as=0.19p ps=1.38u w=1u l=0.7u
X7604 user_project_wrapper_0.analog_io[0] a_41476_115444# user_project_wrapper_0.IOVDD1 user_project_wrapper_0.IOVDD1 sg13_hv_pmos ad=3.9294p pd=7.84u as=2.1312p ps=7.3u w=6.66u l=0.6u
X7605 user_project_wrapper_0.IOVSS1 a_278644_29676# QDLL_TOP_0.VOUT user_project_wrapper_0.IOVSS1 sg13_hv_nmos ad=1.408p pd=5.04u as=2.596p ps=5.58u w=4.4u l=0.6u
X7606 analog_io[18] a_355624_115444# IOVDD3 IOVDD3 sg13_hv_pmos ad=3.9294p pd=7.84u as=2.1312p ps=7.3u w=6.66u l=0.6u
X7607 VDD3 a_296625_208423# a_296731_208493# VDD3 sg13_lv_pmos ad=0.2603p pd=1.75u as=0.2603p ps=1.75u w=1.37u l=0.35u
X7608 VDD3 a_309516_194555# a_309917_194695# VDD3 sg13_lv_pmos ad=0.19p pd=1.38u as=0.19p ps=1.38u w=1u l=0.7u
X7609 user_project_wrapper_0.analog_io[32] a_202114_326125# user_project_wrapper_0.IOVSS1 user_project_wrapper_0.IOVSS1 sg13_lv_nmos ad=0.912p pd=5.18u as=0.912p ps=5.18u w=4.8u l=0.13u
X7610 VDD3 user_project_wrapper_0.sg13g2_IOPadVdd_0.sg13g2_RCClampInverter_noptap_0.out user_project_wrapper_0.IOVSS1 user_project_wrapper_0.IOVSS1 sg13_hv_nmos ad=2.596p pd=5.58u as=1.408p ps=5.04u w=4.4u l=0.6u
X7611 a_296731_208493# a_296625_208423# VDD3 VDD3 sg13_lv_pmos ad=0.2603p pd=1.75u as=0.2603p ps=1.75u w=1.37u l=0.35u
X7612 user_project_wrapper_0.analog_io[32] a_202114_326125# user_project_wrapper_0.IOVSS1 user_project_wrapper_0.IOVSS1 sg13_lv_nmos ad=0.912p pd=5.18u as=0.912p ps=5.18u w=4.8u l=0.13u
X7613 user_project_wrapper_0.IOVDD4 user_project_wrapper_0.sg13g2_IOPadIOVdd_2.sg13g2_Clamp_N43N43D4R_0.gate user_project_wrapper_0.IOVSS1 user_project_wrapper_0.IOVSS1 sg13_hv_nmos ad=2.596p pd=5.58u as=1.408p ps=5.04u w=4.4u l=0.6u
X7614 user_project_wrapper_0.IOVSS1 user_project_wrapper_0.sg13g2_IOPadIOVdd_2.sg13g2_RCClampResistor_0.p2 user_project_wrapper_0.sg13g2_IOPadIOVdd_2.sg13g2_Clamp_N43N43D4R_0.gate user_project_wrapper_0.IOVSS1 sg13_hv_nmos ad=1.71p pd=9.38u as=1.71p ps=9.38u w=9u l=0.5u
X7615 IOVDD3 a_355624_176644# analog_io[20] IOVDD3 sg13_hv_pmos ad=2.1312p pd=7.3u as=3.9294p ps=7.84u w=6.66u l=0.6u
X7616 user_project_wrapper_0.analog_io[1] a_29676_135844# user_project_wrapper_0.IOVSS1 user_project_wrapper_0.IOVSS1 sg13_hv_nmos ad=2.596p pd=5.58u as=1.408p ps=5.04u w=4.4u l=0.6u
X7617 user_project_wrapper_0.analog_io[35] a_213870_324142# user_project_wrapper_0.IOVSS1 user_project_wrapper_0.IOVSS1 sg13_lv_pmos ad=1.824p pd=9.98u as=1.824p ps=9.98u w=9.6u l=0.13u
X7618 user_project_wrapper_0.VDD2 user_project_wrapper_0.sg13g2_IOPadVdd_1.sg13g2_RCClampInverter_noptap_0.out user_project_wrapper_0.IOVSS1 user_project_wrapper_0.IOVSS1 sg13_hv_nmos ad=2.596p pd=5.58u as=1.408p ps=5.04u w=4.4u l=0.6u
X7619 user_project_wrapper_0.IOVSS1 user_project_wrapper_0.sg13g2_IOPadIOVdd_0.sg13g2_Clamp_N43N43D4R_0.gate user_project_wrapper_0.IOVDD2 user_project_wrapper_0.IOVSS1 sg13_hv_nmos ad=1.408p pd=5.04u as=2.596p ps=5.58u w=4.4u l=0.6u
X7620 user_project_wrapper_0.IOVDD2 user_project_wrapper_0.sg13g2_IOPadIOVdd_0.sg13g2_Clamp_N43N43D4R_0.gate user_project_wrapper_0.IOVSS1 user_project_wrapper_0.IOVSS1 sg13_hv_nmos ad=2.596p pd=5.58u as=1.408p ps=5.04u w=4.4u l=0.6u
X7621 user_project_wrapper_0.analog_io[32] a_217444_355624# user_project_wrapper_0.IOVDD4 user_project_wrapper_0.IOVDD4 sg13_hv_pmos ad=3.9294p pd=7.84u as=2.1312p ps=7.3u w=6.66u l=0.6u
X7622 a_309917_199879# a_296731_208493# a_307232_196607# VDD3 sg13_lv_pmos ad=0.24415p pd=1.665u as=0.24415p ps=1.665u w=1.285u l=0.35u
X7623 a_189286_329719# a_189184_325263# a_189184_329719# user_project_wrapper_0.IOVSS1 sg13_lv_nmos ad=0.19p pd=1.38u as=0.19p ps=1.38u w=1u l=0.13u
X7624 VDD3 a_296626_197740# a_296732_197880# VDD3 sg13_lv_pmos ad=1.33p pd=7.38u as=1.33p ps=7.38u w=7u l=0.7u
X7625 a_304196_200821# a_304889_199957# a_304995_198817# user_project_wrapper_0.IOVSS1 sg13_lv_nmos ad=0.209p pd=1.48u as=0.374p ps=2.88u w=1.1u l=0.15u
X7626 user_project_wrapper_0.analog_io[29] a_156244_355624# user_project_wrapper_0.IOVDD4 user_project_wrapper_0.IOVDD4 sg13_hv_pmos ad=3.9294p pd=7.84u as=2.1312p ps=7.3u w=6.66u l=0.6u
X7627 IOVDD3 a_355624_278644# analog_io[26] IOVDD3 sg13_hv_pmos ad=2.1312p pd=7.3u as=3.9294p ps=7.84u w=6.66u l=0.6u
X7628 user_project_wrapper_0.sg13g2_IOPadVdd_0.sg13g2_RCClampInverter_noptap_0.out user_project_wrapper_0.sg13g2_IOPadVdd_0.sg13g2_RCClampResistor_0.p2 VDD3 VDD3 sg13_hv_pmos ad=1.33p pd=7.38u as=1.33p ps=7.38u w=7u l=0.5u
X7629 user_project_wrapper_0.IOVDD4 a_135844_355624# user_project_wrapper_0.analog_io[28] user_project_wrapper_0.IOVDD4 sg13_hv_pmos ad=2.1312p pd=7.3u as=3.9294p ps=7.84u w=6.66u l=0.6u
X7630 user_project_wrapper_0.IOVSS1 user_project_wrapper_0.sg13g2_IOPadIOVdd_0.sg13g2_Clamp_N43N43D4R_0.gate user_project_wrapper_0.IOVDD2 user_project_wrapper_0.IOVSS1 sg13_hv_nmos ad=1.408p pd=5.04u as=2.596p ps=5.58u w=4.4u l=0.6u
X7631 user_project_wrapper_0.IOVDD2 user_project_wrapper_0.sg13g2_IOPadIOVdd_0.sg13g2_Clamp_N43N43D4R_0.gate user_project_wrapper_0.IOVSS1 user_project_wrapper_0.IOVSS1 sg13_hv_nmos ad=2.596p pd=5.58u as=2.068p ps=9.74u w=4.4u l=0.6u
X7632 user_project_wrapper_0.VDD1 user_project_wrapper_0.sg13g2_IOPadVdd_2.sg13g2_RCClampInverter_noptap_0.out user_project_wrapper_0.IOVSS1 user_project_wrapper_0.IOVSS1 sg13_hv_nmos ad=2.596p pd=5.58u as=1.408p ps=5.04u w=4.4u l=0.6u
X7633 a_296731_189665# a_296625_189595# VDD3 VDD3 sg13_lv_pmos ad=0.2603p pd=1.75u as=0.4658p ps=3.42u w=1.37u l=0.35u
X7634 a_296731_208493# a_296625_208423# VDD3 VDD3 sg13_lv_pmos ad=0.2603p pd=1.75u as=0.4658p ps=3.42u w=1.37u l=0.35u
X7635 a_57810_281517# a_58798_281249# user_project_wrapper_0.IOVSS1 user_project_wrapper_0.IOVSS1 sg13_hv_nmos ad=0.646p pd=4.48u as=0.361p ps=2.28u w=1.9u l=0.45u
X7636 a_301735_364458# a_302065_360372# user_project_wrapper_0.IOVSS1 rppd l=20u w=1u
X7637 QDLL_TOP_0.VDD a_190389_99046# user_project_wrapper_0.analog_io[14] QDLL_TOP_0.VDD sg13_lv_pmos ad=0.2128p pd=1.5u as=0.2128p ps=1.5u w=1.12u l=0.13u
X7638 VDD3 a_309516_194555# a_309917_194695# VDD3 sg13_lv_pmos ad=0.19p pd=1.38u as=0.19p ps=1.38u w=1u l=0.7u
X7639 user_project_wrapper_0.IOVSS1 user_project_wrapper_0.sg13g2_IOPadVdd_3.sg13g2_RCClampInverter_noptap_0.out user_project_wrapper_0.IOVSS1 user_project_wrapper_0.IOVSS1 sg13_hv_nmos ad=2.596p pd=5.58u as=0 ps=0 w=4.4u l=0.6u
X7640 VDD3 a_296625_189595# a_296731_189665# VDD3 sg13_lv_pmos ad=0.4658p pd=3.42u as=0.2603p ps=1.75u w=1.37u l=0.35u
X7641 user_project_wrapper_0.IOVSS1 user_project_wrapper_0.sg13g2_IOPadVdd_3.sg13g2_RCClampInverter_noptap_0.out user_project_wrapper_0.IOVSS1 user_project_wrapper_0.IOVSS1 sg13_hv_nmos ad=2.596p pd=5.58u as=0 ps=0 w=4.4u l=0.6u
X7642 user_project_wrapper_0.IOVSS1 user_project_wrapper_0.sg13g2_IOPadVdd_3.sg13g2_RCClampInverter_noptap_0.out user_project_wrapper_0.IOVSS1 user_project_wrapper_0.IOVSS1 sg13_hv_nmos ad=2.596p pd=5.58u as=0 ps=0 w=4.4u l=0.6u
X7643 user_project_wrapper_0.IOVSS1 user_project_wrapper_0.sg13g2_IOPadVdd_0.sg13g2_RCClampInverter_noptap_0.out VDD3 user_project_wrapper_0.IOVSS1 sg13_hv_nmos ad=1.408p pd=5.04u as=2.596p ps=5.58u w=4.4u l=0.6u
X7644 user_project_wrapper_0.IOVDD1 a_41476_115444# user_project_wrapper_0.analog_io[0] user_project_wrapper_0.IOVDD1 sg13_hv_pmos ad=2.1312p pd=7.3u as=3.9294p ps=7.84u w=6.66u l=0.6u
X7645 IOVDD3 user_project_wrapper_0.sg13g2_IOPadIOVdd_3.sg13g2_RCClampResistor_0.p2 user_project_wrapper_0.sg13g2_IOPadIOVdd_3.sg13g2_Clamp_N43N43D4R_0.gate IOVDD3 sg13_hv_pmos ad=1.33p pd=7.38u as=1.33p ps=7.38u w=7u l=0.5u
X7646 VDD3 user_project_wrapper_0.sg13g2_IOPadVdd_0.sg13g2_RCClampInverter_noptap_0.out user_project_wrapper_0.IOVSS1 user_project_wrapper_0.IOVSS1 sg13_hv_nmos ad=2.596p pd=5.58u as=1.408p ps=5.04u w=4.4u l=0.6u
X7647 user_project_wrapper_0.IOVSS1 user_project_wrapper_0.sg13g2_IOPadVdd_3.sg13g2_RCClampResistor_0.p2 user_project_wrapper_0.sg13g2_IOPadVdd_3.sg13g2_RCClampInverter_noptap_0.out user_project_wrapper_0.IOVSS1 sg13_hv_pmos ad=1.33p pd=7.38u as=1.33p ps=7.38u w=7u l=0.5u
X7648 a_296732_197880# a_296626_197740# VDD3 VDD3 sg13_lv_pmos ad=1.33p pd=7.38u as=2.38p ps=14.68u w=7u l=0.7u
X7649 user_project_wrapper_0.IOVSS1 user_project_wrapper_0.sg13g2_IOPadIOVdd_0.sg13g2_Clamp_N43N43D4R_0.gate dantenna l=0.48u w=0.48u
X7650 user_project_wrapper_0.sg13g2_IOPadIOVdd_2.sg13g2_Clamp_N43N43D4R_0.gate user_project_wrapper_0.sg13g2_IOPadIOVdd_2.sg13g2_RCClampResistor_0.p2 user_project_wrapper_0.IOVDD4 user_project_wrapper_0.IOVDD4 sg13_hv_pmos ad=1.33p pd=7.38u as=1.33p ps=7.38u w=7u l=0.5u
X7651 user_project_wrapper_0.analog_io[30] a_194687_324142# user_project_wrapper_0.IOVSS1 user_project_wrapper_0.IOVSS1 sg13_lv_nmos ad=0.912p pd=5.18u as=0.912p ps=5.18u w=4.8u l=0.13u
X7652 user_project_wrapper_0.IOVSS1 user_project_wrapper_0.sg13g2_IOPadIOVdd_0.sg13g2_RCClampResistor_0.p2 user_project_wrapper_0.sg13g2_IOPadIOVdd_0.sg13g2_Clamp_N43N43D4R_0.gate user_project_wrapper_0.IOVSS1 sg13_hv_nmos ad=1.71p pd=9.38u as=1.71p ps=9.38u w=9u l=0.5u
X7653 a_296731_189665# a_296625_189595# VDD3 VDD3 sg13_lv_pmos ad=0.2603p pd=1.75u as=0.4658p ps=3.42u w=1.37u l=0.35u
X7654 user_project_wrapper_0.analog_io[16] a_258244_29676# user_project_wrapper_0.IOVSS1 user_project_wrapper_0.IOVSS1 sg13_hv_nmos ad=2.596p pd=5.58u as=1.408p ps=5.04u w=4.4u l=0.6u
X7655 a_82846_241091# a_82645_240231# user_project_wrapper_0.VDD1 user_project_wrapper_0.VDD1 sg13_lv_pmos ad=1.7p pd=10.68u as=1.7p ps=10.68u w=5u l=0.15u
X7656 VDD3 a_296625_189595# a_296731_189665# VDD3 sg13_lv_pmos ad=0.4658p pd=3.42u as=0.2603p ps=1.75u w=1.37u l=0.35u
X7657 user_project_wrapper_0.IOVDD2 a_237844_41476# user_project_wrapper_0.analog_io[15] user_project_wrapper_0.IOVDD2 sg13_hv_pmos ad=2.1312p pd=7.3u as=3.9294p ps=7.84u w=6.66u l=0.6u
X7658 user_project_wrapper_0.analog_io[28] a_135844_355624# user_project_wrapper_0.IOVDD4 user_project_wrapper_0.IOVDD4 sg13_hv_pmos ad=3.9294p pd=7.84u as=3.1302p ps=14.26u w=6.66u l=0.6u
X7659 QDLL_TOP_0.VDD a_189729_101343# a_190389_101343# QDLL_TOP_0.VDD sg13_lv_pmos ad=0.2128p pd=1.5u as=0.2128p ps=1.5u w=1.12u l=0.13u
X7660 a_298435_364458# a_298765_360372# user_project_wrapper_0.IOVSS1 rppd l=20u w=1u
X7661 user_project_wrapper_0.IOVSS1 a_301186_192011# a_296731_189665# user_project_wrapper_0.IOVSS1 sg13_lv_nmos ad=0.912p pd=5.18u as=1.632p ps=10.28u w=4.8u l=1.06u
X7662 VDD3 a_309516_194555# a_309917_199879# VDD3 sg13_lv_pmos ad=0.19p pd=1.38u as=0.19p ps=1.38u w=1u l=0.7u
X7663 IOVDD3 a_355624_237844# analog_io[23] IOVDD3 sg13_hv_pmos ad=2.1312p pd=7.3u as=3.9294p ps=7.84u w=6.66u l=0.6u
X7664 user_project_wrapper_0.IOVSS1 user_project_wrapper_0.sg13g2_IOPadVdd_3.sg13g2_RCClampInverter_noptap_0.out user_project_wrapper_0.IOVSS1 user_project_wrapper_0.IOVSS1 sg13_hv_nmos ad=1.408p pd=5.04u as=0 ps=0 w=4.4u l=0.6u
X7665 user_project_wrapper_0.IOVDD4 user_project_wrapper_0.sg13g2_IOPadIOVdd_2.sg13g2_Clamp_N43N43D4R_0.gate user_project_wrapper_0.IOVSS1 user_project_wrapper_0.IOVSS1 sg13_hv_nmos ad=2.596p pd=5.58u as=1.408p ps=5.04u w=4.4u l=0.6u
X7666 QDLL_TOP_0.VOUT user_project_wrapper_0.IOVDD2 dpantenna l=1.26u w=27.78u
X7667 user_project_wrapper_0.IOVSS1 user_project_wrapper_0.sg13g2_IOPadIOVdd_1.sg13g2_Clamp_N43N43D4R_0.gate user_project_wrapper_0.IOVDD1 user_project_wrapper_0.IOVSS1 sg13_hv_nmos ad=1.408p pd=5.04u as=2.596p ps=5.58u w=4.4u l=0.6u
X7668 QDLL_TOP_0.CPIN user_project_wrapper_0.analog_io[15] a_190584_102855# user_project_wrapper_0.IOVSS1 sg13_lv_nmos ad=0.1628p pd=1.18u as=88.8f ps=0.98u w=0.74u l=0.13u
X7669 a_296732_200582# a_296626_197740# VDD3 VDD3 sg13_lv_pmos ad=1.33p pd=7.38u as=1.33p ps=7.38u w=7u l=0.7u
X7670 user_project_wrapper_0.sg13g2_IOPadVdd_0.sg13g2_RCClampInverter_noptap_0.out user_project_wrapper_0.sg13g2_IOPadVdd_0.sg13g2_RCClampResistor_0.p2 user_project_wrapper_0.IOVSS1 user_project_wrapper_0.IOVSS1 sg13_hv_nmos ad=1.71p pd=9.38u as=3.06p ps=18.68u w=9u l=0.5u
X7671 user_project_wrapper_0.IOVSS1 a_270512_100118# a_271172_100118# user_project_wrapper_0.IOVSS1 sg13_lv_nmos ad=0.1406p pd=1.12u as=0.1406p ps=1.12u w=0.74u l=0.13u
X7672 user_project_wrapper_0.VDD2 user_project_wrapper_0.sg13g2_IOPadVdd_1.sg13g2_RCClampResistor_0.p2 user_project_wrapper_0.sg13g2_IOPadVdd_1.sg13g2_RCClampInverter_noptap_0.out user_project_wrapper_0.VDD2 sg13_hv_pmos ad=1.33p pd=7.38u as=1.33p ps=7.38u w=7u l=0.5u
X7673 a_91911_127530# a_91090_127895# user_project_wrapper_0.IOVSS1 user_project_wrapper_0.IOVSS1 sg13_lv_nmos ad=0.2516p pd=2.16u as=0.2516p ps=2.16u w=0.74u l=0.13u
X7674 a_296731_208493# a_296625_208423# VDD3 VDD3 sg13_lv_pmos ad=0.2603p pd=1.75u as=0.2603p ps=1.75u w=1.37u l=0.35u
X7675 VDD3 a_296625_189595# a_296731_189665# VDD3 sg13_lv_pmos ad=0.2603p pd=1.75u as=0.2603p ps=1.75u w=1.37u l=0.35u
X7676 user_project_wrapper_0.IOVDD2 user_project_wrapper_0.sg13g2_IOPadIOVdd_0.sg13g2_Clamp_N43N43D4R_0.gate user_project_wrapper_0.IOVSS1 user_project_wrapper_0.IOVSS1 sg13_hv_nmos ad=2.596p pd=5.58u as=1.408p ps=5.04u w=4.4u l=0.6u
X7677 user_project_wrapper_0.IOVDD1 a_41476_115444# user_project_wrapper_0.analog_io[0] user_project_wrapper_0.IOVDD1 sg13_hv_pmos ad=2.1312p pd=7.3u as=3.9294p ps=7.84u w=6.66u l=0.6u
X7678 IOVDD3 user_project_wrapper_0.sg13g2_IOPadIOVdd_3.sg13g2_RCClampResistor_0.p2 user_project_wrapper_0.sg13g2_IOPadIOVdd_3.sg13g2_Clamp_N43N43D4R_0.gate IOVDD3 sg13_hv_pmos ad=1.33p pd=7.38u as=1.33p ps=7.38u w=7u l=0.5u
X7679 VDD3 a_296626_197740# a_296626_197740# VDD3 sg13_lv_pmos ad=0.476p pd=3.48u as=0.266p ps=1.78u w=1.4u l=0.35u
X7680 user_project_wrapper_0.analog_io[10] a_135844_41476# user_project_wrapper_0.IOVDD2 user_project_wrapper_0.IOVDD2 sg13_hv_pmos ad=3.9294p pd=7.84u as=2.1312p ps=7.3u w=6.66u l=0.6u
X7681 user_project_wrapper_0.analog_io[7] a_29676_258244# user_project_wrapper_0.IOVSS1 user_project_wrapper_0.IOVSS1 sg13_hv_nmos ad=2.596p pd=5.58u as=2.068p ps=9.74u w=4.4u l=0.6u
X7682 user_project_wrapper_0.analog_io[35] a_213870_324142# user_project_wrapper_0.IOVSS1 user_project_wrapper_0.IOVSS1 sg13_lv_nmos ad=0.912p pd=5.18u as=0.912p ps=5.18u w=4.8u l=0.13u
X7683 user_project_wrapper_0.sg13g2_IOPadIOVdd_0.sg13g2_Clamp_N43N43D4R_0.gate user_project_wrapper_0.sg13g2_IOPadIOVdd_0.sg13g2_RCClampResistor_0.p2 user_project_wrapper_0.IOVDD2 user_project_wrapper_0.IOVDD2 sg13_hv_pmos ad=1.33p pd=7.38u as=1.33p ps=7.38u w=7u l=0.5u
X7684 a_311846_195517# user_project_wrapper_0.sg13g2_IOPadAnalog_29.padres a_309917_199879# VDD3 sg13_lv_pmos ad=0.24415p pd=1.665u as=0.24415p ps=1.665u w=1.285u l=0.35u
X7685 user_project_wrapper_0.IOVDD4 user_project_wrapper_0.sg13g2_IOPadIOVdd_2.sg13g2_Clamp_N43N43D4R_0.gate user_project_wrapper_0.IOVSS1 user_project_wrapper_0.IOVSS1 sg13_hv_nmos ad=2.596p pd=5.58u as=1.408p ps=5.04u w=4.4u l=0.6u
X7686 user_project_wrapper_0.IOVSS1 user_project_wrapper_0.sg13g2_IOPadVdd_2.sg13g2_RCClampInverter_noptap_0.out dantenna l=0.48u w=0.48u
X7687 a_309516_194555# a_309516_194555# VDD3 VDD3 sg13_lv_pmos ad=0.19p pd=1.38u as=0.19p ps=1.38u w=1u l=0.7u
X7688 a_82746_130212# a_79025_127401# user_project_wrapper_0.IOVSS1 user_project_wrapper_0.IOVSS1 sg13_lv_nmos ad=0.2516p pd=2.16u as=0.2516p ps=2.16u w=0.74u l=0.13u
X7689 user_project_wrapper_0.IOVSS1 a_301186_192011# a_296731_189665# user_project_wrapper_0.IOVSS1 sg13_lv_nmos ad=0.912p pd=5.18u as=0.912p ps=5.18u w=4.8u l=1.06u
X7690 a_208469_325263# a_208367_326377# a_208367_325263# user_project_wrapper_0.IOVSS1 sg13_lv_nmos ad=0.19p pd=1.38u as=0.19p ps=1.38u w=1u l=0.13u
X7691 a_304995_198817# a_304889_198885# a_304196_197873# user_project_wrapper_0.IOVSS1 sg13_lv_nmos ad=0.209p pd=1.48u as=0.209p ps=1.48u w=1.1u l=0.15u
X7692 a_189756_326377# user_project_wrapper_0.IOVSS1 user_project_wrapper_0.IOVSS1 w_188704_326203# sg13_lv_pmos ad=0.38p pd=2.38u as=0.68p ps=4.68u w=2u l=0.13u
X7693 a_57810_281517# a_58170_281249# user_project_wrapper_0.IOVDD1 user_project_wrapper_0.IOVDD1 sg13_hv_pmos ad=0.102p pd=1.28u as=57f ps=0.68u w=0.3u l=0.45u
X7694 user_project_wrapper_0.IOVSS1 user_project_wrapper_0.sg13g2_IOPadVdd_1.sg13g2_RCClampInverter_noptap_0.out user_project_wrapper_0.VDD2 user_project_wrapper_0.IOVSS1 sg13_hv_nmos ad=1.408p pd=5.04u as=2.596p ps=5.58u w=4.4u l=0.6u
X7695 user_project_wrapper_0.IOVSS1 user_project_wrapper_0.sg13g2_IOPadIOVdd_2.sg13g2_Clamp_N43N43D4R_0.gate user_project_wrapper_0.IOVDD4 user_project_wrapper_0.IOVSS1 sg13_hv_nmos ad=1.408p pd=5.04u as=2.596p ps=5.58u w=4.4u l=0.6u
X7696 a_35456_74035# a_39542_74365# user_project_wrapper_0.IOVSS1 rppd l=20u w=1u
X7697 user_project_wrapper_0.VDD1 a_86507_129255# a_88274_129426# user_project_wrapper_0.VDD1 sg13_lv_pmos ad=0.3808p pd=2.92u as=0.2128p ps=1.5u w=1.12u l=0.13u
X7698 user_project_wrapper_0.IOVSS1 user_project_wrapper_0.sg13g2_IOPadIOVdd_2.sg13g2_RCClampResistor_0.p2 user_project_wrapper_0.sg13g2_IOPadIOVdd_2.sg13g2_Clamp_N43N43D4R_0.gate user_project_wrapper_0.IOVSS1 sg13_hv_nmos ad=1.71p pd=9.38u as=1.71p ps=9.38u w=9u l=0.5u
X7699 user_project_wrapper_0.IOVSS1 a_135844_29676# user_project_wrapper_0.analog_io[10] user_project_wrapper_0.IOVSS1 sg13_hv_nmos ad=1.408p pd=5.04u as=2.596p ps=5.58u w=4.4u l=0.6u
X7700 QDLL_TOP_0.VDD a_190389_101343# user_project_wrapper_0.analog_io[15] QDLL_TOP_0.VDD sg13_lv_pmos ad=0.2128p pd=1.5u as=0.2128p ps=1.5u w=1.12u l=0.13u
X7701 user_project_wrapper_0.analog_io[28] a_135844_355624# user_project_wrapper_0.IOVDD4 user_project_wrapper_0.IOVDD4 sg13_hv_pmos ad=3.9294p pd=7.84u as=2.1312p ps=7.3u w=6.66u l=0.6u
X7702 a_296731_208493# a_301186_192011# user_project_wrapper_0.IOVSS1 user_project_wrapper_0.IOVSS1 sg13_lv_nmos ad=0.912p pd=5.18u as=0.912p ps=5.18u w=4.8u l=1.06u
X7703 user_project_wrapper_0.IOVSS1 user_project_wrapper_0.IOVSS1 user_project_wrapper_0.IOVSS1 rppd l=0.5u w=0.5u
X7704 user_project_wrapper_0.IOVSS1 user_project_wrapper_0.sg13g2_IOPadIOVdd_3.sg13g2_Clamp_N43N43D4R_0.gate IOVDD3 user_project_wrapper_0.IOVSS1 sg13_hv_nmos ad=1.408p pd=5.04u as=2.596p ps=5.58u w=4.4u l=0.6u
X7705 user_project_wrapper_0.IOVSS1 a_213870_324142# user_project_wrapper_0.analog_io[35] user_project_wrapper_0.IOVSS1 sg13_lv_nmos ad=0.912p pd=5.18u as=0.912p ps=5.18u w=4.8u l=0.13u
X7706 user_project_wrapper_0.IOVSS1 a_301186_192011# a_296731_189665# user_project_wrapper_0.IOVSS1 sg13_lv_nmos ad=1.632p pd=10.28u as=0.912p ps=5.18u w=4.8u l=1.06u
X7707 a_84598_130577# a_83925_130212# a_84598_130212# user_project_wrapper_0.IOVSS1 sg13_lv_nmos ad=0.2516p pd=2.16u as=0.1406p ps=1.12u w=0.74u l=0.13u
X7708 user_project_wrapper_0.IOVDD2 user_project_wrapper_0.sg13g2_IOPadIOVdd_0.sg13g2_Clamp_N43N43D4R_0.gate user_project_wrapper_0.IOVSS1 user_project_wrapper_0.IOVSS1 sg13_hv_nmos ad=2.596p pd=5.58u as=1.408p ps=5.04u w=4.4u l=0.6u
X7709 user_project_wrapper_0.IOVSS1 a_271172_100118# QDLL_TOP_0.VOUT user_project_wrapper_0.IOVSS1 sg13_lv_nmos ad=0.1406p pd=1.12u as=0.1406p ps=1.12u w=0.74u l=0.13u
X7710 user_project_wrapper_0.IOVDD2 user_project_wrapper_0.sg13g2_IOPadIOVdd_0.sg13g2_Clamp_N43N43D4R_0.gate user_project_wrapper_0.IOVSS1 user_project_wrapper_0.IOVSS1 sg13_hv_nmos ad=2.596p pd=5.58u as=1.408p ps=5.04u w=4.4u l=0.6u
X7711 a_309516_194555# a_309516_194555# VDD3 VDD3 sg13_lv_pmos ad=0.19p pd=1.38u as=0.19p ps=1.38u w=1u l=0.7u
X7712 user_project_wrapper_0.IOVSS1 user_project_wrapper_0.sg13g2_IOPadIOVdd_0.sg13g2_Clamp_N43N43D4R_0.gate user_project_wrapper_0.IOVDD2 user_project_wrapper_0.IOVSS1 sg13_hv_nmos ad=1.408p pd=5.04u as=2.596p ps=5.58u w=4.4u l=0.6u
X7713 IOVDD3 a_355624_156244# analog_io[20] IOVDD3 sg13_hv_pmos ad=2.1312p pd=7.3u as=3.9294p ps=7.84u w=6.66u l=0.6u
X7714 a_304196_200821# a_304090_197941# a_296625_208423# user_project_wrapper_0.IOVSS1 sg13_lv_nmos ad=0.361p pd=2.28u as=0.361p ps=2.28u w=1.9u l=0.16u
X7715 user_project_wrapper_0.analog_io[30] a_194687_324142# user_project_wrapper_0.IOVSS1 user_project_wrapper_0.IOVSS1 sg13_lv_pmos ad=1.824p pd=9.98u as=1.824p ps=9.98u w=9.6u l=0.13u
X7716 user_project_wrapper_0.analog_io[14] a_217444_41476# user_project_wrapper_0.IOVDD2 user_project_wrapper_0.IOVDD2 sg13_hv_pmos ad=3.9294p pd=7.84u as=2.1312p ps=7.3u w=6.66u l=0.6u
X7717 VDD3 a_296625_208423# a_296731_208493# VDD3 sg13_lv_pmos ad=0.2603p pd=1.75u as=0.2603p ps=1.75u w=1.37u l=0.35u
X7718 user_project_wrapper_0.VDD1 user_project_wrapper_0.sg13g2_IOPadVdd_2.sg13g2_RCClampInverter_noptap_0.out user_project_wrapper_0.IOVSS1 user_project_wrapper_0.IOVSS1 sg13_hv_nmos ad=2.596p pd=5.58u as=1.408p ps=5.04u w=4.4u l=0.6u
X7719 a_209480_328605# a_208939_328605# user_project_wrapper_0.IOVSS1 user_project_wrapper_0.IOVSS1 sg13_lv_nmos ad=0.34p pd=2.68u as=0.34p ps=2.68u w=1u l=0.13u
X7720 user_project_wrapper_0.analog_io[0] a_41476_115444# user_project_wrapper_0.IOVDD1 user_project_wrapper_0.IOVDD1 sg13_hv_pmos ad=3.9294p pd=7.84u as=2.1312p ps=7.3u w=6.66u l=0.6u
X7721 a_296625_208423# a_301940_196388# a_296732_200582# VDD3 sg13_lv_pmos ad=0.7695p pd=4.43u as=0.7695p ps=4.43u w=4.05u l=0.5u
X7722 user_project_wrapper_0.IOVDD4 a_217444_355624# user_project_wrapper_0.analog_io[32] user_project_wrapper_0.IOVDD4 sg13_hv_pmos ad=2.1312p pd=7.3u as=3.9294p ps=7.84u w=6.66u l=0.6u
X7723 a_86507_129255# a_87468_125419# user_project_wrapper_0.IOVSS1 user_project_wrapper_0.IOVSS1 sg13_lv_nmos ad=0.2516p pd=2.16u as=0.2516p ps=2.16u w=0.74u l=0.13u
X7724 a_190926_327491# a_190501_327491# a_190824_327491# user_project_wrapper_0.IOVSS1 sg13_lv_nmos ad=0.19p pd=1.38u as=0.19p ps=1.38u w=1u l=0.13u
X7725 user_project_wrapper_0.IOVSS1 a_29676_258244# user_project_wrapper_0.analog_io[7] user_project_wrapper_0.IOVSS1 sg13_hv_nmos ad=1.408p pd=5.04u as=2.596p ps=5.58u w=4.4u l=0.6u
X7726 user_project_wrapper_0.IOVSS1 user_project_wrapper_0.sg13g2_IOPadIOVdd_1.sg13g2_RCClampResistor_0.p2 user_project_wrapper_0.IOVSS1 user_project_wrapper_0.IOVSS1 sg13_hv_nmos ad=1.71p pd=9.38u as=0 ps=0 w=9u l=9.5u
X7727 IOVDD3 user_project_wrapper_0.sg13g2_IOPadIOVdd_3.sg13g2_Clamp_N43N43D4R_0.gate user_project_wrapper_0.IOVSS1 user_project_wrapper_0.IOVSS1 sg13_hv_nmos ad=2.596p pd=5.58u as=1.408p ps=5.04u w=4.4u l=0.6u
X7728 IOVDD3 user_project_wrapper_0.sg13g2_IOPadIOVdd_3.sg13g2_Clamp_N43N43D4R_0.gate user_project_wrapper_0.IOVSS1 user_project_wrapper_0.IOVSS1 sg13_hv_nmos ad=2.596p pd=5.58u as=1.408p ps=5.04u w=4.4u l=0.6u
X7729 a_296732_197880# a_296626_197740# VDD3 VDD3 sg13_lv_pmos ad=1.33p pd=7.38u as=1.33p ps=7.38u w=7u l=0.7u
X7730 IOVDD3 a_355624_115444# analog_io[18] IOVDD3 sg13_hv_pmos ad=2.1312p pd=7.3u as=3.9294p ps=7.84u w=6.66u l=0.6u
X7731 a_194279_327536# a_194193_328627# user_project_wrapper_0.IOVSS1 user_project_wrapper_0.IOVSS1 sg13_lv_nmos ad=0.912p pd=5.18u as=0.912p ps=5.18u w=4.8u l=0.13u
X7732 user_project_wrapper_0.IOVSS1 user_project_wrapper_0.IOVSS1 user_project_wrapper_0.IOVSS1 rppd l=0.5u w=0.5u
X7733 user_project_wrapper_0.IOVDD4 a_237844_355624# user_project_wrapper_0.IOVDD4 rppd l=12.9u w=0.5u
X7734 user_project_wrapper_0.VDD2 user_project_wrapper_0.sg13g2_IOPadVdd_1.sg13g2_RCClampResistor_0.p2 user_project_wrapper_0.sg13g2_IOPadVdd_1.sg13g2_RCClampInverter_noptap_0.out user_project_wrapper_0.VDD2 sg13_hv_pmos ad=1.33p pd=7.38u as=1.33p ps=7.38u w=7u l=0.5u
X7735 user_project_wrapper_0.IOVSS1 a_29676_197044# user_project_wrapper_0.IOVSS1 rppd l=3.54u w=0.5u
X7736 analog_io[20] a_369296_156244# user_project_wrapper_0.IOVSS1 user_project_wrapper_0.IOVSS1 sg13_hv_nmos ad=2.596p pd=5.58u as=1.408p ps=5.04u w=4.4u l=0.6u
X7737 IOVDD3 user_project_wrapper_0.sg13g2_IOPadIOVdd_3.sg13g2_RCClampResistor_0.p2 user_project_wrapper_0.sg13g2_IOPadIOVdd_3.sg13g2_Clamp_N43N43D4R_0.gate IOVDD3 sg13_hv_pmos ad=1.33p pd=7.38u as=1.33p ps=7.38u w=7u l=0.5u
X7738 user_project_wrapper_0.analog_io[35] a_278644_355624# user_project_wrapper_0.IOVDD4 user_project_wrapper_0.IOVDD4 sg13_hv_pmos ad=3.9294p pd=7.84u as=2.1312p ps=7.3u w=6.66u l=0.6u
X7739 user_project_wrapper_0.analog_io[27] a_115444_355624# user_project_wrapper_0.IOVDD4 user_project_wrapper_0.IOVDD4 sg13_hv_pmos ad=3.9294p pd=7.84u as=2.1312p ps=7.3u w=6.66u l=0.6u
X7740 user_project_wrapper_0.IOVSS1 user_project_wrapper_0.IOVSS1 user_project_wrapper_0.IOVSS1 rhigh l=4u w=0.5u
X7741 user_project_wrapper_0.analog_io[32] a_202114_326125# user_project_wrapper_0.IOVSS1 user_project_wrapper_0.IOVSS1 sg13_lv_nmos ad=0.912p pd=5.18u as=0.912p ps=5.18u w=4.8u l=0.13u
X7742 user_project_wrapper_0.IOVSS1 user_project_wrapper_0.IOVSS1 user_project_wrapper_0.IOVSS1 rppd l=0.5u w=0.5u
X7743 user_project_wrapper_0.analog_io[35] a_213870_324142# user_project_wrapper_0.IOVSS1 user_project_wrapper_0.IOVSS1 sg13_lv_pmos ad=1.824p pd=9.98u as=1.824p ps=9.98u w=9.6u l=0.13u
X7744 user_project_wrapper_0.analog_io[12] a_176644_41476# user_project_wrapper_0.IOVDD2 user_project_wrapper_0.IOVDD2 sg13_hv_pmos ad=3.9294p pd=7.84u as=2.1312p ps=7.3u w=6.66u l=0.6u
X7745 user_project_wrapper_0.IOVSS1 user_project_wrapper_0.sg13g2_IOPadVdd_2.sg13g2_RCClampInverter_noptap_0.out user_project_wrapper_0.VDD1 user_project_wrapper_0.IOVSS1 sg13_hv_nmos ad=1.408p pd=5.04u as=2.596p ps=5.58u w=4.4u l=0.6u
X7746 user_project_wrapper_0.VDD2 user_project_wrapper_0.sg13g2_IOPadVdd_1.sg13g2_RCClampInverter_noptap_0.out user_project_wrapper_0.IOVSS1 user_project_wrapper_0.IOVSS1 sg13_hv_nmos ad=2.596p pd=5.58u as=1.408p ps=5.04u w=4.4u l=0.6u
X7747 user_project_wrapper_0.IOVDD4 user_project_wrapper_0.sg13g2_IOPadIOVdd_2.sg13g2_RCClampResistor_0.p2 user_project_wrapper_0.sg13g2_IOPadIOVdd_2.sg13g2_Clamp_N43N43D4R_0.gate user_project_wrapper_0.IOVDD4 sg13_hv_pmos ad=1.33p pd=7.38u as=1.33p ps=7.38u w=7u l=0.5u
X7748 user_project_wrapper_0.IOVDD4 a_258244_355624# user_project_wrapper_0.analog_io[34] user_project_wrapper_0.IOVDD4 sg13_hv_pmos ad=2.1312p pd=7.3u as=3.9294p ps=7.84u w=6.66u l=0.6u
X7749 user_project_wrapper_0.IOVSS1 user_project_wrapper_0.sg13g2_IOPadAnalog_23.padres dantenna l=3.1u w=0.64u
X7750 user_project_wrapper_0.IOVSS1 user_project_wrapper_0.sg13g2_IOPadIOVdd_0.sg13g2_RCClampResistor_0.p2 user_project_wrapper_0.sg13g2_IOPadIOVdd_0.sg13g2_Clamp_N43N43D4R_0.gate user_project_wrapper_0.IOVSS1 sg13_hv_nmos ad=1.71p pd=9.38u as=1.71p ps=9.38u w=9u l=0.5u
X7751 user_project_wrapper_0.IOVSS1 user_project_wrapper_0.IOVSS1 user_project_wrapper_0.IOVSS1 rhigh l=4u w=0.5u
X7752 VDD3 a_309516_194555# a_309917_194695# VDD3 sg13_lv_pmos ad=0.19p pd=1.38u as=0.19p ps=1.38u w=1u l=0.7u
X7753 a_309917_199879# a_309516_194555# VDD3 VDD3 sg13_lv_pmos ad=0.19p pd=1.38u as=0.19p ps=1.38u w=1u l=0.7u
X7754 user_project_wrapper_0.IOVSS1 user_project_wrapper_0.sg13g2_IOPadIOVdd_1.sg13g2_RCClampResistor_0.p2 user_project_wrapper_0.IOVSS1 user_project_wrapper_0.IOVSS1 sg13_hv_nmos ad=1.71p pd=9.38u as=0 ps=0 w=9u l=9.5u
X7755 user_project_wrapper_0.IOVSS1 a_202114_326125# user_project_wrapper_0.analog_io[32] user_project_wrapper_0.IOVSS1 sg13_lv_pmos ad=1.824p pd=9.98u as=1.824p ps=9.98u w=9.6u l=0.13u
X7756 user_project_wrapper_0.IOVSS1 user_project_wrapper_0.sg13g2_IOPadIOVdd_1.sg13g2_Clamp_N43N43D4R_0.gate user_project_wrapper_0.IOVDD1 user_project_wrapper_0.IOVSS1 sg13_hv_nmos ad=1.408p pd=5.04u as=2.596p ps=5.58u w=4.4u l=0.6u
X7757 user_project_wrapper_0.IOVDD4 user_project_wrapper_0.sg13g2_IOPadIOVdd_2.sg13g2_Clamp_N43N43D4R_0.gate user_project_wrapper_0.IOVSS1 user_project_wrapper_0.IOVSS1 sg13_hv_nmos ad=2.596p pd=5.58u as=1.408p ps=5.04u w=4.4u l=0.6u
X7758 a_88393_125210# a_86507_127725# a_88291_125210# user_project_wrapper_0.VDD1 sg13_lv_pmos ad=0.2128p pd=1.5u as=0.2128p ps=1.5u w=1.12u l=0.13u
X7759 IOVDD3 a_355624_197044# analog_io[22] IOVDD3 sg13_hv_pmos ad=2.1312p pd=7.3u as=3.9294p ps=7.84u w=6.66u l=0.6u
X7760 user_project_wrapper_0.IOVSS1 a_202114_326125# user_project_wrapper_0.analog_io[32] user_project_wrapper_0.IOVSS1 sg13_lv_pmos ad=1.824p pd=9.98u as=1.824p ps=9.98u w=9.6u l=0.13u
X7761 a_296731_189665# a_296625_189595# VDD3 VDD3 sg13_lv_pmos ad=0.2603p pd=1.75u as=0.2603p ps=1.75u w=1.37u l=0.35u
X7762 a_189184_326377# user_project_wrapper_0.IOVSS1 user_project_wrapper_0.IOVSS1 w_188704_326203# sg13_lv_pmos ad=0.38p pd=2.38u as=0.68p ps=4.68u w=2u l=0.13u
X7763 user_project_wrapper_0.analog_io[30] a_194687_324142# user_project_wrapper_0.IOVSS1 user_project_wrapper_0.IOVSS1 sg13_lv_nmos ad=0.912p pd=5.18u as=0.912p ps=5.18u w=4.8u l=0.13u
X7764 analog_io[18] a_355624_115444# IOVDD3 IOVDD3 sg13_hv_pmos ad=3.9294p pd=7.84u as=3.1302p ps=14.26u w=6.66u l=0.6u
X7765 user_project_wrapper_0.IOVDD1 user_project_wrapper_0.sg13g2_IOPadIOVdd_1.sg13g2_Clamp_N43N43D4R_0.gate user_project_wrapper_0.IOVSS1 user_project_wrapper_0.IOVSS1 sg13_hv_nmos ad=2.596p pd=5.58u as=1.408p ps=5.04u w=4.4u l=0.6u
X7766 user_project_wrapper_0.analog_io[15] a_190389_101343# user_project_wrapper_0.IOVSS1 user_project_wrapper_0.IOVSS1 sg13_lv_nmos ad=0.1406p pd=1.12u as=0.1406p ps=1.12u w=0.74u l=0.13u
X7767 a_202114_326125# a_205385_326221# user_project_wrapper_0.IOVSS1 user_project_wrapper_0.IOVSS1 sg13_lv_nmos ad=0.912p pd=5.18u as=0.912p ps=5.18u w=4.8u l=0.13u
X7768 a_296731_189665# a_296625_189595# VDD3 VDD3 sg13_lv_pmos ad=0.2603p pd=1.75u as=0.2603p ps=1.75u w=1.37u l=0.35u
X7769 user_project_wrapper_0.IOVSS1 user_project_wrapper_0.sg13g2_IOPadVdd_3.sg13g2_RCClampInverter_noptap_0.out user_project_wrapper_0.IOVSS1 user_project_wrapper_0.IOVSS1 sg13_hv_nmos ad=2.596p pd=5.58u as=0 ps=0 w=4.4u l=0.6u
X7770 a_296625_189595# a_301940_196388# a_296732_197880# VDD3 sg13_lv_pmos ad=0.7695p pd=4.43u as=1.377p ps=8.78u w=4.05u l=0.5u
X7771 a_202114_326125# a_205385_326221# user_project_wrapper_0.IOVSS1 user_project_wrapper_0.IOVSS1 sg13_lv_nmos ad=0.912p pd=5.18u as=0.912p ps=5.18u w=4.8u l=0.13u
X7772 a_309917_194695# a_309516_194555# VDD3 VDD3 sg13_lv_pmos ad=0.19p pd=1.38u as=0.34p ps=2.68u w=1u l=0.7u
X7773 analog_io[22] a_369296_197044# user_project_wrapper_0.IOVSS1 user_project_wrapper_0.IOVSS1 sg13_hv_nmos ad=2.596p pd=5.58u as=1.408p ps=5.04u w=4.4u l=0.6u
X7774 user_project_wrapper_0.IOVSS1 a_369296_135844# analog_io[19] user_project_wrapper_0.IOVSS1 sg13_hv_nmos ad=1.408p pd=5.04u as=2.596p ps=5.58u w=4.4u l=0.6u
X7775 user_project_wrapper_0.IOVSS1 user_project_wrapper_0.sg13g2_IOPadIOVdd_3.sg13g2_Clamp_N43N43D4R_0.gate IOVDD3 user_project_wrapper_0.IOVSS1 sg13_hv_nmos ad=1.408p pd=5.04u as=2.596p ps=5.58u w=4.4u l=0.6u
X7776 user_project_wrapper_0.IOVSS1 user_project_wrapper_0.sg13g2_IOPadIOVdd_3.sg13g2_Clamp_N43N43D4R_0.gate IOVDD3 user_project_wrapper_0.IOVSS1 sg13_hv_nmos ad=1.408p pd=5.04u as=2.596p ps=5.58u w=4.4u l=0.6u
X7777 a_296731_189665# a_296625_189595# VDD3 VDD3 sg13_lv_pmos ad=0.2603p pd=1.75u as=0.2603p ps=1.75u w=1.37u l=0.35u
X7778 a_304995_198817# a_307232_196607# user_project_wrapper_0.IOVSS1 user_project_wrapper_0.IOVSS1 sg13_lv_nmos ad=0.6327p pd=3.71u as=0.6327p ps=3.71u w=3.33u l=0.2u
X7779 user_project_wrapper_0.IOVSS1 user_project_wrapper_0.IOVSS1 user_project_wrapper_0.IOVSS1 rppd l=0.5u w=0.5u
X7780 user_project_wrapper_0.analog_io[33] a_237844_355624# user_project_wrapper_0.IOVDD4 user_project_wrapper_0.IOVDD4 sg13_hv_pmos ad=3.9294p pd=7.84u as=2.1312p ps=7.3u w=6.66u l=0.6u
X7781 user_project_wrapper_0.IOVSS1 user_project_wrapper_0.sg13g2_IOPadIOVdd_1.sg13g2_Clamp_N43N43D4R_0.gate user_project_wrapper_0.IOVDD1 user_project_wrapper_0.IOVSS1 sg13_hv_nmos ad=1.408p pd=5.04u as=2.596p ps=5.58u w=4.4u l=0.6u
X7782 VDD3 a_311108_179669# analog_io[20] user_project_wrapper_0.IOVSS1 sg13_lv_nmos ad=3.4p pd=20.68u as=3.4p ps=20.68u w=10u l=0.15u
X7783 a_296731_189665# a_296625_189595# VDD3 VDD3 sg13_lv_pmos ad=0.2603p pd=1.75u as=0.2603p ps=1.75u w=1.37u l=0.35u
X7784 VDD3 a_296625_189595# a_296731_189665# VDD3 sg13_lv_pmos ad=0.4658p pd=3.42u as=0.2603p ps=1.75u w=1.37u l=0.35u
X7785 VDD3 a_309516_194555# a_309917_194695# VDD3 sg13_lv_pmos ad=0.19p pd=1.38u as=0.19p ps=1.38u w=1u l=0.7u
X7786 QDLL_TOP_0.VDD a_189729_101343# a_190389_101343# QDLL_TOP_0.VDD sg13_lv_pmos ad=0.2128p pd=1.5u as=0.2128p ps=1.5u w=1.12u l=0.13u
X7787 user_project_wrapper_0.IOVDD1 a_41476_197044# user_project_wrapper_0.analog_io[4] user_project_wrapper_0.IOVDD1 sg13_hv_pmos ad=2.1312p pd=7.3u as=3.9294p ps=7.84u w=6.66u l=0.6u
X7788 user_project_wrapper_0.IOVSS1 user_project_wrapper_0.sg13g2_IOPadIOVdd_3.sg13g2_Clamp_N43N43D4R_0.gate IOVDD3 user_project_wrapper_0.IOVSS1 sg13_hv_nmos ad=1.408p pd=5.04u as=2.596p ps=5.58u w=4.4u l=0.6u
X7789 IOVDD3 user_project_wrapper_0.sg13g2_IOPadIOVdd_3.sg13g2_RCClampResistor_0.p2 user_project_wrapper_0.sg13g2_IOPadIOVdd_3.sg13g2_Clamp_N43N43D4R_0.gate IOVDD3 sg13_hv_pmos ad=1.33p pd=7.38u as=1.33p ps=7.38u w=7u l=0.5u
X7790 a_360372_299425# a_364458_299095# user_project_wrapper_0.IOVSS1 rppd l=20u w=1u
X7791 a_296731_208493# a_296625_208423# VDD3 VDD3 sg13_lv_pmos ad=0.2603p pd=1.75u as=0.2603p ps=1.75u w=1.37u l=0.35u
X7792 a_82118_239118# user_project_wrapper_0.IOVSS1 user_project_wrapper_0.IOVSS1 rppd l=2u w=0.5u
X7793 analog_io[20] a_355624_176644# IOVDD3 IOVDD3 sg13_hv_pmos ad=3.9294p pd=7.84u as=2.1312p ps=7.3u w=6.66u l=0.6u
X7794 a_311108_215937# analog_io[23] a_313884_211353# user_project_wrapper_0.IOVSS1 sg13_lv_nmos ad=1.9p pd=10.38u as=1.9p ps=10.38u w=10u l=0.5u
X7795 a_194687_324142# a_194279_327536# user_project_wrapper_0.IOVSS1 user_project_wrapper_0.IOVSS1 sg13_lv_pmos ad=1.824p pd=9.98u as=1.824p ps=9.98u w=9.6u l=0.13u
X7796 user_project_wrapper_0.IOVSS1 a_270512_100118# a_271172_100118# user_project_wrapper_0.IOVSS1 sg13_lv_nmos ad=0.1406p pd=1.12u as=0.1406p ps=1.12u w=0.74u l=0.13u
X7797 a_191438_325263# a_191234_325263# user_project_wrapper_0.IOVSS1 user_project_wrapper_0.IOVSS1 sg13_lv_nmos ad=0.34p pd=2.68u as=0.19p ps=1.38u w=1u l=0.13u
X7798 user_project_wrapper_0.IOVSS1 a_307232_196607# a_304995_198817# user_project_wrapper_0.IOVSS1 sg13_lv_nmos ad=0.6327p pd=3.71u as=0.6327p ps=3.71u w=3.33u l=0.2u
X7799 user_project_wrapper_0.IOVSS1 user_project_wrapper_0.sg13g2_IOPadIOVdd_1.sg13g2_RCClampResistor_0.p2 user_project_wrapper_0.IOVSS1 user_project_wrapper_0.IOVSS1 sg13_hv_nmos ad=1.71p pd=9.38u as=0 ps=0 w=9u l=9.5u
X7800 user_project_wrapper_0.IOVSS1 a_237844_29676# user_project_wrapper_0.analog_io[15] user_project_wrapper_0.IOVSS1 sg13_hv_nmos ad=1.408p pd=5.04u as=2.596p ps=5.58u w=4.4u l=0.6u
X7801 a_188572_99046# a_188296_99070# user_project_wrapper_0.IOVSS1 user_project_wrapper_0.IOVSS1 sg13_lv_nmos ad=0.2516p pd=2.16u as=0.1426p ps=1.16u w=0.74u l=0.13u
X7802 analog_io[26] a_369296_278644# user_project_wrapper_0.IOVSS1 user_project_wrapper_0.IOVSS1 sg13_hv_nmos ad=2.596p pd=5.58u as=2.068p ps=9.74u w=4.4u l=0.6u
X7803 user_project_wrapper_0.analog_io[32] a_202114_326125# user_project_wrapper_0.IOVSS1 user_project_wrapper_0.IOVSS1 sg13_lv_pmos ad=1.824p pd=9.98u as=1.824p ps=9.98u w=9.6u l=0.13u
X7804 user_project_wrapper_0.analog_io[13] a_197044_41476# user_project_wrapper_0.IOVDD2 user_project_wrapper_0.IOVDD2 sg13_hv_pmos ad=3.9294p pd=7.84u as=2.1312p ps=7.3u w=6.66u l=0.6u
X7805 user_project_wrapper_0.IOVSS1 user_project_wrapper_0.sg13g2_IOPadVdd_2.sg13g2_RCClampInverter_noptap_0.out user_project_wrapper_0.VDD1 user_project_wrapper_0.IOVSS1 sg13_hv_nmos ad=1.408p pd=5.04u as=2.596p ps=5.58u w=4.4u l=0.6u
X7806 user_project_wrapper_0.IOVDD4 user_project_wrapper_0.sg13g2_IOPadIOVdd_2.sg13g2_Clamp_N43N43D4R_0.gate user_project_wrapper_0.IOVSS1 user_project_wrapper_0.IOVSS1 sg13_hv_nmos ad=2.596p pd=5.58u as=1.408p ps=5.04u w=4.4u l=0.6u
X7807 a_360372_78325# a_364458_77995# user_project_wrapper_0.IOVSS1 rppd l=20u w=1u
X7808 user_project_wrapper_0.IOVSS1 a_194687_324142# user_project_wrapper_0.analog_io[30] user_project_wrapper_0.IOVSS1 sg13_lv_nmos ad=0.912p pd=5.18u as=0.912p ps=5.18u w=4.8u l=0.13u
X7809 user_project_wrapper_0.IOVDD4 user_project_wrapper_0.sg13g2_IOPadIOVdd_2.sg13g2_Clamp_N43N43D4R_0.gate user_project_wrapper_0.IOVSS1 user_project_wrapper_0.IOVSS1 sg13_hv_nmos ad=2.596p pd=5.58u as=1.408p ps=5.04u w=4.4u l=0.6u
X7810 a_296731_208493# a_296625_208423# VDD3 VDD3 sg13_lv_pmos ad=0.2603p pd=1.75u as=0.4658p ps=3.42u w=1.37u l=0.35u
X7811 a_87434_127531# a_86594_127896# user_project_wrapper_0.IOVSS1 user_project_wrapper_0.IOVSS1 sg13_lv_nmos ad=0.1406p pd=1.12u as=0.2516p ps=2.16u w=0.74u l=0.13u
X7812 user_project_wrapper_0.IOVDD4 user_project_wrapper_0.sg13g2_IOPadIOVdd_2.sg13g2_Clamp_N43N43D4R_0.gate user_project_wrapper_0.IOVSS1 user_project_wrapper_0.IOVSS1 sg13_hv_nmos ad=2.596p pd=5.58u as=1.408p ps=5.04u w=4.4u l=0.6u
X7813 VDD3 user_project_wrapper_0.sg13g2_IOPadVdd_0.sg13g2_RCClampInverter_noptap_0.out user_project_wrapper_0.IOVSS1 user_project_wrapper_0.IOVSS1 sg13_hv_nmos ad=3.256p pd=10.28u as=1.408p ps=5.04u w=4.4u l=0.6u
X7814 user_project_wrapper_0.IOVDD4 user_project_wrapper_0.sg13g2_IOPadIOVdd_2.sg13g2_Clamp_N43N43D4R_0.gate user_project_wrapper_0.IOVSS1 user_project_wrapper_0.IOVSS1 sg13_hv_nmos ad=2.596p pd=5.58u as=1.408p ps=5.04u w=4.4u l=0.6u
X7815 user_project_wrapper_0.IOVSS1 user_project_wrapper_0.sg13g2_IOPadVdd_3.sg13g2_RCClampInverter_noptap_0.out user_project_wrapper_0.IOVSS1 user_project_wrapper_0.IOVSS1 sg13_hv_nmos ad=2.596p pd=5.58u as=0 ps=0 w=4.4u l=0.6u
X7816 user_project_wrapper_0.IOVDD4 user_project_wrapper_0.sg13g2_IOPadIOVdd_2.sg13g2_Clamp_N43N43D4R_0.gate user_project_wrapper_0.IOVSS1 user_project_wrapper_0.IOVSS1 sg13_hv_nmos ad=2.596p pd=5.58u as=1.408p ps=5.04u w=4.4u l=0.6u
X7817 user_project_wrapper_0.analog_io[35] a_278644_369296# user_project_wrapper_0.IOVSS1 user_project_wrapper_0.IOVSS1 sg13_hv_nmos ad=2.596p pd=5.58u as=1.408p ps=5.04u w=4.4u l=0.6u
X7818 user_project_wrapper_0.analog_io[27] a_115444_369296# user_project_wrapper_0.IOVSS1 user_project_wrapper_0.IOVSS1 sg13_hv_nmos ad=2.596p pd=5.58u as=1.408p ps=5.04u w=4.4u l=0.6u
X7819 VDD3 a_309516_194555# a_309516_194555# VDD3 sg13_lv_pmos ad=0.19p pd=1.38u as=0.19p ps=1.38u w=1u l=0.7u
X7820 user_project_wrapper_0.IOVSS1 user_project_wrapper_0.sg13g2_IOPadIOVdd_1.sg13g2_RCClampResistor_0.p2 user_project_wrapper_0.IOVSS1 user_project_wrapper_0.IOVSS1 sg13_hv_nmos ad=1.71p pd=9.38u as=0 ps=0 w=9u l=9.5u
X7821 a_313884_185173# a_296731_189665# a_311189_185546# user_project_wrapper_0.IOVSS1 sg13_lv_nmos ad=3.4p pd=20.68u as=1.9p ps=10.38u w=10u l=0.5u
X7822 a_360372_304705# a_364458_304375# user_project_wrapper_0.IOVSS1 rppd l=20u w=1u
X7823 user_project_wrapper_0.IOVSS1 a_29676_237844# user_project_wrapper_0.analog_io[6] user_project_wrapper_0.IOVSS1 sg13_hv_nmos ad=1.408p pd=5.04u as=2.596p ps=5.58u w=4.4u l=0.6u
X7824 user_project_wrapper_0.IOVDD1 user_project_wrapper_0.sg13g2_IOPadIOVdd_1.sg13g2_Clamp_N43N43D4R_0.gate user_project_wrapper_0.IOVSS1 user_project_wrapper_0.IOVSS1 sg13_hv_nmos ad=2.596p pd=5.58u as=1.408p ps=5.04u w=4.4u l=0.6u
X7825 user_project_wrapper_0.IOVSS1 user_project_wrapper_0.sg13g2_IOPadIOVdd_2.sg13g2_Clamp_N43N43D4R_0.gate user_project_wrapper_0.IOVDD4 user_project_wrapper_0.IOVSS1 sg13_hv_nmos ad=1.408p pd=5.04u as=2.596p ps=5.58u w=4.4u l=0.6u
X7826 user_project_wrapper_0.IOVSS1 user_project_wrapper_0.sg13g2_IOPadIOVdd_3.sg13g2_Clamp_N43N43D4R_0.gate IOVDD3 user_project_wrapper_0.IOVSS1 sg13_hv_nmos ad=1.408p pd=5.04u as=2.596p ps=5.58u w=4.4u l=0.6u
X7827 VDD3 a_314697_196700# a_314793_198352# VDD3 sg13_lv_pmos ad=1.14p pd=6.38u as=1.14p ps=6.38u w=6u l=2.5u
X7828 a_355624_258244# IOVDD3 IOVDD3 rppd l=12.9u w=0.5u
X7829 a_296731_208493# a_296625_208423# VDD3 VDD3 sg13_lv_pmos ad=0.2603p pd=1.75u as=0.2603p ps=1.75u w=1.37u l=0.35u
X7830 a_296731_208493# a_296625_208423# VDD3 VDD3 sg13_lv_pmos ad=0.2603p pd=1.75u as=0.4658p ps=3.42u w=1.37u l=0.35u
X7831 a_82859_239376# user_project_wrapper_0.sg13g2_IOPadAnalog_14.padres a_82846_240684# user_project_wrapper_0.VDD1 sg13_lv_pmos ad=0.95p pd=5.38u as=1.7p ps=10.68u w=5u l=0.3u
X7832 user_project_wrapper_0.IOVSS1 a_213870_324142# user_project_wrapper_0.analog_io[35] user_project_wrapper_0.IOVSS1 sg13_lv_nmos ad=0.912p pd=5.18u as=0.912p ps=5.18u w=4.8u l=0.13u
X7833 user_project_wrapper_0.IOVSS1 user_project_wrapper_0.sg13g2_IOPadIOVdd_2.sg13g2_Clamp_N43N43D4R_0.gate user_project_wrapper_0.IOVDD4 user_project_wrapper_0.IOVSS1 sg13_hv_nmos ad=1.408p pd=5.04u as=2.596p ps=5.58u w=4.4u l=0.6u
X7834 a_296626_197740# a_296626_197740# VDD3 VDD3 sg13_lv_pmos ad=0.266p pd=1.78u as=0.266p ps=1.78u w=1.4u l=0.35u
X7835 VDD3 a_296625_208423# a_296731_208493# VDD3 sg13_lv_pmos ad=0.2603p pd=1.75u as=0.2603p ps=1.75u w=1.37u l=0.35u
X7836 user_project_wrapper_0.IOVDD4 a_278644_355624# user_project_wrapper_0.analog_io[35] user_project_wrapper_0.IOVDD4 sg13_hv_pmos ad=2.1312p pd=7.3u as=3.9294p ps=7.84u w=6.66u l=0.6u
X7837 VDD3 a_296625_189595# a_296731_189665# VDD3 sg13_lv_pmos ad=0.2603p pd=1.75u as=0.2603p ps=1.75u w=1.37u l=0.35u
X7838 user_project_wrapper_0.IOVSS1 user_project_wrapper_0.sg13g2_IOPadVdd_1.sg13g2_RCClampInverter_noptap_0.out user_project_wrapper_0.VDD2 user_project_wrapper_0.IOVSS1 sg13_hv_nmos ad=1.408p pd=5.04u as=2.596p ps=5.58u w=4.4u l=0.6u
X7839 user_project_wrapper_0.IOVSS1 a_192138_324119# a_191800_324119# w_188806_323975# sg13_lv_pmos ad=0.68p pd=4.68u as=0.68p ps=4.68u w=2u l=0.65u
X7840 user_project_wrapper_0.IOVDD4 a_115444_355624# user_project_wrapper_0.analog_io[27] user_project_wrapper_0.IOVDD4 sg13_hv_pmos ad=2.1312p pd=7.3u as=3.9294p ps=7.84u w=6.66u l=0.6u
X7841 QDLL_TOP_0.VDD a_268967_100118# a_269079_100182# QDLL_TOP_0.VDD sg13_lv_pmos ad=0.2254p pd=1.53u as=0.34p ps=2.68u w=1u l=0.5u
X7842 a_296731_189665# a_301186_192011# user_project_wrapper_0.IOVSS1 user_project_wrapper_0.IOVSS1 sg13_lv_nmos ad=0.912p pd=5.18u as=0.912p ps=5.18u w=4.8u l=1.06u
X7843 a_296732_197880# a_301940_196388# a_296625_189595# VDD3 sg13_lv_pmos ad=0.7695p pd=4.43u as=0.7695p ps=4.43u w=4.05u l=0.5u
X7844 QDLL_TOP_0.VOUT a_278644_41476# user_project_wrapper_0.IOVDD2 user_project_wrapper_0.IOVDD2 sg13_hv_pmos ad=3.9294p pd=7.84u as=2.1312p ps=7.3u w=6.66u l=0.6u
X7845 a_309917_199879# a_296731_208493# a_307232_196607# VDD3 sg13_lv_pmos ad=0.24415p pd=1.665u as=0.24415p ps=1.665u w=1.285u l=0.35u
X7846 user_project_wrapper_0.sg13g2_IOPadVdd_2.sg13g2_RCClampInverter_noptap_0.out user_project_wrapper_0.sg13g2_IOPadVdd_2.sg13g2_RCClampResistor_0.p2 user_project_wrapper_0.VDD1 user_project_wrapper_0.VDD1 sg13_hv_pmos ad=1.33p pd=7.38u as=1.33p ps=7.38u w=7u l=0.5u
X7847 user_project_wrapper_0.IOVSS1 a_369296_278644# analog_io[26] user_project_wrapper_0.IOVSS1 sg13_hv_nmos ad=1.408p pd=5.04u as=2.596p ps=5.58u w=4.4u l=0.6u
X7848 VDD3 user_project_wrapper_0.sg13g2_IOPadVdd_0.sg13g2_RCClampInverter_noptap_0.out user_project_wrapper_0.IOVSS1 user_project_wrapper_0.IOVSS1 sg13_hv_nmos ad=2.596p pd=5.58u as=1.408p ps=5.04u w=4.4u l=0.6u
X7849 a_311189_211724# a_296731_208493# a_313884_211353# user_project_wrapper_0.IOVSS1 sg13_lv_nmos ad=1.9p pd=10.38u as=1.9p ps=10.38u w=10u l=0.5u
X7850 analog_io[22] a_369296_197044# user_project_wrapper_0.IOVSS1 user_project_wrapper_0.IOVSS1 sg13_hv_nmos ad=2.596p pd=5.58u as=1.408p ps=5.04u w=4.4u l=0.6u
X7851 user_project_wrapper_0.analog_io[4] a_41476_197044# user_project_wrapper_0.IOVDD1 user_project_wrapper_0.IOVDD1 sg13_hv_pmos ad=3.9294p pd=7.84u as=3.1302p ps=14.26u w=6.66u l=0.6u
X7852 user_project_wrapper_0.IOVSS1 a_190389_99046# user_project_wrapper_0.analog_io[14] user_project_wrapper_0.IOVSS1 sg13_lv_nmos ad=0.1406p pd=1.12u as=0.1406p ps=1.12u w=0.74u l=0.13u
X7853 user_project_wrapper_0.sg13g2_IOPadIOVdd_0.sg13g2_Clamp_N43N43D4R_0.gate user_project_wrapper_0.sg13g2_IOPadIOVdd_0.sg13g2_RCClampResistor_0.p2 user_project_wrapper_0.IOVDD2 user_project_wrapper_0.IOVDD2 sg13_hv_pmos ad=1.33p pd=7.38u as=1.33p ps=7.38u w=7u l=0.5u
X7854 a_35456_303055# a_39542_303385# user_project_wrapper_0.IOVSS1 rppd l=20u w=1u
X7855 user_project_wrapper_0.IOVSS1 a_237844_369296# user_project_wrapper_0.analog_io[33] user_project_wrapper_0.IOVSS1 sg13_hv_nmos ad=1.408p pd=5.04u as=2.596p ps=5.58u w=4.4u l=0.6u
X7856 a_194279_327536# a_194193_328627# user_project_wrapper_0.IOVSS1 user_project_wrapper_0.IOVSS1 sg13_lv_nmos ad=0.912p pd=5.18u as=1.632p ps=10.28u w=4.8u l=0.13u
X7857 user_project_wrapper_0.analog_io[14] a_217444_29676# user_project_wrapper_0.IOVSS1 user_project_wrapper_0.IOVSS1 sg13_hv_nmos ad=2.596p pd=5.58u as=1.408p ps=5.04u w=4.4u l=0.6u
X7858 a_369296_217444# user_project_wrapper_0.IOVSS1 user_project_wrapper_0.IOVSS1 rppd l=3.54u w=0.5u
X7859 VDD3 a_296625_208423# a_296731_208493# VDD3 sg13_lv_pmos ad=0.2603p pd=1.75u as=0.2603p ps=1.75u w=1.37u l=0.35u
X7860 user_project_wrapper_0.IOVSS1 user_project_wrapper_0.sg13g2_IOPadVdd_0.sg13g2_RCClampInverter_noptap_0.out VDD3 user_project_wrapper_0.IOVSS1 sg13_hv_nmos ad=1.408p pd=5.04u as=2.596p ps=5.58u w=4.4u l=0.6u
X7861 user_project_wrapper_0.analog_io[5] a_41476_217444# user_project_wrapper_0.IOVDD1 user_project_wrapper_0.IOVDD1 sg13_hv_pmos ad=3.9294p pd=7.84u as=2.1312p ps=7.3u w=6.66u l=0.6u
X7862 a_210621_325263# a_210417_325263# user_project_wrapper_0.IOVSS1 user_project_wrapper_0.IOVSS1 sg13_lv_nmos ad=0.34p pd=2.68u as=0.19p ps=1.38u w=1u l=0.13u
X7863 a_190584_97917# a_190218_98097# user_project_wrapper_0.IOVSS1 user_project_wrapper_0.IOVSS1 sg13_lv_nmos ad=88.8f pd=0.98u as=0.15245p ps=1.17u w=0.74u l=0.13u
X7864 user_project_wrapper_0.analog_io[32] a_202114_326125# user_project_wrapper_0.IOVSS1 user_project_wrapper_0.IOVSS1 sg13_lv_nmos ad=0.912p pd=5.18u as=0.912p ps=5.18u w=4.8u l=0.13u
X7865 a_190686_324119# a_190757_324686# user_project_wrapper_0.IOVSS1 w_188806_323975# sg13_lv_pmos ad=0.38p pd=2.38u as=0.38p ps=2.38u w=2u l=0.13u
X7866 user_project_wrapper_0.sg13g2_IOPadAnalog_22.padres user_project_wrapper_0.IOVDD4 dpantenna l=0.64u w=4.98u
X7867 user_project_wrapper_0.IOVSS1 a_213870_324142# user_project_wrapper_0.analog_io[35] user_project_wrapper_0.IOVSS1 sg13_lv_nmos ad=0.912p pd=5.18u as=0.912p ps=5.18u w=4.8u l=0.13u
X7868 user_project_wrapper_0.IOVDD4 user_project_wrapper_0.sg13g2_IOPadIOVdd_2.sg13g2_Clamp_N43N43D4R_0.gate user_project_wrapper_0.IOVSS1 user_project_wrapper_0.IOVSS1 sg13_hv_nmos ad=2.596p pd=5.58u as=1.408p ps=5.04u w=4.4u l=0.6u
X7869 user_project_wrapper_0.analog_io[29] a_156244_355624# user_project_wrapper_0.IOVDD4 user_project_wrapper_0.IOVDD4 sg13_hv_pmos ad=3.9294p pd=7.84u as=2.1312p ps=7.3u w=6.66u l=0.6u
X7870 user_project_wrapper_0.IOVDD2 a_258244_41476# user_project_wrapper_0.analog_io[16] user_project_wrapper_0.IOVDD2 sg13_hv_pmos ad=2.1312p pd=7.3u as=3.9294p ps=7.84u w=6.66u l=0.6u
X7871 IOVDD3 a_355624_278644# analog_io[26] IOVDD3 sg13_hv_pmos ad=3.1302p pd=14.26u as=3.9294p ps=7.84u w=6.66u l=0.6u
X7872 user_project_wrapper_0.IOVDD1 user_project_wrapper_0.sg13g2_IOPadIOVdd_1.sg13g2_Clamp_N43N43D4R_0.gate user_project_wrapper_0.IOVSS1 user_project_wrapper_0.IOVSS1 sg13_hv_nmos ad=2.596p pd=5.58u as=1.408p ps=5.04u w=4.4u l=0.6u
X7873 a_269799_100118# a_269543_100118# QDLL_TOP_0.VDD QDLL_TOP_0.VDD sg13_lv_pmos ad=0.34p pd=2.68u as=0.2481p ps=1.56u w=1u l=0.25u
X7874 a_191196_92557# a_190638_90472# user_project_wrapper_0.IOVSS1 rppd l=10u w=1u
X7875 a_87851_125174# a_87673_125210# user_project_wrapper_0.VDD1 user_project_wrapper_0.VDD1 sg13_lv_pmos ad=0.2128p pd=1.5u as=0.3808p ps=2.92u w=1.12u l=0.13u
X7876 user_project_wrapper_0.IOVDD1 a_41476_135844# user_project_wrapper_0.analog_io[1] user_project_wrapper_0.IOVDD1 sg13_hv_pmos ad=2.1312p pd=7.3u as=3.9294p ps=7.84u w=6.66u l=0.6u
X7877 user_project_wrapper_0.analog_io[12] a_176644_29676# user_project_wrapper_0.IOVSS1 user_project_wrapper_0.IOVSS1 sg13_hv_nmos ad=2.596p pd=5.58u as=1.408p ps=5.04u w=4.4u l=0.6u
X7878 a_82859_241546# user_project_wrapper_0.analog_io[4] a_82846_242854# user_project_wrapper_0.VDD1 sg13_lv_pmos ad=0.95p pd=5.38u as=1.7p ps=10.68u w=5u l=0.3u
X7879 a_304995_198817# a_307232_196607# user_project_wrapper_0.IOVSS1 user_project_wrapper_0.IOVSS1 sg13_lv_nmos ad=0.6327p pd=3.71u as=0.6327p ps=3.71u w=3.33u l=0.2u
X7880 user_project_wrapper_0.IOVSS1 user_project_wrapper_0.sg13g2_IOPadVdd_1.sg13g2_RCClampInverter_noptap_0.out user_project_wrapper_0.VDD2 user_project_wrapper_0.IOVSS1 sg13_hv_nmos ad=1.408p pd=5.04u as=2.596p ps=5.58u w=4.4u l=0.6u
X7881 user_project_wrapper_0.IOVDD2 a_197044_41476# user_project_wrapper_0.analog_io[13] user_project_wrapper_0.IOVDD2 sg13_hv_pmos ad=2.1312p pd=7.3u as=3.9294p ps=7.84u w=6.66u l=0.6u
X7882 a_309917_199879# a_309516_194555# VDD3 VDD3 sg13_lv_pmos ad=0.19p pd=1.38u as=0.19p ps=1.38u w=1u l=0.7u
X7883 analog_io[23] analog_io[23] user_project_wrapper_0.IOVSS1 rppd l=2u w=1u
X7884 user_project_wrapper_0.IOVDD4 a_237844_355624# user_project_wrapper_0.analog_io[33] user_project_wrapper_0.IOVDD4 sg13_hv_pmos ad=2.1312p pd=7.3u as=3.9294p ps=7.84u w=6.66u l=0.6u
X7885 user_project_wrapper_0.VDD1 user_project_wrapper_0.sg13g2_IOPadVdd_2.sg13g2_RCClampInverter_noptap_0.out user_project_wrapper_0.IOVSS1 user_project_wrapper_0.IOVSS1 sg13_hv_nmos ad=2.596p pd=5.58u as=1.408p ps=5.04u w=4.4u l=0.6u
X7886 user_project_wrapper_0.analog_io[15] a_190389_101343# user_project_wrapper_0.IOVSS1 user_project_wrapper_0.IOVSS1 sg13_lv_nmos ad=0.1406p pd=1.12u as=0.2516p ps=2.16u w=0.74u l=0.13u
X7887 user_project_wrapper_0.analog_io[30] a_194687_324142# user_project_wrapper_0.IOVSS1 user_project_wrapper_0.IOVSS1 sg13_lv_nmos ad=0.912p pd=5.18u as=0.912p ps=5.18u w=4.8u l=0.13u
X7888 a_301405_39542# a_301735_35456# user_project_wrapper_0.IOVSS1 rppd l=20u w=1u
X7889 IOVDD3 user_project_wrapper_0.sg13g2_IOPadIOVdd_3.sg13g2_RCClampResistor_0.p2 user_project_wrapper_0.sg13g2_IOPadIOVdd_3.sg13g2_Clamp_N43N43D4R_0.gate IOVDD3 sg13_hv_pmos ad=1.33p pd=7.38u as=1.33p ps=7.38u w=7u l=0.5u
X7890 user_project_wrapper_0.IOVSS1 a_369296_176644# analog_io[20] user_project_wrapper_0.IOVSS1 sg13_hv_nmos ad=1.408p pd=5.04u as=2.596p ps=5.58u w=4.4u l=0.6u
X7891 VDD3 a_296625_189595# a_296731_189665# VDD3 sg13_lv_pmos ad=0.2603p pd=1.75u as=0.2603p ps=1.75u w=1.37u l=0.35u
X7892 analog_io[23] a_369296_237844# user_project_wrapper_0.IOVSS1 user_project_wrapper_0.IOVSS1 sg13_hv_nmos ad=2.596p pd=5.58u as=1.408p ps=5.04u w=4.4u l=0.6u
X7893 user_project_wrapper_0.analog_io[33] user_project_wrapper_0.IOVDD4 dpantenna l=1.26u w=27.78u
X7894 analog_io[20] a_355624_156244# IOVDD3 IOVDD3 sg13_hv_pmos ad=3.9294p pd=7.84u as=2.1312p ps=7.3u w=6.66u l=0.6u
X7895 a_190926_326377# a_189184_326377# a_190824_326377# w_188704_326203# sg13_lv_pmos ad=0.38p pd=2.38u as=0.38p ps=2.38u w=2u l=0.13u
X7896 IOVDD3 user_project_wrapper_0.sg13g2_IOPadIOVdd_3.sg13g2_RCClampResistor_0.p2 user_project_wrapper_0.sg13g2_IOPadIOVdd_3.sg13g2_Clamp_N43N43D4R_0.gate IOVDD3 sg13_hv_pmos ad=1.33p pd=7.38u as=1.33p ps=7.38u w=7u l=0.5u
X7897 a_191234_329719# a_190824_329719# user_project_wrapper_0.IOVSS1 w_188700_330166# sg13_lv_pmos ad=0.68p pd=4.68u as=0.68p ps=4.68u w=2u l=0.13u
X7898 VDD3 a_309516_194555# a_309917_194695# VDD3 sg13_lv_pmos ad=0.19p pd=1.38u as=0.19p ps=1.38u w=1u l=0.7u
X7899 a_202114_326125# a_205385_326221# user_project_wrapper_0.IOVSS1 user_project_wrapper_0.IOVSS1 sg13_lv_nmos ad=0.912p pd=5.18u as=0.912p ps=5.18u w=4.8u l=0.13u
X7900 user_project_wrapper_0.sg13g2_IOPadVdd_2.sg13g2_RCClampInverter_noptap_0.out user_project_wrapper_0.sg13g2_IOPadVdd_2.sg13g2_RCClampResistor_0.p2 user_project_wrapper_0.VDD1 user_project_wrapper_0.VDD1 sg13_hv_pmos ad=1.33p pd=7.38u as=1.33p ps=7.38u w=7u l=0.5u
X7901 user_project_wrapper_0.IOVDD1 a_41476_217444# user_project_wrapper_0.analog_io[5] user_project_wrapper_0.IOVDD1 sg13_hv_pmos ad=3.1302p pd=14.26u as=3.9294p ps=7.84u w=6.66u l=0.6u
X7902 VDD3 a_296625_208423# a_296731_208493# VDD3 sg13_lv_pmos ad=0.2603p pd=1.75u as=0.2603p ps=1.75u w=1.37u l=0.35u
X7903 user_project_wrapper_0.IOVSS1 user_project_wrapper_0.sg13g2_IOPadIOVdd_3.sg13g2_Clamp_N43N43D4R_0.gate IOVDD3 user_project_wrapper_0.IOVSS1 sg13_hv_nmos ad=1.408p pd=5.04u as=2.596p ps=5.58u w=4.4u l=0.6u
X7904 user_project_wrapper_0.sg13g2_IOPadVdd_0.sg13g2_RCClampInverter_noptap_0.out user_project_wrapper_0.sg13g2_IOPadVdd_0.sg13g2_RCClampResistor_0.p2 VDD3 VDD3 sg13_hv_pmos ad=1.33p pd=7.38u as=2.38p ps=14.68u w=7u l=0.5u
X7905 user_project_wrapper_0.VDD2 user_project_wrapper_0.sg13g2_IOPadVdd_1.sg13g2_RCClampResistor_0.p2 user_project_wrapper_0.sg13g2_IOPadVdd_1.sg13g2_RCClampInverter_noptap_0.out user_project_wrapper_0.VDD2 sg13_hv_pmos ad=1.33p pd=7.38u as=1.33p ps=7.38u w=7u l=0.5u
X7906 a_301405_39542# a_301075_35456# user_project_wrapper_0.IOVSS1 rppd l=20u w=1u
X7907 user_project_wrapper_0.IOVSS1 a_79038_134366# a_79038_134366# user_project_wrapper_0.IOVSS1 sg13_lv_nmos ad=0.1428p pd=1.52u as=0.1428p ps=1.52u w=0.42u l=0.56u
X7908 a_309917_199879# user_project_wrapper_0.sg13g2_IOPadAnalog_29.padres a_311846_195517# VDD3 sg13_lv_pmos ad=0.24415p pd=1.665u as=0.24415p ps=1.665u w=1.285u l=0.35u
X7909 QDLL_TOP_0.VDD a_271172_100118# QDLL_TOP_0.VOUT QDLL_TOP_0.VDD sg13_lv_pmos ad=0.2128p pd=1.5u as=0.2128p ps=1.5u w=1.12u l=0.13u
X7910 user_project_wrapper_0.IOVSS1 user_project_wrapper_0.sg13g2_IOPadIOVdd_2.sg13g2_Clamp_N43N43D4R_0.gate user_project_wrapper_0.IOVDD4 user_project_wrapper_0.IOVSS1 sg13_hv_nmos ad=1.408p pd=5.04u as=2.596p ps=5.58u w=4.4u l=0.6u
X7911 user_project_wrapper_0.IOVSS1 a_202114_326125# user_project_wrapper_0.analog_io[32] user_project_wrapper_0.IOVSS1 sg13_lv_pmos ad=1.824p pd=9.98u as=1.824p ps=9.98u w=9.6u l=0.13u
X7912 VDD3 user_project_wrapper_0.sg13g2_IOPadVdd_0.sg13g2_RCClampInverter_noptap_0.out user_project_wrapper_0.IOVSS1 user_project_wrapper_0.IOVSS1 sg13_hv_nmos ad=2.596p pd=5.58u as=1.408p ps=5.04u w=4.4u l=0.6u
X7913 user_project_wrapper_0.VDD1 user_project_wrapper_0.sg13g2_IOPadVdd_2.sg13g2_RCClampInverter_noptap_0.out user_project_wrapper_0.IOVSS1 user_project_wrapper_0.IOVSS1 sg13_hv_nmos ad=2.596p pd=5.58u as=1.408p ps=5.04u w=4.4u l=0.6u
C0 a_190638_90472# QDLL_TOP_0.CPIN 0.00327f
C1 a_189921_330851# a_190297_329719# 0.00112f
C2 user_project_wrapper_0.sg13g2_IOPadOut4mA$1_0.c2p user_project_wrapper_0.sg13g2_IOPadAnalog_8.padres 0.01345f
C3 a_210007_327491# a_210417_327491# 0.15379f
C4 a_208367_327491# a_209905_328013# 0.00515f
C5 a_208939_327491# a_210109_328013# 0
C6 a_85211_124842# a_86507_127725# 0.1031f
C7 a_190501_327491# a_190722_328013# 0.05425f
C8 w_188704_326203# a_190297_326377# 0.08768f
C9 a_360372_298765# a_360458_298765# 0.03774f
C10 a_364458_299095# a_364458_298435# 0.02109f
C11 a_210417_328605# a_210417_327491# 0.02058f
C12 a_189184_327491# a_190926_328013# 0.0266f
C13 a_189756_327491# a_191438_327491# 0
C14 w_188806_323975# a_189184_326377# 0.00175f
C15 a_211921_327104# a_211921_326892# 0.01085f
C16 a_83389_128838# a_79025_136081# 0
C17 a_191800_324119# a_189672_324776# 0.20572f
C18 a_209480_328605# a_209905_329327# 0.00962f
C19 TOP_ROILIFNEURON_0.MEM a_210417_327491# 0.00575f
C20 user_project_wrapper_0.VDD1 a_78824_135221# 2.73558f
C21 a_314697_196700# user_project_wrapper_0.sg13g2_IOPadAnalog_29.padres 0.2799f
C22 a_309917_194695# a_311846_195517# 3.21285f
C23 a_89953_129061# a_93400_129062# 0.00115f
C24 a_86507_127725# a_91090_129060# 0.024f
C25 a_82658_129203# a_83389_128838# 0.0025f
C26 a_88274_129426# a_88274_127896# 0
C27 a_78824_128711# a_78220_128106# 0.00173f
C28 a_87434_129426# a_86594_127896# 0
C29 a_83389_129203# a_83796_128838# 0.00441f
C30 a_299425_39542# a_300085_39542# 0.02109f
C31 a_305695_360458# user_project_wrapper_0.IOVDD4 0
C32 user_project_wrapper_0.VDD1 a_79025_129164# 1.75375f
C33 w_207887_327938# a_210109_328013# 0.01287f
C34 a_78220_123062# user_project_wrapper_0.sg13g2_IOPadAnalog_8.padres 0.00116f
C35 a_189524_90558# a_190082_90557# 0.06619f
C36 w_207887_327938# a_210621_328605# 0.08621f
C37 TOP_ROILIFNEURON_0.MEM a_212178_331163# 0.01133f
C38 a_208367_329719# a_208469_327491# 0
C39 a_208939_329719# a_209041_327491# 0
C40 a_208939_325263# a_210109_327491# 0
C41 user_project_wrapper_0.sg13g2_IOPadAnalog_21.padres a_209041_327491# 0.00958f
C42 user_project_wrapper_0.VDD1 a_58798_281249# 1.36886f
C43 TOP_ROILIFNEURON_0.MEM a_211921_325997# 0.00499f
C44 a_187018_328627# a_187364_324106# 0.28931f
C45 a_85875_125209# a_87775_125210# 0
C46 a_87468_125419# a_87571_125210# 0.07171f
C47 user_project_wrapper_0.sg13g2_IOPadIn$1_0.p2c a_83586_127455# 0.00127f
C48 user_project_wrapper_0.sg13g2_IOPadAnalog_22.padres a_209684_327491# 0
C49 a_208367_325263# a_209684_327491# 0
C50 a_208017_327918# a_208367_327491# 0.52312f
C51 a_208939_325263# a_208939_327491# 0.04275f
C52 a_35456_303715# a_35456_303055# 0.02109f
C53 a_79975_360458# user_project_wrapper_0.IOVDD4 0
C54 a_364458_303715# a_364458_303055# 0.02109f
C55 a_360372_303385# a_360458_303385# 0.03774f
C56 a_210621_325263# a_211537_325785# 0.00953f
C57 a_211153_325997# a_211153_325785# 0.01085f
C58 user_project_wrapper_0.sg13g2_IOPadAnalog_22.padres a_209480_328605# 0
C59 a_189184_328605# a_190501_327491# 0
C60 a_190501_328605# a_189184_327491# 0
C61 a_208367_325263# a_209480_328605# 0
C62 a_192354_326677# a_191438_326377# 0.00953f
C63 a_85052_125418# a_84332_125209# 0.25433f
C64 a_209104_331163# a_208939_329719# 0
C65 a_87571_125210# user_project_wrapper_0.VDD1 0.14348f
C66 a_210137_330851# a_210621_328605# 0
C67 TOP_ROILIFNEURON_0.MEM a_192354_328693# 0.00168f
C68 user_project_wrapper_0.IOVDD2 a_301405_35542# 0
C69 a_208171_324119# a_206547_324106# 0.13181f
C70 user_project_wrapper_0.sg13g2_IOPadAnalog_8.padres a_82859_239376# 0.01813f
C71 a_209104_331163# user_project_wrapper_0.sg13g2_IOPadAnalog_21.padres 0
C72 user_project_wrapper_0.sg13g2_IOPadAnalog_22.padres w_207887_326203# 0.02796f
C73 w_207887_326203# a_208367_325263# 0.27272f
C74 w_207883_330166# a_208017_326341# 0.08203f
C75 w_207887_327938# a_208939_325263# 0.01667f
C76 user_project_wrapper_0.sg13g2_IOPadOut4mA$1_1.sg13g2_GateLevelUpInv_noptap$1$1_0.ngate a_58798_281249# 0.04338f
C77 a_364458_76675# a_364458_76015# 0.02109f
C78 a_360372_76345# a_360458_76345# 0.03774f
C79 a_298105_360458# a_298105_360372# 0.03774f
C80 user_project_wrapper_0.sg13g2_IOPadAnalog_30.padres a_202618_56308# 0.0512f
C81 user_project_wrapper_0.IOVDD1 a_35456_297775# 0.01588f
C82 a_78220_128106# a_79038_127856# 0.17968f
C83 a_208017_326341# a_209041_325785# 0.01917f
C84 a_208939_325263# a_209905_325785# 0.01434f
C85 a_208367_325263# a_210621_325263# 0.0018f
C86 w_188806_323975# a_189184_325263# 0.00143f
C87 a_237844_355624# user_project_wrapper_0.IOVDD4 58.9173f
C88 user_project_wrapper_0.VDD1 a_82840_127455# 0.32303f
C89 w_188704_327938# a_189184_329719# 0.06454f
C90 w_188700_330166# a_190501_329719# 0.1007f
C91 w_188704_326203# a_189756_325263# 0.24283f
C92 a_35456_301075# a_35542_301075# 0.03774f
C93 a_39542_301405# a_39542_300745# 0.02109f
C94 user_project_wrapper_0.IOVDD4 a_301735_364458# 0.01567f
C95 a_296731_208493# analog_io[23] 0.25834f
C96 a_364458_79975# IOVDD3 0.01409f
C97 a_78218_138281# a_78218_138195# 0.01716f
C98 TOP_ROILIFNEURON_0.MEM a_211153_327104# 0.00105f
C99 user_project_wrapper_0.analog_io[1] user_project_wrapper_0.sg13g2_IOPadAnalog_9.padres 0.33116f
C100 a_191970_325997# a_189672_324776# 0
C101 a_360372_73705# a_360372_74365# 0.02109f
C102 a_74695_364458# a_75025_360458# 0.03774f
C103 a_74365_360372# a_75025_360372# 0.02109f
C104 a_84598_130577# a_83492_127455# 0.18019f
C105 a_192738_328905# a_192738_328693# 0.01085f
C106 w_207989_323975# a_208920_324155# 0.01274f
C107 a_355784_123661# IOVDD3 1.92793f
C108 a_211153_325785# a_210621_326377# 0
C109 a_211921_325997# a_208855_324776# 0
C110 user_project_wrapper_0.sg13g2_IOPadAnalog_9.padres a_78220_132587# 0.01143f
C111 a_189148_99070# QDLL_TOP_0.VOUT 0
C112 a_305035_360458# a_305365_360458# 0.37213f
C113 a_209104_330851# a_208017_326341# 0.00312f
C114 user_project_wrapper_0.VDD1 a_85591_241383# 0
C115 a_301075_35542# a_301075_35456# 0.03774f
C116 a_186202_326221# a_187018_328627# 1.32746f
C117 user_project_wrapper_0.IOVDD2 a_122095_35456# 0.01409f
C118 user_project_wrapper_0.sg13g2_IOPadOut4mA$1_0.c2p a_58170_179249# 0.12491f
C119 user_project_wrapper_0.sg13g2_IOPadAnalog_8.padres a_79038_136536# 0.01693f
C120 TOP_ROILIFNEURON_0.MEM a_212178_331343# 0.00415f
C121 TOP_ROILIFNEURON_0.MEM a_192738_325570# 0.00567f
C122 user_project_wrapper_0.IOVDD1 a_39542_75025# 0.01881f
C123 a_79025_129571# m2_81563_127336# 0
C124 TOP_ROILIFNEURON_0.MEM a_192738_325358# 0.00436f
C125 a_190824_328605# a_190824_329719# 0.01118f
C126 a_189184_326377# a_190722_327491# 0
C127 a_211153_328013# a_210621_327491# 0.00381f
C128 a_364458_77995# VDD3 0.00158f
C129 a_211921_327798# a_210417_327491# 0
C130 a_209905_327491# a_209684_327491# 0.01614f
C131 a_209041_327491# a_209480_327491# 0
C132 user_project_wrapper_0.VDD2 a_121435_35456# 0.00157f
C133 w_188704_326203# a_190722_325263# 0
C134 a_209684_325263# a_209041_325263# 0
C135 a_209480_325263# a_208469_325263# 0
C136 a_210417_325263# a_211537_325570# 0
C137 a_210007_325263# a_211921_325570# 0
C138 user_project_wrapper_0.IOVDD1 a_39542_304045# 0.01881f
C139 a_82846_241091# a_86970_241383# 0
C140 a_86046_241645# a_85989_241748# 0.00974f
C141 user_project_wrapper_0.sg13g2_IOPadIn$1_1.p2c a_85591_241383# 0.01163f
C142 user_project_wrapper_0.IOVDD1 user_project_wrapper_0.sg13g2_IOPadAnalog_9.padres 1.36563f
C143 user_project_wrapper_0.sg13g2_IOPadAnalog_15.padres a_82859_241546# 0
C144 a_208939_327491# a_208367_327491# 0.83724f
C145 user_project_wrapper_0.IOVDD4 user_project_wrapper_0.analog_io[34] 0.10967p
C146 a_35456_81295# a_35542_81625# 0.03774f
C147 a_364458_299755# a_364458_299095# 0.02109f
C148 a_360372_299425# a_360458_299425# 0.03774f
C149 a_360458_74035# VDD3 0
C150 user_project_wrapper_0.sg13g2_IOPadAnalog_22.padres a_209104_331343# 0.00201f
C151 a_208071_331343# a_208017_327918# 0
C152 a_208920_324155# a_208855_324776# 0.01192f
C153 a_189396_324119# a_189672_324776# 0.03742f
C154 user_project_wrapper_0.VDD1 a_79025_138251# 2.98486f
C155 a_278644_41476# a_286861_41636# 0.01916f
C156 TOP_ROILIFNEURON_0.MEM a_191970_327586# 0.00105f
C157 a_301509_196360# a_296731_189665# 0
C158 a_211921_330241# a_211921_330026# 0.01056f
C159 a_190954_331343# a_190501_329719# 0
C160 a_311189_185546# a_296731_189665# 5.04484f
C161 user_project_wrapper_0.sg13g2_IOPadAnalog_21.padres a_210007_325263# 0
C162 a_296731_208493# a_304889_198885# 0.47277f
C163 user_project_wrapper_0.VDD1 a_88274_129426# 0.49525f
C164 w_207887_327938# a_208367_327491# 0.23718f
C165 user_project_wrapper_0.IOVDD1 a_35542_299425# 0
C166 a_188408_90558# a_188966_90557# 0.06619f
C167 a_191754_330987# a_190954_330987# 0.01566f
C168 a_191901_330987# a_190868_330987# 0.02622f
C169 a_210137_331163# a_210937_330987# 0.01566f
C170 TOP_ROILIFNEURON_0.MEM w_188700_330166# 0.01187f
C171 a_190501_327491# a_188920_324155# 0
C172 a_209684_325263# a_209905_326377# 0.00101f
C173 user_project_wrapper_0.sg13g2_IOPadVdd_2.sg13g2_RCClampResistor_0.p2 user_project_wrapper_0.VDD1 36.1519f
C174 user_project_wrapper_0.VDD1 m2_83010_126180# 0.04368f
C175 a_35542_304045# a_35542_303715# 0.37213f
C176 a_87468_125419# a_87673_125210# 0.03571f
C177 a_85052_125418# a_85155_125209# 0.07171f
C178 a_79038_125686# a_78824_124371# 0
C179 a_78221_125094# a_78221_124694# 0.01732f
C180 w_207887_326203# a_209041_325785# 0.01319f
C181 a_87627_124843# a_87851_125174# 0.04241f
C182 a_78655_360458# user_project_wrapper_0.IOVDD4 0
C183 a_364458_304375# a_364458_303715# 0.02109f
C184 a_360372_304045# a_360458_304045# 0.03774f
C185 a_210417_326377# a_208367_326377# 0.01094f
C186 a_191970_326892# a_191438_326377# 0.00324f
C187 a_190926_326377# a_190824_326377# 0.22366f
C188 a_82667_125418# a_82527_127455# 0
C189 a_209104_330851# a_209480_328605# 0
C190 user_project_wrapper_0.IOVDD2 a_300085_35542# 0
C191 a_87673_125210# user_project_wrapper_0.VDD1 0.20448f
C192 a_207638_331163# user_project_wrapper_0.sg13g2_IOPadAnalog_22.padres 0.01218f
C193 a_121765_39542# a_121765_35542# 0.03774f
C194 a_190954_331163# a_190501_329719# 0
C195 a_360372_77005# a_360458_77005# 0.03774f
C196 a_364458_77335# a_364458_76675# 0.02109f
C197 user_project_wrapper_0.sg13g2_IOPadAnalog_7.padres a_284218_56308# 0.0512f
C198 a_209905_327099# a_208939_327491# 0
C199 w_207883_330166# a_212178_330851# 0.00282f
C200 user_project_wrapper_0.VDD1 a_79038_128322# 0.09487f
C201 a_135844_355624# user_project_wrapper_0.IOVDD4 58.9173f
C202 a_189921_331163# user_project_wrapper_0.sg13g2_IOPadAnalog_19.padres 0
C203 a_39542_302065# a_39542_301405# 0.02109f
C204 a_35456_301735# a_35542_301735# 0.03774f
C205 a_364458_81295# IOVDD3 0.01409f
C206 user_project_wrapper_0.IOVDD2 a_225661_41636# 1.92793f
C207 a_355624_156244# a_355784_164461# 0.01916f
C208 user_project_wrapper_0.sg13g2_IOPadAnalog_19.padres a_190047_324119# 0.00303f
C209 TOP_ROILIFNEURON_0.MEM a_192354_326465# 0.00168f
C210 a_74035_364458# a_74365_360458# 0.03774f
C211 a_73705_360372# a_74365_360372# 0.02109f
C212 a_211537_326677# a_210007_326377# 0
C213 a_190297_325263# a_189672_324776# 0.02344f
C214 a_84598_130577# a_89114_129426# 0.00741f
C215 a_190862_108496# a_191417_108495# 0.06676f
C216 a_304375_360458# a_304705_360458# 0.37213f
C217 w_207887_326203# a_210307_324119# 0.00108f
C218 w_207989_323975# a_209869_324119# 0.10325f
C219 user_project_wrapper_0.sg13g2_IOPadAnalog_9.padres a_78219_134883# 0.00582f
C220 a_190501_329719# a_190926_329327# 0
C221 a_300415_35542# a_300415_35456# 0.03774f
C222 user_project_wrapper_0.VDD1 a_86046_241645# 0.26259f
C223 a_191234_329719# a_192354_330026# 0
C224 a_190824_329719# a_192738_330026# 0
C225 user_project_wrapper_0.VDD1 user_project_wrapper_0.sg13g2_IOPadOut4mA$1_0.sg13g2_GateLevelUpInv_noptap$1$1_0.ngate 0.29858f
C226 a_208939_328605# a_208939_326377# 0
C227 user_project_wrapper_0.sg13g2_IOPadAnalog_19.padres a_189858_329327# 0.00867f
C228 a_189921_330851# a_189756_325263# 0
C229 user_project_wrapper_0.sg13g2_IOPadAnalog_17.padres a_188455_330851# 0.01131f
C230 user_project_wrapper_0.IOVDD2 a_120775_35456# 0.01409f
C231 a_58798_179951# user_project_wrapper_0.VDD1 1.32649f
C232 a_360458_306025# user_project_wrapper_0.sg13g2_IOPadIOVdd_3.sg13g2_RCClampResistor_0.p2 0.03777f
C233 a_79025_129571# user_project_wrapper_0.sg13g2_IOPadAnalog_8.padres 0.08832f
C234 user_project_wrapper_0.analog_io[6] a_56308_243418# 0.05479f
C235 a_75025_360372# user_project_wrapper_0.IOVDD4 0.01881f
C236 user_project_wrapper_0.IOVDD1 a_39542_76345# 0.01881f
C237 TOP_ROILIFNEURON_0.MEM a_209480_325263# 0
C238 a_364458_79315# VDD3 0
C239 analog_io[18] VDD3 19.8007f
C240 a_35456_79975# a_35542_79975# 0.03774f
C241 user_project_wrapper_0.sg13g2_IOPadAnalog_22.padres a_208792_324119# 0.00101f
C242 a_191234_326377# a_191438_327491# 0.002f
C243 a_39542_80305# a_39542_79645# 0.02109f
C244 w_207989_323975# a_209480_325263# 0.0015f
C245 user_project_wrapper_0.VDD2 a_120115_35456# 0
C246 w_207887_326203# a_210417_325263# 0.22627f
C247 a_208367_325263# a_208792_324119# 0
C248 a_208017_327918# a_208579_324119# 0
C249 a_208367_328605# a_209041_328605# 0.01812f
C250 a_35456_79315# a_35456_78655# 0.02109f
C251 a_208939_328605# a_209905_328605# 0.01221f
C252 a_190584_97917# QDLL_TOP_0.CPIN 0.00544f
C253 user_project_wrapper_0.IOVDD1 a_39542_305365# 0.02119f
C254 a_210417_325263# a_210621_325263# 0.43471f
C255 a_85287_241383# a_85989_241383# 0
C256 user_project_wrapper_0.sg13g2_IOPadIn$1_1.p2c a_86046_241645# 0.01567f
C257 a_135844_355624# user_project_wrapper_0.analog_io[28] 25.1197f
C258 a_79025_126994# a_79025_129164# 0
C259 m1_82116_130103# m2_82112_130096# 0.00843f
C260 a_190686_324119# a_187364_324106# 0
C261 a_190047_324119# a_189184_326377# 0
C262 a_209869_324119# a_208855_324776# 0.15708f
C263 a_237844_41476# a_246061_41636# 0.01916f
C264 a_209684_329719# a_208367_328605# 0
C265 a_309516_194555# a_311846_195517# 0.00479f
C266 a_314793_201808# user_project_wrapper_0.sg13g2_IOPadAnalog_29.padres 0.63231f
C267 a_210621_329719# a_211153_330026# 0.00324f
C268 a_304889_199957# a_296625_189595# 0.83533f
C269 a_304196_197873# a_296732_197880# 0.17448f
C270 TOP_ROILIFNEURON_0.MEM a_192738_328013# 0.00699f
C271 a_209480_329719# a_208939_328605# 0
C272 a_78220_128592# a_78220_128192# 0.05035f
C273 a_79038_130026# a_79038_128322# 0.00178f
C274 a_86594_129426# a_87434_129061# 0.00936f
C275 a_300415_364458# a_301075_364458# 0.02109f
C276 a_210307_324119# a_211321_324119# 0
C277 a_210645_324119# a_210983_324119# 0.18331f
C278 a_209869_324119# a_209997_324870# 0.10289f
C279 a_188888_331343# a_189184_325263# 0
C280 a_57810_180219# a_58170_179951# 0.3766f
C281 a_313884_211353# a_296731_208493# 4.65413f
C282 user_project_wrapper_0.sg13g2_IOPadAnalog_26.padres analog_io[25] 0.33115f
C283 w_188704_327938# a_190722_327491# 0
C284 user_project_wrapper_0.IOVDD1 a_35542_300745# 0
C285 a_301575_187719# user_project_wrapper_0.sg13g2_IOPadAnalog_1.padres 0.00258f
C286 a_83050_125173# m2_83010_126180# 0.00103f
C287 a_187294_90558# a_187852_90557# 0.06619f
C288 a_208871_330987# a_209018_330987# 0.17736f
C289 a_82974_125209# user_project_wrapper_0.sg13g2_IOPadIn$1_0.p2c 0.02082f
C290 a_189835_330987# a_188802_330987# 0.02597f
C291 a_189688_330987# a_188888_330987# 0.01602f
C292 a_190954_331163# TOP_ROILIFNEURON_0.MEM 0.00344f
C293 a_209480_325263# a_208855_324776# 0.02344f
C294 a_78824_130881# a_79038_130492# 0.05038f
C295 user_project_wrapper_0.VDD1 m1_82112_127957# 0.02707f
C296 a_85211_124842# a_85875_125209# 0.04165f
C297 a_85435_125173# a_85257_125209# 0.19246f
C298 a_82667_125418# a_82770_125209# 0.07171f
C299 w_188806_323975# a_190757_324686# 0.09549f
C300 w_188704_326203# a_191462_324119# 0
C301 a_77335_360458# user_project_wrapper_0.IOVDD4 0
C302 a_364458_305035# a_364458_304375# 0.02109f
C303 a_360372_304705# a_360458_304705# 0.03774f
C304 QDLL_TOP_0.VOUT a_278644_41476# 25.1197f
C305 a_191970_326892# a_190501_326377# 0
C306 a_85052_125418# user_project_wrapper_0.VDD1 0.61733f
C307 a_87105_130835# a_85127_131750# 0.00311f
C308 user_project_wrapper_0.IOVDD2 a_116815_35456# 0.01409f
C309 QDLL_TOP_0.VDD a_269799_100118# 0.18713f
C310 IOVDD3 a_369296_156244# 0.16358f
C311 a_121105_39542# a_121105_35542# 0.03774f
C312 TOP_ROILIFNEURON_0.MEM a_211170_330987# 0.00533f
C313 a_360372_77665# a_360458_77665# 0.03774f
C314 a_364458_77995# a_364458_77335# 0.02109f
C315 analog_io[20] a_355624_176644# 25.1197f
C316 a_188455_331163# user_project_wrapper_0.sg13g2_IOPadAnalog_17.padres 0.01215f
C317 w_188700_330166# a_192995_330851# 0.00282f
C318 user_project_wrapper_0.VDD2 a_116155_35456# 0
C319 user_project_wrapper_0.VDD1 a_89114_129061# 0
C320 a_35456_302395# a_35542_302395# 0.03774f
C321 a_39542_302725# a_39542_302065# 0.02109f
C322 a_189184_325263# a_190047_324119# 0.00131f
C323 a_188834_326341# a_189756_328605# 0.66928f
C324 user_project_wrapper_0.IOVDD2 a_144061_41636# 1.92793f
C325 a_82433_130212# a_83925_130212# 0.00736f
C326 a_190501_329719# a_191970_329814# 0
C327 a_189858_325785# a_187364_324106# 0
C328 a_190501_325263# a_190824_326377# 0
C329 a_189286_325785# a_189756_326377# 0
C330 a_190824_325263# a_190501_326377# 0
C331 a_190297_325263# a_190297_326377# 0.00495f
C332 a_73375_364458# a_73705_360458# 0.03774f
C333 w_188704_326203# a_190926_326377# 0.01287f
C334 a_189748_108496# a_190304_108495# 0.06657f
C335 a_303715_360458# a_304045_360458# 0.37213f
C336 user_project_wrapper_0.sg13g2_IOPadAnalog_22.padres a_209104_330987# 0
C337 user_project_wrapper_0.sg13g2_IOPadAnalog_9.padres a_79025_137844# 0.26938f
C338 a_189184_327491# a_190297_327491# 0.60144f
C339 a_189756_327491# a_190824_327491# 0.01582f
C340 a_208071_330987# a_208017_327918# 0
C341 a_207985_330987# a_208939_325263# 0
C342 user_project_wrapper_0.sg13g2_IOPadAnalog_17.padres a_190297_328605# 0
C343 a_190501_329719# a_189184_328605# 0
C344 a_189184_329719# a_190501_328605# 0
C345 a_189756_329719# a_190297_328605# 0.0023f
C346 a_188834_326341# a_190824_328605# 0
C347 a_188834_327918# a_189286_329327# 0.00157f
C348 a_189756_325263# a_191234_328605# 0.00184f
C349 a_191751_90558# user_project_wrapper_0.analog_io[13] 0.01131f
C350 a_299755_35542# a_299755_35456# 0.03774f
C351 a_208103_324155# a_209480_326377# 0
C352 a_217444_369296# user_project_wrapper_0.analog_io[32] 9.69836f
C353 a_211153_328013# a_211153_327798# 0.01056f
C354 user_project_wrapper_0.IOVDD2 a_119455_35456# 0.01409f
C355 a_360458_73705# a_360458_73375# 0.37213f
C356 a_35542_79645# user_project_wrapper_0.IOVDD1 0
C357 a_29676_115444# user_project_wrapper_0.analog_io[0] 9.69836f
C358 a_73705_360372# user_project_wrapper_0.IOVDD4 0.01881f
C359 user_project_wrapper_0.IOVDD1 a_39542_77665# 0.01881f
C360 a_209684_328605# a_209905_328013# 0.00101f
C361 a_208367_328605# a_210109_328013# 0
C362 a_364458_80635# VDD3 0.00157f
C363 user_project_wrapper_0.sg13g2_IOPadAnalog_21.padres a_210417_326377# 0
C364 a_83070_130212# user_project_wrapper_0.sg13g2_IOPadIn$1_0.p2c 0.00214f
C365 a_39542_80965# a_39542_80305# 0.02109f
C366 user_project_wrapper_0.VDD2 a_118795_35456# 0.00158f
C367 w_188704_326203# a_191438_325263# 0.08621f
C368 a_35456_80635# a_35542_80635# 0.03774f
C369 a_208367_328605# a_210621_328605# 0.00136f
C370 a_209684_328605# a_210109_329327# 0.05272f
C371 a_82859_242012# user_project_wrapper_0.sg13g2_IOPadAnalog_8.padres 0.08319f
C372 user_project_wrapper_0.sg13g2_IOPadAnalog_14.padres a_82118_239118# 0.1075f
C373 a_190389_101343# QDLL_TOP_0.CPIN 0.02635f
C374 a_192738_326677# a_192738_326465# 0.01085f
C375 a_186431_99272# user_project_wrapper_0.analog_io[13] 0.03466f
C376 a_296626_197740# a_296731_189665# 0.0925f
C377 a_210417_329719# a_211153_330026# 0
C378 a_210007_329719# a_211537_330026# 0
C379 a_304995_198817# a_307232_196607# 11.7696f
C380 a_197044_41476# a_205261_41636# 0.01916f
C381 a_209684_329719# a_208469_329719# 0
C382 user_project_wrapper_0.VDD1 a_35456_74035# 0.00157f
C383 a_258244_29676# user_project_wrapper_0.IOVDD2 0.16358f
C384 a_301186_192011# a_314697_196700# 1.09649f
C385 a_189858_327099# a_188920_324155# 0
C386 a_209638_324119# a_209869_324119# 0.14148f
C387 a_209230_324119# a_209940_324686# 0.00615f
C388 a_208792_324119# a_210307_324119# 0
C389 a_189756_325263# a_190297_325263# 0.22762f
C390 a_189184_325263# a_191234_325263# 0.01189f
C391 user_project_wrapper_0.IOVDD1 a_35542_302065# 0
C392 m2_81766_242000# user_project_wrapper_0.analog_io[4] 0.00469f
C393 user_project_wrapper_0.VDD2 user_project_wrapper_0.sg13g2_IOPadVdd_1.sg13g2_RCClampResistor_0.p2 36.1501f
C394 user_project_wrapper_0.sg13g2_IOPadAnalog_9.padres a_78220_128106# 0.15868f
C395 a_182218_56308# user_project_wrapper_0.analog_io[12] 0.05479f
C396 a_85257_125209# user_project_wrapper_0.sg13g2_IOPadIn$1_0.p2c 0
C397 a_208017_326341# a_208939_328605# 0.66928f
C398 a_208017_327918# a_209684_328605# 0
C399 a_208939_325263# a_208367_328605# 0.39659f
C400 a_78220_130691# a_79025_131334# 0
C401 a_305695_364458# a_305035_364458# 0.02109f
C402 a_192738_325997# a_192738_326465# 0.00322f
C403 a_79038_132196# a_78824_130881# 0
C404 a_79025_131741# a_85127_131750# 0.01321f
C405 analog_io[20] a_369296_176644# 9.69836f
C406 a_82872_125209# a_83490_125209# 0.02258f
C407 a_209684_325263# a_209869_324119# 0.0054f
C408 a_209480_325263# a_209638_324119# 0.00107f
C409 TOP_ROILIFNEURON_0.MEM a_191970_329814# 0.00105f
C410 a_82826_124842# a_85211_124842# 0.19982f
C411 a_81625_360458# user_project_wrapper_0.sg13g2_IOPadVdd_3.sg13g2_RCClampResistor_0.p2 0.03777f
C412 w_188704_326203# a_188988_324119# 0.00159f
C413 a_76015_360458# user_project_wrapper_0.IOVDD4 0
C414 a_189016_101343# QDLL_TOP_0.VDD 0.20521f
C415 a_360372_305365# a_360458_305365# 0.03774f
C416 a_364458_305695# a_364458_305035# 0.02109f
C417 user_project_wrapper_0.VDD1 a_56308_159337# 0
C418 w_188704_326203# a_189756_328605# 0
C419 a_191124_324119# a_192138_324119# 0
C420 a_191462_324119# a_191800_324119# 0.18331f
C421 a_190686_324119# a_190814_324870# 0.10289f
C422 a_58170_179951# a_57810_179517# 0.00209f
C423 user_project_wrapper_0.VDD1 user_project_wrapper_0.analog_io[4] 20.3877f
C424 user_project_wrapper_0.sg13g2_IOPadAnalog_30.padres user_project_wrapper_0.IOVDD2 1.36563f
C425 a_186430_98275# user_project_wrapper_0.analog_io[13] 0.0301f
C426 a_304705_39542# a_305365_39542# 0.02109f
C427 user_project_wrapper_0.IOVDD1 a_41636_205261# 1.92793f
C428 a_79038_126152# user_project_wrapper_0.VDD1 0.09468f
C429 a_83070_130577# a_79025_131741# 0.00227f
C430 a_78220_130291# a_79025_131334# 0
C431 user_project_wrapper_0.IOVDD2 a_115495_35456# 0.01409f
C432 a_92512_129426# a_87105_130835# 0.0715f
C433 a_120445_39542# a_120445_35542# 0.03774f
C434 a_360372_78325# a_360458_78325# 0.03774f
C435 a_364458_78655# a_364458_77995# 0.02109f
C436 a_190297_325263# a_190722_325263# 0.00962f
C437 a_190501_325263# a_190926_325263# 0.05288f
C438 a_209684_325263# a_209480_325263# 0.83518f
C439 user_project_wrapper_0.sg13g2_IOPadAnalog_29.padres VDD3 8.19108f
C440 a_191970_325997# a_191970_325785# 0.01085f
C441 a_191438_325263# a_192354_325785# 0.00953f
C442 user_project_wrapper_0.VDD2 a_114835_35456# 0.00157f
C443 a_35456_303055# a_35542_303055# 0.03774f
C444 a_39542_303385# a_39542_302725# 0.02109f
C445 a_190501_329719# a_188920_324155# 0
C446 a_79025_127401# a_82433_130212# 0.10926f
C447 a_82746_130212# a_83070_130577# 0.05776f
C448 user_project_wrapper_0.sg13g2_IOPadIn$1_2.p2c a_194687_324142# 0.06356f
C449 a_85989_241383# a_82846_243261# 0
C450 a_271172_100118# QDLL_TOP_0.VOUT 0.92972f
C451 a_35542_74035# a_39542_73705# 0.03774f
C452 a_190824_328605# a_191970_328905# 0
C453 a_191438_328605# a_192354_329120# 0.0091f
C454 a_191970_329332# a_191970_329120# 0.01085f
C455 a_188632_108496# a_189190_108495# 0.06619f
C456 a_303055_360458# a_303385_360458# 0.37213f
C457 a_87434_127531# a_85127_131750# 0
C458 a_194193_328627# a_194687_324142# 0.09942f
C459 a_189524_90558# user_project_wrapper_0.analog_io[13] 0.01131f
C460 a_209104_330987# a_209104_330851# 0.29305f
C461 user_project_wrapper_0.IOVDD2 a_118135_35456# 0.01409f
C462 user_project_wrapper_0.sg13g2_IOPadOut4mA$1_1.c2p a_57810_281517# 0.02529f
C463 a_35542_80965# user_project_wrapper_0.IOVDD1 0
C464 TOP_ROILIFNEURON_0.MEM a_211153_326465# 0.00105f
C465 user_project_wrapper_0.IOVDD1 a_39542_78985# 0.01881f
C466 user_project_wrapper_0.sg13g2_IOPadAnalog_3.padres a_343292_182218# 0.0512f
C467 a_208367_328605# a_208367_327491# 0.48499f
C468 a_208939_328605# a_209684_327491# 0.00156f
C469 a_209684_328605# a_208939_327491# 0.00132f
C470 w_207887_326203# a_211921_326465# 0.0018f
C471 w_188704_326203# a_190501_325263# 0.10247f
C472 a_84598_130577# user_project_wrapper_0.sg13g2_IOPadIn$1_0.p2c 0
C473 user_project_wrapper_0.VDD2 a_117475_35456# 0.00153f
C474 a_208939_328605# a_209480_328605# 0.203f
C475 a_191438_325263# a_191800_324119# 0.00336f
C476 TOP_ROILIFNEURON_0.MEM a_211537_329814# 0.00168f
C477 a_191970_328013# a_191970_327798# 0.01056f
C478 a_360372_300085# a_360458_300415# 0.03774f
C479 w_207887_327938# a_209684_328605# 0.10225f
C480 w_207887_326203# a_208939_328605# 0
C481 a_210417_326377# a_210621_326377# 0.43471f
C482 a_208103_324155# a_209041_325263# 0.00407f
C483 a_156244_41476# a_164461_41636# 0.01916f
C484 a_176644_29676# user_project_wrapper_0.IOVDD2 0.16358f
C485 a_296625_208423# a_304196_200821# 8.39194f
C486 a_296626_197740# a_307232_196607# 0
C487 a_301186_192011# a_304889_199957# 0.10617f
C488 user_project_wrapper_0.VDD1 a_35456_75355# 0
C489 a_210417_329719# a_210621_329719# 0.43471f
C490 a_301940_196388# a_304995_198817# 0.17356f
C491 a_208171_324119# a_208579_324119# 0.15212f
C492 a_187364_324106# a_188920_324155# 0.24725f
C493 a_206547_324106# a_205385_326221# 0.02049f
C494 a_208071_331343# a_207985_330987# 0.00565f
C495 user_project_wrapper_0.sg13g2_IOPadAnalog_8.padres a_82846_242854# 0.03366f
C496 user_project_wrapper_0.IOVDD1 a_35542_303385# 0
C497 a_56308_121018# user_project_wrapper_0.sg13g2_IOPadAnalog_8.padres 0.0512f
C498 a_78824_126541# m1_81567_127343# 0
C499 a_190721_331163# a_190954_331163# 0.01498f
C500 a_82667_125418# user_project_wrapper_0.sg13g2_IOPadIn$1_0.p2c 0.20352f
C501 a_79025_133504# a_79038_132196# 0.71261f
C502 a_78824_133051# a_79025_131741# 0
C503 a_211537_326465# a_210621_326377# 0
C504 a_191438_325263# a_191970_326677# 0
C505 a_79038_132662# a_78220_130691# 0
C506 a_210137_330851# a_209684_328605# 0
C507 a_80965_360458# a_80965_360372# 0.03774f
C508 a_89953_129061# a_86507_129255# 0
C509 a_190287_102497# QDLL_TOP_0.VDD 0.01446f
C510 a_191438_328605# a_191970_328013# 0
C511 w_188700_330166# a_190926_329719# 0
C512 a_189609_324119# a_191124_324119# 0
C513 a_190047_324119# a_190757_324686# 0.00615f
C514 a_190455_324119# a_190686_324119# 0.14148f
C515 a_314697_196700# a_315347_192648# 1.13945f
C516 user_project_wrapper_0.IOVDD1 user_project_wrapper_0.analog_io[1] 0.10967p
C517 a_304045_39542# a_304705_39542# 0.02109f
C518 user_project_wrapper_0.IOVDD2 a_114175_35456# 0.01409f
C519 a_79025_125231# a_79025_133911# 0.0973f
C520 a_208367_326377# a_209480_326377# 0.62905f
C521 a_208939_326377# a_210007_326377# 0.01463f
C522 a_119785_39542# a_119785_35542# 0.03774f
C523 a_83492_127455# a_83796_129203# 0.00298f
C524 a_207638_331163# a_207638_330987# 0.03126f
C525 a_364458_79315# a_364458_78655# 0.02109f
C526 a_360372_78985# a_360458_78985# 0.03774f
C527 user_project_wrapper_0.analog_io[13] a_190862_108496# 0.0113f
C528 a_296625_189595# VDD3 30.1096f
C529 a_191438_325263# a_191970_325997# 0.002f
C530 a_190926_327099# a_189756_327491# 0
C531 a_190722_327099# a_189184_327491# 0
C532 a_186202_326221# a_188920_324155# 0
C533 a_189184_329719# a_191438_329719# 0.00122f
C534 a_190501_329719# a_190926_330241# 0.00495f
C535 a_57810_179517# a_58170_179249# 0.3766f
C536 a_300415_364458# user_project_wrapper_0.IOVDD4 0.01555f
C537 a_35542_74695# a_39542_74365# 0.03774f
C538 a_269799_100118# a_269931_100182# 0.38927f
C539 a_87775_125210# a_86507_129255# 0
C540 user_project_wrapper_0.VDD1 user_project_wrapper_0.sg13g2_IOPadAnalog_28.padres 1.74533f
C541 a_360458_301405# IOVDD3 0
C542 a_187518_108496# a_188074_108495# 0.06657f
C543 user_project_wrapper_0.IOVDD1 a_41476_115444# 58.9173f
C544 a_190501_328605# a_192354_329120# 0
C545 a_190297_328605# a_191970_329120# 0
C546 a_302395_360458# a_302725_360458# 0.37213f
C547 a_116485_39542# a_116485_35542# 0.03774f
C548 a_190954_330851# a_190297_328605# 0
C549 a_187294_90558# user_project_wrapper_0.analog_io[13] 0.04263f
C550 a_86507_127725# a_91090_127530# 0
C551 user_project_wrapper_0.sg13g2_IOPadAnalog_0.padres VDD3 1.74533f
C552 a_210051_330987# a_212178_330987# 0.00257f
C553 a_188455_331163# a_188455_331343# 0.02961f
C554 a_306025_360458# user_project_wrapper_0.sg13g2_IOPadIOVdd_2.sg13g2_RCClampResistor_0.p2 0.03777f
C555 a_208103_324155# a_210417_327491# 0
C556 a_190824_325263# a_191124_324119# 0.00706f
C557 a_191438_327491# a_192738_328225# 0
C558 TOP_ROILIFNEURON_0.MEM a_211153_330026# 0.00113f
C559 a_360372_300745# a_360458_301075# 0.03774f
C560 w_207883_330166# a_209905_329719# 0
C561 a_190319_102855# QDLL_TOP_0.CPIN 0.23746f
C562 a_79038_125686# user_project_wrapper_0.sg13g2_IOPadAnalog_9.padres 0
C563 user_project_wrapper_0.VDD1 a_35456_76675# 0.00153f
C564 a_296626_197740# a_301940_196388# 1.94953f
C565 a_296625_208423# a_304090_197941# 0.94853f
C566 a_301186_192011# a_314793_201808# 0.21319f
C567 user_project_wrapper_0.sg13g2_IOPadAnalog_17.padres a_190824_327491# 0
C568 user_project_wrapper_0.sg13g2_IOPadAnalog_19.padres a_189756_327491# 0.2146f
C569 user_project_wrapper_0.IOVDD1 user_project_wrapper_0.analog_io[5] 0.10967p
C570 a_90579_127530# a_91090_127530# 0.00441f
C571 a_89953_127531# a_92512_127531# 0.00441f
C572 a_84332_125209# a_89114_127531# 0
C573 a_188888_331163# a_189688_330987# 0.01602f
C574 a_188920_324155# a_190926_327491# 0
C575 a_208367_329719# a_210621_329719# 0.00122f
C576 a_35456_298435# a_35542_298765# 0.03774f
C577 a_360458_75025# IOVDD3 0
C578 a_82645_242401# user_project_wrapper_0.analog_io[4] 0.00235f
C579 a_82846_242854# a_82118_242359# 0.00232f
C580 a_79038_134366# a_78824_133051# 0
C581 a_78219_134797# a_79025_133504# 0
C582 a_79025_138251# a_79038_130492# 0
C583 a_79025_136081# a_79025_131741# 0.37242f
C584 a_87434_129426# a_86507_129255# 0.48669f
C585 a_78824_128711# a_79025_131334# 0
C586 a_78824_126541# a_78221_125094# 0.00173f
C587 a_79025_126994# a_79038_126152# 0.70614f
C588 a_80305_360458# a_80305_360372# 0.03774f
C589 a_82658_129203# a_79025_131741# 0.00104f
C590 user_project_wrapper_0.sg13g2_IOPadAnalog_19.padres user_project_wrapper_0.IOVDD4 1.36563f
C591 user_project_wrapper_0.sg13g2_IOPadVdd_2.sg13g2_RCClampInverter_noptap_0.out user_project_wrapper_0.IOVDD1 49.206f
C592 a_188988_324119# a_189396_324119# 0.15212f
C593 a_189729_101343# user_project_wrapper_0.sg13g2_IOPadAnalog_6.padres 0.00117f
C594 analog_io[20] user_project_wrapper_0.sg13g2_IOPadAnalog_3.padres 0.33115f
C595 a_303385_39542# a_304045_39542# 0.02109f
C596 a_82746_130212# a_79025_136081# 0.00102f
C597 a_83079_128838# a_83070_130577# 0
C598 a_82348_128838# a_82433_130212# 0.00112f
C599 a_86594_129426# a_87105_130835# 0.0076f
C600 a_79025_129164# a_79025_127401# 0.09828f
C601 a_119125_39542# a_119125_35542# 0.03774f
C602 a_360372_79645# a_360458_79645# 0.03774f
C603 a_364458_79975# a_364458_79315# 0.02109f
C604 a_189729_99046# user_project_wrapper_0.analog_io[14] 0.01277f
C605 a_190297_325263# a_191438_325263# 0.00342f
C606 a_190824_325263# a_190926_325785# 0.22366f
C607 a_268697_100118# a_268967_100118# 0.26306f
C608 a_301423_202742# VDD3 1.8093f
C609 a_188184_101343# QDLL_TOP_0.VOUT 0.00847f
C610 a_191970_326892# a_191438_327491# 0
C611 user_project_wrapper_0.analog_io[13] a_188632_108496# 0.0113f
C612 IOVDD3 a_360458_298105# 0
C613 a_208017_327918# a_206201_328627# 0
C614 user_project_wrapper_0.sg13g2_IOPadIOVdd_0.sg13g2_RCClampResistor_0.p2 a_306025_35542# 0.03777f
C615 a_189756_326377# a_189184_327491# 0.01078f
C616 a_189184_326377# a_189756_327491# 0.00811f
C617 a_188834_327918# a_189286_330241# 0.01465f
C618 a_299095_364458# user_project_wrapper_0.IOVDD4 0.01447f
C619 a_35542_75355# a_39542_75025# 0.03774f
C620 a_88291_125210# a_86507_129255# 0.00276f
C621 a_268967_100118# a_269079_100182# 0.55452f
C622 a_360458_302725# IOVDD3 0
C623 a_190297_328605# a_189286_329327# 0
C624 a_190824_328605# a_191234_328605# 0.15379f
C625 a_189184_328605# a_190722_329327# 0.01977f
C626 a_190501_328605# a_189858_329327# 0
C627 user_project_wrapper_0.IOVDD1 a_29676_258244# 0.16358f
C628 a_301735_360458# a_302065_360458# 0.37213f
C629 a_210621_328605# a_211153_328693# 0.002f
C630 a_115825_39542# a_115825_35542# 0.03774f
C631 user_project_wrapper_0.sg13g2_IOPadAnalog_19.padres user_project_wrapper_0.analog_io[28] 0.33127f
C632 user_project_wrapper_0.sg13g2_IOPadIn$1_2.sg13g2_LevelDown_noptap$1_0.sg13g2_SecondaryProtection$1$1_0.core user_project_wrapper_0.IOVDD4 1.37355f
C633 a_35542_304375# a_39542_304045# 0.03774f
C634 a_207985_330987# a_208071_330987# 0.05224f
C635 a_208103_324155# a_208469_327491# 0
C636 TOP_ROILIFNEURON_0.MEM a_190501_327491# 0
C637 a_79025_127401# a_82840_127455# 0.11042f
C638 a_210621_329719# a_210417_328605# 0.002f
C639 a_208017_326341# a_210007_326377# 0
C640 user_project_wrapper_0.IOVDD2 user_project_wrapper_0.analog_io[16] 0.10967p
C641 user_project_wrapper_0.sg13g2_IOPadAnalog_21.padres a_209480_326377# 0.00854f
C642 user_project_wrapper_0.sg13g2_IOPadIn$1_2.sg13g2_LevelDown_noptap$1_0.sg13g2_SecondaryProtection$1$1_0.core a_200038_338690# 0.37988f
C643 a_304889_198885# a_304889_199957# 0.84411f
C644 user_project_wrapper_0.sg13g2_IOPadIn$1_2.p2c a_189756_326377# 0.00124f
C645 TOP_ROILIFNEURON_0.MEM a_210621_329719# 0.12104f
C646 a_79025_124824# a_79038_123982# 0.70614f
C647 user_project_wrapper_0.VDD2 a_202618_56308# -0
C648 a_360372_301405# a_360458_301735# 0.03774f
C649 a_191970_327104# a_191970_326892# 0.01085f
C650 a_35542_79975# user_project_wrapper_0.VDD1 0
C651 a_355624_217444# IOVDD3 58.9173f
C652 user_project_wrapper_0.VDD1 a_35456_77995# 0.00158f
C653 a_210109_326377# a_208939_326377# 0
C654 a_209905_326377# a_208367_326377# 0.00427f
C655 a_189184_325263# a_189756_327491# 0.00125f
C656 a_211921_326892# a_210007_326377# 0
C657 user_project_wrapper_0.IOVDD2 a_305365_39542# 0.02119f
C658 a_299755_364458# a_300415_364458# 0.02109f
C659 a_88274_127896# a_89114_127531# 0.00441f
C660 a_87434_127896# a_88274_127531# 0.01332f
C661 a_82527_127455# a_83164_127455# 0.00125f
C662 a_83164_127820# a_83586_127455# 0.00441f
C663 a_84332_125209# a_91911_127530# 0.00446f
C664 user_project_wrapper_0.sg13g2_IOPadAnalog_22.padres a_209041_330241# 0
C665 a_35456_299095# a_35542_299425# 0.03774f
C666 a_208017_327918# a_208469_330241# 0.01465f
C667 a_208367_329719# a_210417_329719# 0.01121f
C668 a_360458_76345# IOVDD3 0
C669 a_211170_330851# a_211921_330453# 0.00195f
C670 a_369296_258244# a_369456_266461# 0.01778f
C671 a_79025_138251# a_79038_132196# 0
C672 a_78824_135221# a_78219_134797# 0.00173f
C673 a_79025_136081# a_79038_134366# 0
C674 a_79645_360458# a_79645_360372# 0.03774f
C675 a_79025_135674# a_79038_134832# 0.70614f
C676 TOP_ROILIFNEURON_0.MEM a_194279_327536# 0.02949f
C677 a_83389_129203# a_79025_133911# 0.07158f
C678 a_89953_129061# a_90579_129060# 0.04426f
C679 VDD3 a_343292_284218# 0
C680 w_188700_330166# a_190722_330241# 0.01266f
C681 a_314793_197200# analog_io[20] 0.44322f
C682 w_207887_327938# a_206201_328627# 0
C683 a_258244_41476# user_project_wrapper_0.analog_io[16] 25.1197f
C684 a_189016_101343# a_189148_101407# 0.38927f
C685 a_186431_100948# user_project_wrapper_0.sg13g2_IOPadAnalog_6.padres 0.27323f
C686 a_302725_39542# a_303385_39542# 0.02109f
C687 a_314793_201808# a_315347_192648# 11.1636f
C688 a_79025_127401# a_79025_138251# 0.02117f
C689 user_project_wrapper_0.sg13g2_IOPadAnalog_1.padres a_304889_199957# 0.05369f
C690 a_190824_326377# a_191438_326377# 0.01253f
C691 m2_81563_127336# a_79025_131741# 0.0245f
C692 a_79025_129571# a_79025_125231# 0.03593f
C693 a_83492_130212# a_82433_130212# 0.02469f
C694 a_118465_39542# a_118465_35542# 0.03774f
C695 user_project_wrapper_0.sg13g2_IOPadAnalog_30.padres user_project_wrapper_0.analog_io[13] 0.33115f
C696 a_364458_80635# a_364458_79975# 0.02109f
C697 a_360372_80305# a_360458_80305# 0.03774f
C698 a_187914_99087# a_188184_99046# 0.26306f
C699 a_190501_325263# a_190297_325263# 0.83518f
C700 a_301186_192011# VDD3 1.81091f
C701 IOVDD3 a_360458_299425# 0
C702 a_209684_326377# a_210007_327491# 0
C703 a_209480_326377# a_209480_327491# 0.03801f
C704 a_210007_326377# a_209684_327491# 0
C705 a_190501_328605# a_190722_329719# 0
C706 a_191987_330851# a_191438_329719# 0
C707 a_188834_327918# a_190824_329719# 0
C708 a_189756_325263# a_190297_329719# 0.0176f
C709 a_35542_76015# a_39542_75685# 0.03774f
C710 a_297775_364458# user_project_wrapper_0.IOVDD4 0.01588f
C711 a_208103_324155# a_209480_325263# 0.00256f
C712 user_project_wrapper_0.sg13g2_IOPadIn$1_2.p2c a_208920_324155# 0.08237f
C713 user_project_wrapper_0.analog_io[30] user_project_wrapper_0.analog_io[32] 0.32231f
C714 TOP_ROILIFNEURON_0.MEM a_209684_326377# 0
C715 m2_82112_130096# a_79025_125231# 0
C716 a_87571_125210# a_86507_127725# 0.01682f
C717 a_360458_304045# IOVDD3 0
C718 a_190501_327491# a_190926_327491# 0.05288f
C719 a_190297_327491# a_190722_327491# 0.00962f
C720 a_301075_360458# a_301405_360458# 0.37213f
C721 w_207887_326203# a_210007_326377# 0.11544f
C722 user_project_wrapper_0.IOVDD1 user_project_wrapper_0.uo_PAD[3] 26.991f
C723 user_project_wrapper_0.analog_io[14] user_project_wrapper_0.VDD2 19.8008f
C724 user_project_wrapper_0.VDD1 a_85127_131750# 0.9955f
C725 a_210007_328605# a_211537_328905# 0
C726 a_115165_39542# a_115165_35542# 0.03774f
C727 a_208367_328605# a_209684_328605# 0.72543f
C728 a_83492_127455# a_82527_127455# 0.04189f
C729 a_89953_129061# a_89953_127531# 0.05528f
C730 a_35542_305035# a_39542_304705# 0.03774f
C731 TOP_ROILIFNEURON_0.MEM a_211153_328905# 0.00105f
C732 w_188704_327938# a_189756_327491# 0.21189f
C733 a_190389_99046# a_190319_97955# 0
C734 user_project_wrapper_0.analog_io[15] user_project_wrapper_0.VDD2 19.8008f
C735 w_207887_327938# a_211537_328693# 0.0018f
C736 a_191751_90558# a_192309_92557# 0
C737 user_project_wrapper_0.sg13g2_IOPadAnalog_22.padres a_206547_324106# 0
C738 a_79025_127401# a_79038_128322# 0.00145f
C739 a_87105_130835# a_88274_129061# 0
C740 a_210417_329719# a_210417_328605# 0.03297f
C741 a_208367_325263# a_206547_324106# 0.00805f
C742 a_209684_329719# a_209905_329327# 0
C743 user_project_wrapper_0.VDD1 a_83070_130577# 0.45561f
C744 a_296731_208493# a_296732_200582# 0.19757f
C745 user_project_wrapper_0.sg13g2_IOPadOut4mA$1_1.c2p a_82846_242854# 0
C746 a_189756_325263# a_189672_324776# 0.00611f
C747 a_188834_326341# a_191438_326377# 0
C748 a_189286_325785# a_188920_324155# 0
C749 TOP_ROILIFNEURON_0.MEM a_210417_329719# 0.00574f
C750 user_project_wrapper_0.sg13g2_IOPadAnalog_19.padres a_191234_326377# 0
C751 a_360372_302065# a_360458_302395# 0.03774f
C752 w_207887_326203# a_213462_327536# 0
C753 w_207883_330166# a_209041_330241# 0.01323f
C754 a_208017_327918# a_208469_328605# 0.01947f
C755 a_189286_328605# a_189184_327491# 0.00181f
C756 a_189858_328605# a_189756_327491# 0
C757 a_35542_81295# user_project_wrapper_0.VDD1 0
C758 a_210621_326377# a_209480_326377# 0.00342f
C759 a_87627_124843# a_88274_127531# 0
C760 a_85977_125209# a_84332_125209# 0.02951f
C761 a_210109_327099# a_210007_326377# 0.1023f
C762 user_project_wrapper_0.IOVDD2 a_304045_39542# 0.01881f
C763 a_298765_39542# a_299095_35542# 0.03774f
C764 a_298435_35456# a_299095_35456# 0.02109f
C765 a_360372_75025# a_360458_75355# 0.03774f
C766 a_299095_364458# a_299755_364458# 0.02109f
C767 a_89114_127896# a_84332_125209# 0.00375f
C768 user_project_wrapper_0.sg13g2_IOPadAnalog_22.padres a_209684_329719# 0
C769 user_project_wrapper_0.sg13g2_IOPadAnalog_21.padres a_209041_325263# 0.00834f
C770 user_project_wrapper_0.VDD1 a_89114_127531# 0
C771 a_208367_325263# a_209684_329719# 0
C772 a_35456_299755# a_35542_300085# 0.03774f
C773 a_190389_99046# QDLL_TOP_0.VDD 2.59451f
C774 user_project_wrapper_0.IOVDD4 a_304045_360372# 0.01881f
C775 a_360458_77665# IOVDD3 0
C776 user_project_wrapper_0.sg13g2_IOPadIn$1_2.p2c a_189737_324155# 0.08103f
C777 a_78219_135283# a_79025_136081# 0
C778 a_78985_360458# a_78985_360372# 0.03774f
C779 a_78220_128592# a_78824_130881# 0.00173f
C780 a_83079_128838# a_79025_136081# 0.09751f
C781 a_190722_325263# a_189672_324776# 0
C782 a_79025_129571# a_79025_133911# 0.48391f
C783 a_83079_128838# a_82658_129203# 0.02385f
C784 a_88274_129426# a_86507_127725# 0
C785 a_89114_129426# a_83492_127455# 0.01632f
C786 w_188700_330166# a_194193_328627# 0
C787 a_188184_101343# a_188296_101407# 0.55452f
C788 a_302065_39542# a_302725_39542# 0.02109f
C789 a_360458_73375# IOVDD3 0
C790 a_189184_326377# a_191234_326377# 0.01094f
C791 a_190501_326377# a_190824_326377# 0.35443f
C792 user_project_wrapper_0.sg13g2_IOPadAnalog_8.padres a_79025_131741# 0.12988f
C793 a_208469_327491# a_208367_326377# 0
C794 a_117805_39542# a_117805_35542# 0.03774f
C795 m2_82112_130096# a_79025_133911# 0
C796 m1_82116_130103# a_79025_131741# 0
C797 a_84598_130577# a_83398_130212# 0
C798 user_project_wrapper_0.sg13g2_IOPadAnalog_19.padres a_189756_329719# 0.19093f
C799 a_360372_80965# a_360458_80965# 0.03774f
C800 a_364458_81295# a_364458_80635# 0.02109f
C801 user_project_wrapper_0.sg13g2_IOPadAnalog_19.padres user_project_wrapper_0.sg13g2_IOPadAnalog_17.padres 16.0312f
C802 a_211537_326677# a_211537_326465# 0.01085f
C803 a_360458_75685# VDD3 0
C804 a_369296_197044# IOVDD3 0.16358f
C805 user_project_wrapper_0.analog_io[30] a_194279_327536# 0.17614f
C806 a_192826_90558# QDLL_TOP_0.CPIN 0.15064f
C807 user_project_wrapper_0.sg13g2_IOPadIn$1_2.p2c a_209869_324119# 0.00448f
C808 a_82118_240839# a_82118_239118# 0.01797f
C809 a_35542_76675# a_39542_76345# 0.03774f
C810 m1_81998_130507# a_79025_125231# 0.01518f
C811 m1_82112_127957# a_79025_127401# 0.01284f
C812 a_87673_125210# a_86507_127725# 0.07361f
C813 a_360458_305365# IOVDD3 0
C814 a_360372_298105# a_360458_298435# 0.03774f
C815 m5_6440_9800# m6_6440_9800# 0.66064p
C816 a_83796_129203# user_project_wrapper_0.sg13g2_IOPadIn$1_0.p2c 0.00841f
C817 a_300415_360458# a_300745_360458# 0.37213f
C818 w_188704_326203# a_191438_326377# 0.08621f
C819 a_343292_202618# analog_io[22] 0.05479f
C820 a_83389_128838# a_79025_133911# 0.01283f
C821 a_86594_129061# a_85127_131750# 0.02398f
C822 user_project_wrapper_0.VDD1 a_78824_133051# 2.73558f
C823 a_209041_325785# a_206547_324106# 0
C824 a_208469_325785# a_208939_326377# 0
C825 a_114505_39542# a_114505_35542# 0.03774f
C826 a_210007_328605# a_211153_329120# 0
C827 a_209480_328605# a_211537_329120# 0
C828 a_93461_128591# a_93400_129062# 0.0048f
C829 a_93204_129062# a_93298_129062# 0.08985f
C830 TOP_ROILIFNEURON_0.MEM a_211537_328225# 0.00168f
C831 a_369296_217444# a_369456_225661# 0.01778f
C832 user_project_wrapper_0.VDD1 a_92512_129426# 0.38151f
C833 a_35542_305695# a_39542_305365# 0.03774f
C834 a_82872_125209# a_79025_125231# 0.00359f
C835 TOP_ROILIFNEURON_0.MEM a_211921_329332# 0.00497f
C836 a_182931_326125# user_project_wrapper_0.analog_io[27] 18.3394f
C837 a_315347_192648# VDD3 0.01827f
C838 VDD3 analog_io[23] 97.6891f
C839 w_207887_327938# a_208469_328605# 0.01325f
C840 a_190638_90558# a_191196_92557# 0
C841 a_186430_102197# user_project_wrapper_0.analog_io[13] 0.02786f
C842 TOP_ROILIFNEURON_0.MEM a_191987_330987# 0.00533f
C843 a_188802_330987# a_189921_330987# 0.05294f
C844 a_189756_325263# a_190297_326377# 0.02261f
C845 a_188834_326341# a_190501_326377# 0
C846 a_188834_327918# a_190824_326377# 0
C847 user_project_wrapper_0.sg13g2_IOPadAnalog_17.padres a_189184_326377# 0.18129f
C848 a_209904_331163# a_209684_329719# 0
C849 w_207887_326203# a_209905_325263# 0
C850 a_92512_129426# user_project_wrapper_0.sg13g2_IOPadIn$1_1.p2c 0.00207f
C851 a_360372_302725# a_360458_303055# 0.03774f
C852 a_210109_325785# a_210109_325263# 0
C853 w_207883_330166# a_209684_329719# 0.1007f
C854 a_208939_325263# a_209905_329327# 0.00101f
C855 a_208017_326341# a_209041_329327# 0.00157f
C856 a_208939_329719# a_208469_329327# 0
C857 a_191234_328605# a_191234_327491# 0.02058f
C858 a_355784_246061# IOVDD3 1.92793f
C859 a_82770_125209# a_82527_127455# 0
C860 a_87851_125174# a_84332_125209# 0
C861 a_79038_123982# user_project_wrapper_0.VDD1 0.09466f
C862 user_project_wrapper_0.IOVDD2 a_302725_39542# 0.02119f
C863 a_210307_324119# a_206547_324106# 0
C864 user_project_wrapper_0.analog_io[14] a_217444_41476# 25.1197f
C865 a_209638_324119# a_209684_326377# 0
C866 user_project_wrapper_0.analog_io[7] a_85989_241383# 0
C867 user_project_wrapper_0.IOVDD1 a_29676_115444# 0.16358f
C868 a_298105_39542# a_298435_35542# 0.03774f
C869 a_297775_35456# a_298435_35456# 0.02109f
C870 TOP_ROILIFNEURON_0.MEM a_190501_329719# 0
C871 a_188802_330987# a_188834_326341# 0
C872 a_360372_75685# a_360458_76015# 0.03774f
C873 a_298435_364458# a_299095_364458# 0.02109f
C874 a_188455_330987# user_project_wrapper_0.sg13g2_IOPadAnalog_17.padres 0.01059f
C875 a_88274_127896# a_89114_127896# 0.05839f
C876 user_project_wrapper_0.sg13g2_IOPadAnalog_16.padres user_project_wrapper_0.IOVDD4 1.36563f
C877 a_57810_180219# user_project_wrapper_0.sg13g2_IOPadOut4mA$1_0.c2p 0.01733f
C878 user_project_wrapper_0.VDD1 a_91911_127530# 0.28624f
C879 a_189286_326377# a_189184_327491# 0.02855f
C880 a_189858_326377# a_189756_327491# 0.02675f
C881 user_project_wrapper_0.IOVDD4 a_302725_360372# 0.02119f
C882 a_35456_300415# a_35542_300745# 0.03774f
C883 a_186431_99272# QDLL_TOP_0.VDD 0.00296f
C884 user_project_wrapper_0.sg13g2_IOPadIn$1_2.p2c a_190686_324119# 0.02188f
C885 a_360458_78985# IOVDD3 0
C886 a_209104_330851# a_209684_329719# 0.00107f
C887 a_78218_138195# a_78219_135283# 0.007f
C888 a_79025_138251# a_79038_137002# 0.01018f
C889 a_78824_137391# a_78219_136982# 0.00113f
C890 a_78325_360458# a_78325_360372# 0.03774f
C891 a_190490_98199# QDLL_TOP_0.CPIN 0.10061f
C892 a_210007_325263# a_208939_326377# 0
C893 a_191970_325785# a_189672_324776# 0
C894 a_209480_325263# a_208367_326377# 0.00184f
C895 a_209684_325263# a_209684_326377# 0.00874f
C896 a_82348_128838# a_79025_138251# 0
C897 a_75355_364458# a_75355_360458# 0.03774f
C898 w_207887_326203# a_210109_326377# 0.01287f
C899 a_208367_325263# a_208939_325263# 0.97501f
C900 a_286861_369456# a_278644_369296# 0.01778f
C901 user_project_wrapper_0.sg13g2_IOPadAnalog_22.padres a_208939_325263# 0.00455f
C902 a_304889_198885# VDD3 0.20574f
C903 user_project_wrapper_0.sg13g2_IOPadAnalog_9.padres a_79025_131334# 0.32292f
C904 a_185968_102197# a_186431_100948# 0.00216f
C905 a_91911_127530# user_project_wrapper_0.sg13g2_IOPadIn$1_1.p2c 0.00767f
C906 a_190926_330241# a_190926_329719# 0
C907 a_301405_39542# a_302065_39542# 0.02109f
C908 a_188834_327918# a_188834_326341# 0.04203f
C909 a_189184_325263# a_189756_329719# 0.00459f
C910 user_project_wrapper_0.sg13g2_IOPadAnalog_8.padres a_79038_134366# 0.01719f
C911 user_project_wrapper_0.sg13g2_IOPadAnalog_17.padres a_189184_325263# 0.15995f
C912 user_project_wrapper_0.IOVDD2 a_298435_35456# 0.01567f
C913 a_117145_39542# a_117145_35542# 0.03774f
C914 user_project_wrapper_0.IOVDD1 a_35542_74035# 0
C915 user_project_wrapper_0.IOVDD4 a_80635_364458# 0.01409f
C916 a_360458_77005# VDD3 -0
C917 a_191438_328605# a_191234_329719# 0.002f
C918 a_186430_98275# QDLL_TOP_0.VDD 0.56483f
C919 a_35542_77335# a_39542_77005# 0.03774f
C920 analog_io[19] VDD3 19.8007f
C921 a_58798_281951# user_project_wrapper_0.sg13g2_IOPadOut4mA$1_1.c2p 1.75397f
C922 a_82846_241091# a_82645_240231# 0.04627f
C923 a_208367_327491# a_209041_328013# 0.01591f
C924 a_208939_327491# a_209905_328013# 0.01267f
C925 a_209480_327491# a_210417_327491# 0.02229f
C926 user_project_wrapper_0.sg13g2_IOPadAnalog_15.padres a_82118_239118# 0
C927 a_85052_125418# a_86507_127725# 0.12707f
C928 user_project_wrapper_0.sg13g2_IOPadAnalog_18.padres user_project_wrapper_0.IOVDD4 1.36563f
C929 m3_6440_9800# m4_6440_9800# 1.03989p
C930 a_360372_298765# a_360458_299095# 0.03774f
C931 a_189184_327491# a_190722_328013# 0.00515f
C932 a_189756_327491# a_190926_328013# 0
C933 w_188704_326203# a_190501_326377# 0.10257f
C934 a_210109_327099# a_210109_326377# 0
C935 w_188806_323975# a_189756_326377# 0.0016f
C936 a_82658_128838# a_79025_136081# 0.01178f
C937 a_309917_199879# user_project_wrapper_0.sg13g2_IOPadAnalog_29.padres 1.10989f
C938 a_209480_328605# a_209041_329327# 0
C939 user_project_wrapper_0.sg13g2_IOPadAnalog_21.padres a_212178_331343# 0
C940 a_191462_324119# a_189672_324776# 0.21008f
C941 user_project_wrapper_0.VDD1 a_79025_136081# 2.0852f
C942 a_314697_196700# a_311846_195517# 0.00812f
C943 a_89953_129061# a_93298_129062# 0.00158f
C944 a_90579_129060# a_91090_129060# 0.00441f
C945 a_211153_330026# a_211153_329814# 0.01085f
C946 a_82658_129203# a_82658_128838# 0.09384f
C947 TOP_ROILIFNEURON_0.MEM a_210007_327491# 0
C948 a_78824_128711# a_78220_128192# 0
C949 a_83389_129203# a_83389_128838# 0.09189f
C950 user_project_wrapper_0.VDD1 a_82658_129203# 0.45385f
C951 a_79038_126152# a_79025_127401# 0.0104f
C952 w_207887_327938# a_209905_328013# 0.01266f
C953 a_305695_364458# user_project_wrapper_0.IOVDD4 0.01587f
C954 user_project_wrapper_0.IOVDD1 user_project_wrapper_0.ui_PAD[2] 84.7563f
C955 TOP_ROILIFNEURON_0.MEM a_210417_328605# 0.00568f
C956 a_189756_325263# a_190722_325263# 0.00596f
C957 user_project_wrapper_0.sg13g2_IOPadAnalog_17.padres a_189286_325263# 0.00801f
C958 a_79025_124824# user_project_wrapper_0.sg13g2_IOPadAnalog_8.padres 0.00776f
C959 w_207887_327938# a_210109_329327# 0
C960 a_189524_90558# a_190082_92557# 0
C961 user_project_wrapper_0.sg13g2_IOPadAnalog_1.padres VDD3 3.66638f
C962 user_project_wrapper_0.IOVDD2 user_project_wrapper_0.VDD2 0.15509p
C963 TOP_ROILIFNEURON_0.MEM w_207989_323975# 0.12711f
C964 a_208017_326341# a_209041_327491# 0.00271f
C965 a_208939_325263# a_209905_327491# 0.00101f
C966 user_project_wrapper_0.VDD1 a_58170_281249# 0.02159f
C967 user_project_wrapper_0.sg13g2_IOPadAnalog_21.padres a_208469_327491# 0.00111f
C968 TOP_ROILIFNEURON_0.MEM a_211537_325997# 0.00168f
C969 user_project_wrapper_0.VDD2 user_project_wrapper_0.sg13g2_IOPadVdd_1.sg13g2_RCClampInverter_noptap_0.out 0.10089p
C970 a_186202_326221# a_187364_324106# 0.02049f
C971 a_237844_355624# user_project_wrapper_0.analog_io[33] 25.1197f
C972 a_85875_125209# a_87571_125210# 0
C973 user_project_wrapper_0.sg13g2_IOPadIn$1_0.p2c a_83164_127455# 0
C974 a_208017_327918# a_208939_327491# 0.00771f
C975 a_208367_325263# a_208367_327491# 0.16124f
C976 user_project_wrapper_0.sg13g2_IOPadAnalog_22.padres a_208367_327491# 0.2073f
C977 a_79975_364458# user_project_wrapper_0.IOVDD4 0.01409f
C978 a_360372_303385# a_360458_303715# 0.03774f
C979 a_210621_325263# a_211153_325785# 0.00381f
C980 a_189184_328605# a_189184_327491# 0.48499f
C981 a_190501_328605# a_189756_327491# 0.00132f
C982 a_208367_328605# a_206201_328627# 0
C983 a_191970_326677# a_191438_326377# 0.00381f
C984 a_211537_327104# a_211537_327586# 0.0031f
C985 a_83490_125209# a_84332_125209# 0.00321f
C986 a_87627_124843# a_87434_127896# 0.00239f
C987 a_85977_125209# user_project_wrapper_0.VDD1 0.14154f
C988 user_project_wrapper_0.sg13g2_IOPadAnalog_19.padres a_189858_327491# 0.00958f
C989 a_210137_330851# a_210109_329327# 0
C990 TOP_ROILIFNEURON_0.MEM a_191970_328693# 0.00105f
C991 a_209104_331163# a_208017_326341# 0
C992 a_209018_330987# a_208939_329719# 0
C993 user_project_wrapper_0.IOVDD2 a_301405_39542# 0.02119f
C994 w_207887_327938# a_208017_327918# 0.33625f
C995 user_project_wrapper_0.sg13g2_IOPadAnalog_8.padres a_82859_239842# 0.0772f
C996 w_207883_330166# a_208939_325263# 0.06115f
C997 user_project_wrapper_0.sg13g2_IOPadOut4mA$1_1.sg13g2_GateLevelUpInv_noptap$1$1_0.ngate a_58170_281249# 0.00721f
C998 a_297775_364458# a_298435_364458# 0.02109f
C999 a_360372_76345# a_360458_76675# 0.03774f
C1000 a_210621_326377# a_210417_327491# 0.002f
C1001 w_188704_326203# a_188834_327918# 0.189f
C1002 a_208367_325263# a_210109_325785# 0.02698f
C1003 a_208939_325263# a_209041_325785# 0.22412f
C1004 a_208017_326341# a_208469_325785# 0.00124f
C1005 w_188704_327938# a_189756_329719# 0.06189f
C1006 w_188700_330166# a_189184_329719# 0.23499f
C1007 a_225661_355784# user_project_wrapper_0.IOVDD4 1.92793f
C1008 user_project_wrapper_0.VDD1 a_89114_127896# 0.505f
C1009 w_188704_327938# user_project_wrapper_0.sg13g2_IOPadAnalog_17.padres 0.05797f
C1010 a_35456_301075# a_35542_301405# 0.03774f
C1011 user_project_wrapper_0.IOVDD4 a_301405_360372# 0.02119f
C1012 a_360458_80305# IOVDD3 0
C1013 a_311189_211724# analog_io[23] 0.12489f
C1014 user_project_wrapper_0.sg13g2_IOPadAnalog_6.padres user_project_wrapper_0.analog_io[14] 0.18217f
C1015 a_77665_360458# a_77665_360372# 0.03774f
C1016 user_project_wrapper_0.IOVDD2 user_project_wrapper_0.sg13g2_IOPadIOVdd_0.sg13g2_RCClampResistor_0.p2 0.10479p
C1017 user_project_wrapper_0.analog_io[1] a_41476_135844# 25.1197f
C1018 TOP_ROILIFNEURON_0.MEM a_208855_324776# 0.38353f
C1019 a_191438_325263# a_189672_324776# 0.03792f
C1020 a_191970_325997# a_191438_326377# 0
C1021 a_79038_130026# a_79025_136081# 0
C1022 a_74695_364458# a_74695_360458# 0.03774f
C1023 w_207989_323975# a_208855_324776# 0.35052f
C1024 a_78220_128592# a_79025_129164# 0
C1025 a_84598_130577# a_89953_129061# 0.00256f
C1026 a_313884_211353# VDD3 0.16347f
C1027 a_191975_108496# QDLL_TOP_0.CPIN 0
C1028 a_355624_115444# IOVDD3 58.9173f
C1029 a_188760_99480# QDLL_TOP_0.VOUT 0
C1030 a_190319_102855# a_190584_102855# 0
C1031 a_360372_80965# user_project_wrapper_0.sg13g2_IOPadVdd_0.sg13g2_RCClampResistor_0.p2 0.02109f
C1032 user_project_wrapper_0.analog_io[15] user_project_wrapper_0.sg13g2_IOPadAnalog_6.padres 0.18217f
C1033 a_211537_325997# a_208855_324776# 0
C1034 a_305035_364458# a_305365_360458# 0.03774f
C1035 user_project_wrapper_0.sg13g2_IOPadAnalog_9.padres a_79038_132662# 0.16101f
C1036 a_209104_330851# a_208939_325263# 0
C1037 a_189756_325263# a_190926_328605# 0.00134f
C1038 a_189184_329719# a_189286_328605# 0.02933f
C1039 a_189756_329719# a_189858_328605# 0.02684f
C1040 a_89114_127896# user_project_wrapper_0.sg13g2_IOPadIn$1_1.p2c 0
C1041 a_300745_39542# a_301405_39542# 0.02109f
C1042 a_191970_330453# a_191970_330241# 0.01085f
C1043 a_191438_329719# a_192354_330241# 0.00953f
C1044 a_190297_329719# a_189756_328605# 0
C1045 user_project_wrapper_0.sg13g2_IOPadAnalog_21.padres a_207638_330851# 0
C1046 user_project_wrapper_0.VDD1 a_87832_241383# 0.20948f
C1047 a_182931_326125# a_187018_328627# 0.09942f
C1048 user_project_wrapper_0.sg13g2_IOPadOut4mA$1_0.c2p a_57810_179517# 0.02529f
C1049 user_project_wrapper_0.sg13g2_IOPadAnalog_8.padres a_78219_135283# 0.00431f
C1050 a_190868_330987# a_191987_331343# 0.00565f
C1051 user_project_wrapper_0.IOVDD2 a_122095_35542# 0
C1052 TOP_ROILIFNEURON_0.MEM a_192354_325570# 0.01042f
C1053 user_project_wrapper_0.IOVDD1 a_35542_75355# 0
C1054 a_190824_328605# a_190297_329719# 0
C1055 a_190297_328605# a_190824_329719# 0
C1056 a_211921_328225# a_210621_327491# 0
C1057 a_209041_327491# a_209684_327491# 0
C1058 a_208469_327491# a_209480_327491# 0
C1059 a_211921_327798# a_210007_327491# 0
C1060 a_209905_327491# a_208367_327491# 0.01977f
C1061 a_35456_79315# a_35542_79645# 0.03774f
C1062 a_211537_327798# a_210417_327491# 0
C1063 a_83492_127455# user_project_wrapper_0.sg13g2_IOPadIn$1_0.p2c 0.00752f
C1064 user_project_wrapper_0.VDD2 a_121435_35542# -0
C1065 w_188806_323975# a_192738_325358# 0
C1066 user_project_wrapper_0.IOVDD1 a_35542_304375# 0
C1067 a_211153_328013# a_210621_328605# 0
C1068 a_210007_325263# a_211537_325570# 0
C1069 a_210417_325263# a_211153_325570# 0
C1070 a_209684_325263# a_208469_325263# 0
C1071 a_35542_77995# a_39542_77665# 0.03774f
C1072 a_85591_241748# a_85989_241748# 0.00668f
C1073 a_85989_241383# a_86970_241383# 0.09254f
C1074 a_85287_241383# a_85591_241383# 0.00441f
C1075 user_project_wrapper_0.IOVDD1 a_41476_135844# 58.9173f
C1076 TOP_ROILIFNEURON_0.MEM a_211921_327798# 0.00639f
C1077 user_project_wrapper_0.uo_PAD[8] user_project_wrapper_0.sg13g2_IOPadOut4mA$1_1.sg13g2_GateLevelUpInv_noptap$1$1_0.pgate 2.57975f
C1078 user_project_wrapper_0.IOVDD4 a_258244_369296# 0.16358f
C1079 a_360372_299425# a_360458_299755# 0.03774f
C1080 m2_6440_9800# m3_6440_9800# 1.03989p
C1081 a_360372_73705# VDD3 0.03085f
C1082 user_project_wrapper_0.sg13g2_IOPadAnalog_22.padres a_208071_331343# 0.00541f
C1083 a_210621_326377# a_211153_327104# 0.00193f
C1084 w_207887_327938# a_210109_327491# 0
C1085 a_208071_331343# a_208367_325263# 0
C1086 a_188988_324119# a_189672_324776# 0
C1087 a_209997_324870# a_208855_324776# 0.05065f
C1088 a_190814_324870# a_187364_324106# 0
C1089 a_210621_329719# a_211153_329814# 0.00193f
C1090 a_301423_196360# a_296731_189665# 2.33177f
C1091 user_project_wrapper_0.VDD1 a_78218_138195# 0.09677f
C1092 a_313884_185173# a_296731_189665# 4.65413f
C1093 a_208939_325263# a_210417_325263# 0.00252f
C1094 a_355624_197044# analog_io[22] 25.1197f
C1095 user_project_wrapper_0.VDD1 a_86594_129426# 0.66761f
C1096 user_project_wrapper_0.sg13g2_IOPadAnalog_21.padres a_209480_325263# 0.00824f
C1097 a_296731_208493# a_301575_211562# 0.09617f
C1098 w_207887_327938# a_208939_327491# 0.21189f
C1099 a_188455_331343# user_project_wrapper_0.sg13g2_IOPadAnalog_19.padres 0
C1100 user_project_wrapper_0.IOVDD1 a_35456_299095# 0.01447f
C1101 a_188408_90558# a_188966_92557# 0
C1102 a_190954_331163# a_190954_330987# 0.13024f
C1103 a_191754_330987# a_190868_330987# 0.02617f
C1104 a_189184_327491# a_188920_324155# 0.14371f
C1105 a_35542_81625# user_project_wrapper_0.VDD1 0
C1106 a_35456_303715# a_35542_303715# 0.03774f
C1107 a_85875_125209# a_87673_125210# 0.00193f
C1108 a_83490_125209# a_85155_125209# 0
C1109 user_project_wrapper_0.sg13g2_IOPadIn$1_0.p2c a_82527_127455# 0.03803f
C1110 a_78221_125094# a_78824_124371# 0.00885f
C1111 a_87468_125419# a_87851_125174# 0.02964f
C1112 w_188806_323975# a_189737_324155# 0.01274f
C1113 w_207887_326203# a_208469_325785# 0.01313f
C1114 a_78655_364458# user_project_wrapper_0.IOVDD4 0.01409f
C1115 a_360372_304045# a_360458_304375# 0.03774f
C1116 a_188834_327918# a_189286_327491# 0.00298f
C1117 a_135844_29676# a_144061_29836# 0.01778f
C1118 a_190926_326377# a_190297_326377# 0.01192f
C1119 a_190722_326377# a_190824_326377# 0.20881f
C1120 a_82826_124842# a_82840_127455# 0
C1121 a_87851_125174# user_project_wrapper_0.VDD1 0.25385f
C1122 user_project_wrapper_0.IOVDD2 a_300085_39542# 0.02081f
C1123 TOP_ROILIFNEURON_0.MEM a_192738_329120# 0.00639f
C1124 a_121435_35456# a_121765_35542# 0.03774f
C1125 a_360372_77005# a_360458_77335# 0.03774f
C1126 TOP_ROILIFNEURON_0.MEM a_192995_330851# 0.00974f
C1127 a_188802_330987# a_189921_330851# 0.00843f
C1128 a_188888_330987# a_188888_330851# 0.29305f
C1129 a_190721_331163# a_190501_329719# 0
C1130 user_project_wrapper_0.sg13g2_IOPadOut4mA$1_1.sg13g2_GateLevelUpInv_noptap$1$1_0.ngate user_project_wrapper_0.uo_PAD[8] 0.9733f
C1131 a_209041_327099# a_208939_327491# 0.0363f
C1132 a_208469_327099# a_208367_327491# 0.03624f
C1133 w_207883_330166# a_211170_330851# 0.02488f
C1134 user_project_wrapper_0.VDD1 a_83796_128838# 0
C1135 a_123661_355784# user_project_wrapper_0.IOVDD4 1.92793f
C1136 a_35456_301735# a_35542_302065# 0.03774f
C1137 user_project_wrapper_0.IOVDD1 user_project_wrapper_0.sg13g2_IOPadAnalog_14.padres 1.36563f
C1138 a_369296_237844# analog_io[23] 9.69836f
C1139 user_project_wrapper_0.IOVDD2 a_217444_41476# 58.9173f
C1140 a_77005_360458# a_77005_360372# 0.03774f
C1141 user_project_wrapper_0.sg13g2_IOPadIn$1_2.p2c a_188920_324155# 0.00771f
C1142 a_82846_240684# user_project_wrapper_0.analog_io[4] 0
C1143 TOP_ROILIFNEURON_0.MEM a_191970_326465# 0.00105f
C1144 a_190926_325785# a_190824_326377# 0.00167f
C1145 a_190501_325263# a_189672_324776# 0.04269f
C1146 a_211153_326677# a_210007_326377# 0
C1147 a_74035_364458# a_74035_360458# 0.03774f
C1148 a_84598_130577# a_87434_129426# 0.01487f
C1149 w_207887_326203# a_209940_324686# 0
C1150 w_207989_323975# a_209638_324119# 0.10005f
C1151 a_190862_108496# a_191417_110495# 0
C1152 user_project_wrapper_0.sg13g2_IOPadAnalog_9.padres a_79025_135674# 0.32292f
C1153 a_304045_360372# a_304705_360372# 0.02109f
C1154 a_304375_364458# a_304705_360458# 0.03774f
C1155 a_189756_329719# a_191438_328605# 0
C1156 a_190501_329719# a_190722_329327# 0
C1157 a_211537_325358# a_211537_325570# 0.01085f
C1158 a_300085_39542# a_300745_39542# 0.02109f
C1159 a_191234_329719# a_191970_330026# 0
C1160 a_190824_329719# a_192354_330026# 0
C1161 user_project_wrapper_0.VDD1 a_85591_241748# 0.37718f
C1162 user_project_wrapper_0.VDD1 a_56308_202618# 0
C1163 user_project_wrapper_0.IOVDD2 a_120775_35542# 0
C1164 a_209104_331163# a_209104_331343# 0.12339f
C1165 a_58170_179951# user_project_wrapper_0.VDD1 0.00367f
C1166 user_project_wrapper_0.IOVDD1 a_35542_76675# 0
C1167 TOP_ROILIFNEURON_0.MEM a_209684_325263# 0
C1168 a_75025_360458# user_project_wrapper_0.IOVDD4 0
C1169 a_343292_121018# VDD3 0
C1170 a_35456_79975# a_35542_80305# 0.03774f
C1171 user_project_wrapper_0.sg13g2_IOPadAnalog_22.padres a_208579_324119# 0.00132f
C1172 a_211153_328013# a_208367_327491# 0
C1173 a_360458_79645# VDD3 0
C1174 w_207989_323975# a_209684_325263# 0
C1175 user_project_wrapper_0.VDD2 a_120115_35542# 0
C1176 a_208367_325263# a_208579_324119# 0
C1177 w_207887_326203# a_210007_325263# 0.11519f
C1178 a_35542_79645# a_35542_79315# 0.37213f
C1179 a_189756_325263# a_190926_326377# 0.00166f
C1180 a_208939_328605# a_209041_328605# 0.2219f
C1181 a_208367_328605# a_208469_328605# 0.23056f
C1182 a_192738_325570# a_192745_324776# 0
C1183 a_210007_325263# a_210621_325263# 0.01253f
C1184 user_project_wrapper_0.IOVDD1 a_35542_305695# 0
C1185 a_35542_78655# a_39542_78325# 0.03774f
C1186 user_project_wrapper_0.sg13g2_IOPadAnalog_6.padres a_190287_98223# 0
C1187 a_192738_325358# a_192745_324776# 0.00339f
C1188 user_project_wrapper_0.sg13g2_IOPadIn$1_1.p2c a_85591_241748# 0.19496f
C1189 a_85287_241383# a_86046_241645# 0
C1190 a_78824_126541# a_79025_129164# 0
C1191 analog_io[25] a_369296_258244# 9.69836f
C1192 VDD3 user_project_wrapper_0.sg13g2_IOPadAnalog_25.padres 1.74533f
C1193 a_190455_324119# a_187364_324106# 0
C1194 a_189609_324119# a_189184_326377# 0
C1195 a_309516_194555# a_309917_194695# 6.24219f
C1196 a_211537_330453# a_211537_330241# 0.01085f
C1197 a_209684_329719# a_208939_328605# 0
C1198 a_209638_324119# a_208855_324776# 0.0523f
C1199 a_304889_199957# a_296732_197880# 0.01661f
C1200 a_86594_129426# a_86594_129061# 0.09189f
C1201 TOP_ROILIFNEURON_0.MEM a_192354_328013# 0.01123f
C1202 a_210307_324119# a_210983_324119# 0
C1203 a_209940_324686# a_211321_324119# 0
C1204 a_313884_211353# a_311189_211724# 7.71569f
C1205 a_311108_215937# a_296731_208493# 0.00384f
C1206 user_project_wrapper_0.sg13g2_IOPadAnalog_26.padres a_343292_263818# 0.0512f
C1207 a_189756_325263# a_191438_325263# 0.00116f
C1208 user_project_wrapper_0.IOVDD1 a_35456_300415# 0.01555f
C1209 a_82826_124842# m2_83010_126180# 0.00171f
C1210 a_182218_343292# user_project_wrapper_0.sg13g2_IOPadAnalog_18.padres 0.0512f
C1211 a_186731_92558# a_188408_90558# 0
C1212 a_187294_90558# a_187852_92557# 0
C1213 a_189688_330987# a_188802_330987# 0.02649f
C1214 a_188888_331163# a_188888_330987# 0.13024f
C1215 user_project_wrapper_0.sg13g2_IOPadAnalog_19.padres a_190824_325263# 0
C1216 a_82770_125209# user_project_wrapper_0.sg13g2_IOPadIn$1_0.p2c 0.01194f
C1217 a_189184_328605# a_189286_327099# 0.00118f
C1218 user_project_wrapper_0.VDD1 user_project_wrapper_0.sg13g2_IOPadAnalog_8.padres 2.43675f
C1219 a_209684_325263# a_208855_324776# 0.04269f
C1220 user_project_wrapper_0.VDD1 m1_82116_130103# 0.01719f
C1221 a_85211_124842# a_85257_125209# 0.08174f
C1222 a_85052_125418# a_85875_125209# 0.23138f
C1223 a_209684_325263# a_209997_324870# 0.00258f
C1224 w_188806_323975# a_190686_324119# 0.10325f
C1225 a_192738_328693# a_192738_328225# 0.00322f
C1226 w_188704_326203# a_191124_324119# 0.00108f
C1227 a_77335_364458# user_project_wrapper_0.IOVDD4 0.01409f
C1228 a_360372_304705# a_360458_305035# 0.03774f
C1229 a_305365_35542# a_305695_35542# 0.37213f
C1230 a_192354_327104# a_190297_326377# 0
C1231 a_83490_125209# user_project_wrapper_0.VDD1 0.2127f
C1232 a_83925_130212# a_85127_131750# 0
C1233 QDLL_TOP_0.VDD a_269355_100412# 0.28471f
C1234 user_project_wrapper_0.IOVDD2 a_116815_35542# 0
C1235 IOVDD3 a_355784_164461# 1.92793f
C1236 user_project_wrapper_0.sg13g2_IOPadAnalog_8.padres user_project_wrapper_0.sg13g2_IOPadIn$1_1.p2c 0.56865f
C1237 a_360372_77665# a_360458_77995# 0.03774f
C1238 a_120775_35456# a_121105_35542# 0.03774f
C1239 analog_io[20] a_343292_182218# 0.05479f
C1240 user_project_wrapper_0.sg13g2_IOPadIOVdd_0.sg13g2_RCClampResistor_0.p2 user_project_wrapper_0.sg13g2_IOPadIOVdd_0.sg13g2_Clamp_N43N43D4R_0.gate 22.6715f
C1241 TOP_ROILIFNEURON_0.MEM a_210137_330987# 0
C1242 a_211170_331163# a_211170_330987# 0.13024f
C1243 a_190868_330987# a_192995_330987# 0.00257f
C1244 a_190926_325785# a_190926_325263# 0
C1245 a_210417_326377# a_210621_327491# 0.002f
C1246 m1_81768_242005# user_project_wrapper_0.sg13g2_IOPadAnalog_15.padres 0.00419f
C1247 user_project_wrapper_0.VDD1 a_88274_129061# 0
C1248 w_188700_330166# a_191987_330851# 0.02488f
C1249 user_project_wrapper_0.VDD2 a_116155_35542# -0
C1250 a_35456_302395# a_35542_302725# 0.03774f
C1251 a_188834_327918# a_189396_324119# 0
C1252 a_189184_325263# a_189609_324119# 0
C1253 a_189756_325263# a_189756_328605# 0.04222f
C1254 a_190501_329719# a_190926_329719# 0.05284f
C1255 a_76345_360458# a_76345_360372# 0.03774f
C1256 a_83070_130577# a_83925_130212# 0
C1257 a_83398_130212# a_83796_129203# 0.01996f
C1258 a_82859_241546# user_project_wrapper_0.analog_io[4] 0.17968f
C1259 user_project_wrapper_0.IOVDD2 a_135844_41476# 58.9173f
C1260 user_project_wrapper_0.sg13g2_IOPadIn$1_2.p2c user_project_wrapper_0.analog_io[32] 0.17737f
C1261 TOP_ROILIFNEURON_0.MEM a_192738_326892# 0.00631f
C1262 user_project_wrapper_0.sg13g2_IOPadAnalog_19.padres a_189858_329719# 0.01013f
C1263 a_189286_325785# a_187364_324106# 0
C1264 a_190824_325263# a_189184_326377# 0
C1265 a_73375_364458# a_73375_360458# 0.03774f
C1266 w_188704_326203# a_190722_326377# 0.01266f
C1267 a_191438_328605# a_192354_328905# 0.00953f
C1268 a_189748_108496# a_190304_110495# 0
C1269 user_project_wrapper_0.sg13g2_IOPadAnalog_9.padres a_78824_137391# 0.04883f
C1270 a_303385_360372# a_304045_360372# 0.02109f
C1271 a_303715_364458# a_304045_360458# 0.03774f
C1272 user_project_wrapper_0.sg13g2_IOPadAnalog_22.padres a_208071_330987# 0.00275f
C1273 a_207985_330987# a_208017_327918# 0
C1274 a_208071_330987# a_208367_325263# 0
C1275 a_189756_325263# a_190824_328605# 0.00321f
C1276 a_188834_326341# a_190297_328605# 0.00123f
C1277 a_189756_329719# a_190501_328605# 0.00113f
C1278 a_189184_325263# a_189286_329327# 0
C1279 a_189184_329719# a_189184_328605# 0.19405f
C1280 a_91090_127530# a_86507_129255# 0
C1281 a_205385_326221# a_206201_328627# 1.32746f
C1282 a_189184_327491# a_190501_327491# 0.73864f
C1283 a_189756_327491# a_190297_327491# 0.21292f
C1284 a_191196_90557# user_project_wrapper_0.analog_io[13] 0.0113f
C1285 user_project_wrapper_0.sg13g2_IOPadAnalog_17.padres a_190501_328605# 0
C1286 a_191234_329719# a_191438_329719# 0.43471f
C1287 a_208103_324155# a_209684_326377# 0
C1288 user_project_wrapper_0.sg13g2_IOPadAnalog_6.padres user_project_wrapper_0.IOVDD2 4.09689f
C1289 a_212178_330987# a_212178_330851# 0.07033f
C1290 user_project_wrapper_0.IOVDD2 a_119455_35542# 0
C1291 a_192995_331163# a_192995_331343# 0.02961f
C1292 a_360458_73705# a_364458_73375# 0.03774f
C1293 a_79038_130026# user_project_wrapper_0.sg13g2_IOPadAnalog_8.padres 0.01719f
C1294 a_35456_79315# user_project_wrapper_0.IOVDD1 0.01409f
C1295 user_project_wrapper_0.IOVDD1 a_35542_77995# 0
C1296 a_208367_328605# a_209905_328013# 0
C1297 a_73705_360458# user_project_wrapper_0.IOVDD4 0
C1298 a_208017_326341# a_210417_326377# 0
C1299 a_360458_80965# VDD3 0
C1300 a_35456_80635# a_35542_80965# 0.03774f
C1301 user_project_wrapper_0.VDD2 a_118795_35542# 0
C1302 w_188704_326203# a_190926_325785# 0.01287f
C1303 a_209684_328605# a_209905_329327# 0.01614f
C1304 a_211537_329814# a_211537_329332# 0.0031f
C1305 a_35542_79315# a_39542_78985# 0.03774f
C1306 user_project_wrapper_0.sg13g2_IOPadAnalog_14.padres a_82645_240231# 0.00101f
C1307 m1_6440_9800# m2_6440_9800# 1.03989p
C1308 a_189729_101343# QDLL_TOP_0.CPIN 0.00262f
C1309 a_210417_326377# a_211921_326892# 0
C1310 a_185968_98275# user_project_wrapper_0.analog_io[13] 0.56515f
C1311 m1_83011_126179# user_project_wrapper_0.sg13g2_IOPadIn$1_0.p2c 0.01145f
C1312 a_296732_200582# a_304889_199957# 0
C1313 a_209480_329719# a_211537_330026# 0
C1314 a_210007_329719# a_211153_330026# 0
C1315 user_project_wrapper_0.VDD1 a_39542_74365# 0.00299f
C1316 a_301940_196388# a_301423_196360# 0.04017f
C1317 a_304090_197941# a_296625_189595# 0.92487f
C1318 user_project_wrapper_0.VDD1 a_58170_179249# 0.02159f
C1319 a_209230_324119# a_209869_324119# 0.00115f
C1320 a_211537_325358# a_211321_324119# 0
C1321 a_208792_324119# a_209940_324686# 0
C1322 w_188704_327938# a_192738_328225# 0.0018f
C1323 a_355624_197044# a_355784_205261# 0.01916f
C1324 a_189184_325263# a_190824_325263# 0.38521f
C1325 a_189756_325263# a_190501_325263# 0.21029f
C1326 user_project_wrapper_0.IOVDD1 a_35456_301735# 0.01567f
C1327 user_project_wrapper_0.VDD2 a_284218_56308# -0
C1328 user_project_wrapper_0.sg13g2_IOPadAnalog_9.padres a_78220_128192# 0.00843f
C1329 user_project_wrapper_0.sg13g2_IOPadAnalog_22.padres a_209684_328605# 0
C1330 a_85435_125173# user_project_wrapper_0.sg13g2_IOPadIn$1_0.p2c 0
C1331 a_208017_327918# a_208367_328605# 0.62443f
C1332 a_208939_325263# a_208939_328605# 0.04222f
C1333 a_208367_325263# a_209684_328605# 0
C1334 a_79025_131741# a_84707_131750# 0.10196f
C1335 a_78220_130691# a_78824_130881# 0.00901f
C1336 a_209684_325263# a_209638_324119# 0.0029f
C1337 a_209480_325263# a_209230_324119# 0.00209f
C1338 a_83050_125173# a_83490_125209# 0.3249f
C1339 a_82826_124842# a_85052_125418# 0.02435f
C1340 user_project_wrapper_0.analog_io[13] user_project_wrapper_0.VDD2 21.54636f
C1341 a_191970_328905# a_191438_327491# 0
C1342 a_188572_101637# QDLL_TOP_0.VDD 0.31014f
C1343 a_360372_305365# a_360458_305695# 0.03774f
C1344 a_76015_364458# user_project_wrapper_0.IOVDD4 0.01409f
C1345 a_191124_324119# a_191800_324119# 0
C1346 a_190757_324686# a_192138_324119# 0
C1347 a_57810_180219# a_57810_179517# 0.00446f
C1348 a_304705_35542# a_305035_35542# 0.37213f
C1349 user_project_wrapper_0.VDD1 a_82118_242359# 0.03245f
C1350 a_78221_126292# user_project_wrapper_0.VDD1 0.01333f
C1351 user_project_wrapper_0.IOVDD1 a_29676_197044# 0.16358f
C1352 a_79025_125231# a_79025_131741# 0.53854f
C1353 user_project_wrapper_0.IOVDD2 a_115495_35542# 0
C1354 a_360372_78325# a_360458_78655# 0.03774f
C1355 a_91911_129060# a_87105_130835# 0.00736f
C1356 a_120115_35456# a_120445_35542# 0.03774f
C1357 a_209104_331163# a_209104_330987# 0.13024f
C1358 a_190297_325263# a_189858_325263# 0
C1359 a_191234_325263# a_192738_325570# 0
C1360 a_190501_325263# a_190722_325263# 0.01614f
C1361 a_191438_325263# a_191970_325785# 0.00381f
C1362 a_311846_195517# VDD3 0.68287f
C1363 a_192738_327104# a_192738_327586# 0.0031f
C1364 user_project_wrapper_0.VDD2 a_114835_35542# -0
C1365 a_190926_328605# a_189756_328605# 0
C1366 a_35456_303055# a_35542_303385# 0.03774f
C1367 a_188834_327918# a_189286_329719# 0.00271f
C1368 a_189184_329719# a_188920_324155# 0.12077f
C1369 a_75685_360458# a_75685_360372# 0.03774f
C1370 a_35456_74035# a_35456_73375# 0.02109f
C1371 a_270512_100118# QDLL_TOP_0.VOUT 0
C1372 a_86046_241645# a_82846_243261# 0
C1373 a_87105_130835# user_project_wrapper_0.sg13g2_IOPadOut4mA$1_0.c2p 0.00281f
C1374 user_project_wrapper_0.sg13g2_IOPadIn$1_2.p2c a_194279_327536# 0.01089f
C1375 a_35542_298105# a_39542_298105# 0.03774f
C1376 a_82746_130212# a_79025_125231# 0.11021f
C1377 w_207887_326203# a_210417_326377# 0.22627f
C1378 a_190824_328605# a_190926_328605# 0.22366f
C1379 a_191438_328605# a_191970_329120# 0.00324f
C1380 a_360458_300415# IOVDD3 0
C1381 a_210621_325263# a_210417_326377# 0.00165f
C1382 a_188632_108496# a_189190_110495# 0
C1383 a_302725_360372# a_303385_360372# 0.02109f
C1384 a_303055_364458# a_303385_360458# 0.03774f
C1385 a_190954_330851# a_191438_328605# 0
C1386 a_86594_127531# a_85127_131750# 0
C1387 a_211921_328905# a_211921_328693# 0.01085f
C1388 a_188966_90557# user_project_wrapper_0.analog_io[13] 0.0113f
C1389 a_194193_328627# a_194279_327536# 1.32746f
C1390 a_58798_281951# a_57810_281517# 0.00367f
C1391 a_35456_80635# user_project_wrapper_0.IOVDD1 0.01409f
C1392 user_project_wrapper_0.IOVDD2 a_118135_35542# 0
C1393 a_360458_74365# a_364458_74035# 0.03774f
C1394 TOP_ROILIFNEURON_0.MEM a_211921_326677# 0.00707f
C1395 user_project_wrapper_0.IOVDD1 a_35542_79315# 0
C1396 a_208367_328605# a_208939_327491# 0.01817f
C1397 a_208939_328605# a_208367_327491# 0.03209f
C1398 w_207887_326203# a_211537_326465# 0.0018f
C1399 user_project_wrapper_0.VDD2 a_117475_35542# 0
C1400 a_211153_326465# a_211153_325997# 0.00322f
C1401 a_191438_325263# a_191462_324119# 0.0021f
C1402 TOP_ROILIFNEURON_0.MEM a_211153_329814# 0.00105f
C1403 a_190722_328013# a_190722_327491# 0
C1404 a_364458_300415# a_360458_300415# 0.03774f
C1405 w_207887_327938# a_208367_328605# 0.33809f
C1406 a_208103_324155# a_208469_325263# 0.01726f
C1407 user_project_wrapper_0.VDD1 a_39542_75685# 0.00199f
C1408 a_296626_197740# a_304995_198817# 0.1945f
C1409 a_296625_208423# a_307232_196607# 0.00712f
C1410 a_301186_192011# a_304196_200821# 0
C1411 a_210007_329719# a_210621_329719# 0.01253f
C1412 a_29676_135844# user_project_wrapper_0.analog_io[1] 9.69836f
C1413 a_206547_324106# a_202114_326125# 0.0106f
C1414 user_project_wrapper_0.sg13g2_IOPadAnalog_19.padres a_189858_328013# 0
C1415 a_82859_242012# a_82846_242854# 0.70614f
C1416 user_project_wrapper_0.sg13g2_IOPadAnalog_8.padres a_82645_242401# 0.11065f
C1417 a_79025_126994# user_project_wrapper_0.sg13g2_IOPadAnalog_8.padres 0.01276f
C1418 user_project_wrapper_0.IOVDD1 a_35456_303055# 0.01555f
C1419 a_93208_127531# a_93719_127531# 0.00441f
C1420 a_208017_327918# a_208469_329719# 0.00271f
C1421 a_208367_329719# a_208103_324155# 0.12077f
C1422 a_79025_136081# a_79038_130492# 0
C1423 a_79025_133911# a_79025_131741# 0.44404f
C1424 a_79025_133504# a_78220_130691# 0.25173f
C1425 a_78824_133051# a_79038_132196# 0
C1426 a_209104_330851# a_209684_328605# 0
C1427 a_211153_326465# a_210621_326377# 0.002f
C1428 a_80635_364458# a_81295_364458# 0.02109f
C1429 a_86507_127725# a_85127_131750# 0.0012f
C1430 TOP_ROILIFNEURON_0.MEM a_192738_330241# 0.00639f
C1431 a_186430_102197# QDLL_TOP_0.VDD 0.56483f
C1432 w_188806_323975# a_188920_324155# 0.0826f
C1433 w_188700_330166# a_190722_329719# 0
C1434 a_190047_324119# a_190686_324119# 0.00115f
C1435 a_189609_324119# a_190757_324686# 0
C1436 a_314697_196700# a_314793_197200# 0.66193f
C1437 a_304045_35542# a_304375_35542# 0.37213f
C1438 user_project_wrapper_0.IOVDD1 a_29676_135844# 0.16358f
C1439 a_82746_130212# a_79025_133911# 0.00248f
C1440 a_208367_326377# a_209684_326377# 0.73565f
C1441 a_208939_326377# a_209480_326377# 0.20339f
C1442 user_project_wrapper_0.IOVDD2 a_114175_35542# 0
C1443 a_119455_35456# a_119785_35542# 0.03774f
C1444 a_360372_78985# a_360458_79315# 0.03774f
C1445 user_project_wrapper_0.sg13g2_IOPadAnalog_6.padres a_270178_100118# 0.00579f
C1446 user_project_wrapper_0.analog_io[13] a_190304_108495# 0.01131f
C1447 a_296732_197880# VDD3 15.6224f
C1448 a_192738_329332# a_192738_329814# 0.0031f
C1449 a_189756_329719# a_191438_329719# 0
C1450 a_190501_329719# a_190722_330241# 0.05425f
C1451 a_189184_329719# a_190926_330241# 0.02616f
C1452 a_190722_327099# a_189756_327491# 0
C1453 user_project_wrapper_0.sg13g2_IOPadAnalog_21.padres user_project_wrapper_0.analog_io[32] 0.40261f
C1454 a_190824_326377# a_190824_327491# 0.01118f
C1455 user_project_wrapper_0.IOVDD4 user_project_wrapper_0.analog_io[27] 0.10967p
C1456 a_41636_123661# a_41476_115444# 0.01916f
C1457 a_300085_360372# user_project_wrapper_0.IOVDD4 0.02081f
C1458 a_35456_74695# a_35456_74035# 0.02109f
C1459 a_87571_125210# a_86507_129255# 0
C1460 user_project_wrapper_0.IOVDD1 a_41636_123661# 1.92793f
C1461 a_360458_301735# IOVDD3 0
C1462 a_190501_328605# a_191970_329120# 0
C1463 a_186397_108409# a_188632_108410# 0
C1464 a_187518_108496# a_188074_110495# 0
C1465 a_302395_364458# a_302725_360458# 0.03774f
C1466 a_302065_360372# a_302725_360372# 0.02109f
C1467 a_190954_330851# a_190501_328605# 0
C1468 a_189921_330851# a_190297_328605# 0
C1469 a_116155_35456# a_116485_35542# 0.03774f
C1470 a_186731_90558# user_project_wrapper_0.analog_io[13] 0.19783f
C1471 a_86507_127725# a_89114_127531# 0
C1472 a_89953_129061# a_93719_127531# 0.02461f
C1473 a_210051_330987# a_211170_330987# 0.05255f
C1474 user_project_wrapper_0.sg13g2_IOPadVdd_0.sg13g2_RCClampResistor_0.p2 VDD3 36.1501f
C1475 a_79025_124824# a_79025_125231# 0
C1476 user_project_wrapper_0.sg13g2_IOPadOut4mA$1_1.sg13g2_GateLevelUpInv_noptap$1$1_0.pgate user_project_wrapper_0.sg13g2_IOPadOut4mA$1_1.c2p 0.03147f
C1477 a_208103_324155# a_210007_327491# 0
C1478 IOVDD3 user_project_wrapper_0.sg13g2_IOPadAnalog_26.padres 1.36563f
C1479 a_296731_208493# a_309917_194695# 0.00231f
C1480 a_190824_325263# a_190757_324686# 0
C1481 a_191438_327491# a_192354_328225# 0
C1482 w_207989_323975# a_208103_324155# 0.0826f
C1483 a_364458_301075# a_360458_301075# 0.03774f
C1484 a_296625_208423# a_301940_196388# 4.19034f
C1485 a_301186_192011# a_304090_197941# 2.87231f
C1486 a_210007_329719# a_210417_329719# 0.15379f
C1487 user_project_wrapper_0.VDD1 a_39542_77005# 0.00238f
C1488 a_78221_125094# user_project_wrapper_0.sg13g2_IOPadAnalog_9.padres 0.15793f
C1489 a_189756_325263# a_191234_327491# 0.00172f
C1490 a_188834_326341# a_190824_327491# 0
C1491 a_188834_327918# a_189286_328013# 0.02077f
C1492 user_project_wrapper_0.VDD1 user_project_wrapper_0.sg13g2_IOPadOut4mA$1_1.c2p 8.42411f
C1493 user_project_wrapper_0.sg13g2_IOPadAnalog_17.padres a_190297_327491# 0
C1494 user_project_wrapper_0.IOVDD2 a_156244_29676# 0.16358f
C1495 a_89953_127531# a_91090_127530# 0.00133f
C1496 a_84332_125209# a_88274_127531# 0
C1497 user_project_wrapper_0.IOVDD1 a_29676_217444# 0.16358f
C1498 a_188920_324155# a_190722_327491# 0
C1499 a_208939_329719# a_210621_329719# 0
C1500 a_208367_329719# a_210109_330241# 0.02616f
C1501 a_39542_298765# a_35542_298765# 0.03774f
C1502 a_360458_75355# IOVDD3 0
C1503 a_82645_242401# a_82118_242359# 0.00754f
C1504 a_79038_134366# a_79025_133911# 0.02956f
C1505 a_78219_134797# a_78824_133051# 0.00913f
C1506 a_79025_136081# a_79038_132196# 0
C1507 a_190501_325263# a_190926_326377# 0
C1508 a_88274_129426# a_86507_129255# 0.07697f
C1509 a_78824_128711# a_78824_130881# 0
C1510 a_79025_126994# a_78221_126292# 0
C1511 a_78824_126541# a_79038_126152# 0.05038f
C1512 user_project_wrapper_0.sg13g2_IOPadOut4mA$1_1.sg13g2_GateLevelUpInv_noptap$1$1_0.ngate user_project_wrapper_0.sg13g2_IOPadOut4mA$1_1.c2p 0.03235f
C1513 a_191234_328605# a_191438_327491# 0.00165f
C1514 a_91090_129425# a_91911_129060# 0.10325f
C1515 a_189395_101343# user_project_wrapper_0.sg13g2_IOPadAnalog_6.padres 0
C1516 a_208103_324155# a_208855_324776# 0.00517f
C1517 user_project_wrapper_0.IOVDD1 user_project_wrapper_0.sg13g2_IOPadOut4mA$1_0.sg13g2_GateLevelUpInv_noptap$1$1_0.pgate 15.518f
C1518 a_303385_35542# a_303715_35542# 0.37213f
C1519 a_79025_127401# a_79025_136081# 0.76441f
C1520 a_83079_128838# a_79025_125231# 0
C1521 a_360372_79645# a_360458_79975# 0.03774f
C1522 a_82658_129203# a_79025_127401# 0.02864f
C1523 a_118795_35456# a_119125_35542# 0.03774f
C1524 user_project_wrapper_0.analog_io[13] a_188074_108495# 0.0287f
C1525 a_186431_100948# QDLL_TOP_0.VOUT 0.27781f
C1526 a_190824_325263# a_190722_325785# 0.20881f
C1527 a_190297_325263# a_190926_325785# 0.01192f
C1528 a_190501_325263# a_191438_325263# 0.00396f
C1529 a_296732_200582# VDD3 15.6224f
C1530 IOVDD3 a_360458_298435# 0
C1531 analog_io[22] IOVDD3 0.10967p
C1532 user_project_wrapper_0.sg13g2_IOPadAnalog_22.padres a_206201_328627# 0.00132f
C1533 a_208017_327918# a_205385_326221# 0
C1534 a_208367_325263# a_206201_328627# 0
C1535 a_190824_328605# a_189756_328605# 0.01489f
C1536 a_355624_115444# analog_io[18] 25.1197f
C1537 a_189756_326377# a_189756_327491# 0.27199f
C1538 a_189184_325263# a_189286_330241# 0.02541f
C1539 a_298765_360372# user_project_wrapper_0.IOVDD4 0.02181f
C1540 a_35456_75355# a_35456_74695# 0.02109f
C1541 a_87673_125210# a_86507_129255# 0
C1542 a_29676_217444# user_project_wrapper_0.analog_io[5] 9.69836f
C1543 a_190501_328605# a_189286_329327# 0
C1544 a_190297_328605# a_191234_328605# 0.02229f
C1545 a_360458_303055# IOVDD3 0
C1546 user_project_wrapper_0.analog_io[11] a_156244_41476# 25.1197f
C1547 a_301735_364458# a_302065_360458# 0.03774f
C1548 a_301405_360372# a_302065_360372# 0.02109f
C1549 a_369296_115444# a_369456_123661# 0.01778f
C1550 a_86594_127896# a_85127_131750# 0
C1551 a_208469_325263# a_208367_326377# 0.0201f
C1552 a_209041_325263# a_208939_326377# 0.02133f
C1553 a_115495_35456# a_115825_35542# 0.03774f
C1554 a_141418_343292# user_project_wrapper_0.analog_io[28] 0.05479f
C1555 a_91090_129425# a_91090_127895# 0
C1556 a_35456_304375# a_35456_303715# 0.02109f
C1557 w_188704_326203# a_190824_327491# 0
C1558 w_188704_327938# a_189858_328013# 0.01302f
C1559 user_project_wrapper_0.sg13g2_IOPadAnalog_6.padres user_project_wrapper_0.analog_io[13] 1.18607f
C1560 a_208017_326341# a_209480_326377# 0.00135f
C1561 a_208939_325263# a_210007_326377# 0.00366f
C1562 user_project_wrapper_0.sg13g2_IOPadAnalog_21.padres a_209684_326377# 0
C1563 a_304889_198885# a_304196_200821# 0.13599f
C1564 a_188888_331343# a_188920_324155# 0
C1565 user_project_wrapper_0.sg13g2_IOPadIn$1_2.p2c a_187364_324106# 0.02557f
C1566 a_208871_330987# a_208103_324155# 0
C1567 a_78824_124371# a_79038_123516# 0
C1568 a_79025_124824# a_78220_123062# 0.29206f
C1569 a_364458_301735# a_360458_301735# 0.03774f
C1570 a_35542_80305# user_project_wrapper_0.VDD1 0
C1571 a_211537_326892# a_210007_326377# 0
C1572 a_209041_326377# a_208367_326377# 0.01727f
C1573 a_209905_326377# a_208939_326377# 0.0122f
C1574 user_project_wrapper_0.VDD1 a_39542_78325# 0.00238f
C1575 user_project_wrapper_0.IOVDD2 a_305035_35456# 0.01567f
C1576 a_117145_35542# a_116815_35456# 0.03774f
C1577 a_258244_355624# user_project_wrapper_0.analog_io[34] 25.1197f
C1578 a_299755_360458# a_300085_360458# 0.37213f
C1579 TOP_ROILIFNEURON_0.MEM user_project_wrapper_0.sg13g2_IOPadIn$1_2.p2c 0.00272f
C1580 a_89953_127531# a_92512_127896# 0.05788f
C1581 a_84332_125209# a_91090_127895# 0.04985f
C1582 a_83164_127820# a_83164_127455# 0.08754f
C1583 a_87434_127896# a_87434_127531# 0.09399f
C1584 a_88274_127896# a_88274_127531# 0.09189f
C1585 user_project_wrapper_0.sg13g2_IOPadAnalog_22.padres a_208469_330241# 0.00126f
C1586 a_208939_329719# a_210417_329719# 0
C1587 a_208367_329719# a_210007_329719# 0.38724f
C1588 a_208367_325263# a_208469_330241# 0.02541f
C1589 user_project_wrapper_0.sg13g2_IOPadIn$1_2.p2c w_207989_323975# 0.11796f
C1590 a_39542_299425# a_35542_299425# 0.03774f
C1591 user_project_wrapper_0.IOVDD4 a_305365_360458# 0
C1592 a_360458_76675# IOVDD3 0
C1593 a_211170_330851# a_211537_330453# 0.00399f
C1594 a_79025_135674# a_78219_134883# 0
C1595 a_78824_135221# a_79038_134832# 0.05038f
C1596 a_79315_364458# a_79975_364458# 0.02109f
C1597 a_83079_128838# a_79025_133911# 0.06295f
C1598 a_79025_129571# a_79025_131741# 0.25137f
C1599 TOP_ROILIFNEURON_0.MEM a_194193_328627# 0.10442f
C1600 a_314793_197200# a_311108_179669# 0.00308f
C1601 w_207883_330166# a_206201_328627# 0
C1602 w_188700_330166# a_189858_330241# 0.01323f
C1603 w_207887_327938# a_205385_326221# 0
C1604 a_89953_129061# a_83492_127455# 0.04588f
C1605 a_190047_324119# a_188920_324155# 0.00111f
C1606 a_187914_101343# user_project_wrapper_0.sg13g2_IOPadAnalog_6.padres 0.00837f
C1607 a_314793_201808# a_314793_197200# 0.79558f
C1608 a_302725_35542# a_303055_35542# 0.37213f
C1609 a_343292_263818# analog_io[25] 0.05479f
C1610 a_190297_326377# a_191438_326377# 0.00342f
C1611 a_190824_326377# a_190926_327099# 0.1023f
C1612 a_305619_187719# a_304889_199957# 0.06876f
C1613 user_project_wrapper_0.sg13g2_IOPadAnalog_8.padres a_79038_130492# 0.07195f
C1614 a_84598_130212# a_79025_125231# 0
C1615 a_83070_130212# a_82433_130212# 0.00124f
C1616 a_83492_130212# a_83070_130577# 0.00441f
C1617 a_87105_130470# a_87105_130835# 0.09189f
C1618 m2_82112_130096# a_79025_131741# 0
C1619 a_118135_35456# a_118465_35542# 0.03774f
C1620 a_360372_80305# a_360458_80635# 0.03774f
C1621 a_188760_99480# a_189148_99070# 0.00413f
C1622 IOVDD3 a_360458_299755# 0
C1623 a_209480_326377# a_209684_327491# 0
C1624 a_209684_326377# a_209480_327491# 0
C1625 a_191970_329120# a_191438_329719# 0
C1626 a_189858_329327# a_188920_324155# 0
C1627 a_210007_326377# a_208367_327491# 0
C1628 a_189184_328605# a_190722_329719# 0
C1629 user_project_wrapper_0.sg13g2_IOPadIn$1_2.p2c a_208855_324776# 0.08592f
C1630 a_190954_330851# a_191438_329719# 0.00268f
C1631 a_188834_327918# a_190297_329719# 0
C1632 a_189184_325263# a_190824_329719# 0
C1633 a_35456_76015# a_35456_75355# 0.02109f
C1634 a_82859_239842# a_82859_239376# 0.04646f
C1635 a_29836_266461# a_29676_258244# 0.01778f
C1636 a_208103_324155# a_209684_325263# 0.00993f
C1637 m2_81563_127336# a_79025_127401# 0
C1638 a_85977_125209# a_86507_127725# 0
C1639 a_360458_304375# IOVDD3 0
C1640 a_190297_327491# a_189858_327491# 0
C1641 a_191234_327491# a_192738_327798# 0
C1642 a_210109_328605# a_210007_327491# 0.00167f
C1643 w_207989_323975# a_208367_326377# 0.00175f
C1644 w_207887_326203# a_209480_326377# 0.08768f
C1645 a_190501_327491# a_190722_327491# 0.01614f
C1646 a_301075_364458# a_301405_360458# 0.03774f
C1647 a_300745_360372# a_301405_360372# 0.02109f
C1648 a_89114_129061# a_86507_129255# 0.00125f
C1649 a_210007_328605# a_211153_328905# 0
C1650 a_210621_328605# a_211537_329120# 0.0091f
C1651 a_211153_329332# a_211153_329120# 0.01085f
C1652 user_project_wrapper_0.VDD1 a_84707_131750# 0.34653f
C1653 a_208939_328605# a_209684_328605# 0.20478f
C1654 a_210109_325785# a_210007_326377# 0.00167f
C1655 a_114835_35456# a_115165_35542# 0.03774f
C1656 a_83492_127455# a_83164_127820# 0.19718f
C1657 a_86507_127725# a_89114_127896# 0.00587f
C1658 a_35456_305035# a_35456_304375# 0.02109f
C1659 user_project_wrapper_0.sg13g2_IOPadAnalog_17.padres user_project_wrapper_0.analog_io[27] 0.01213f
C1660 VDD3 user_project_wrapper_0.sg13g2_IOPadAnalog_27.padres 1.74533f
C1661 a_190389_99046# a_190218_98097# 0
C1662 a_189729_99046# a_190319_97955# 0.00108f
C1663 user_project_wrapper_0.sg13g2_IOPadAnalog_3.padres VDD3 1.74533f
C1664 a_191751_90558# a_191751_90472# 0.04209f
C1665 a_360372_300085# a_360372_299425# 0.02109f
C1666 w_207887_327938# a_211153_328693# 0.0018f
C1667 user_project_wrapper_0.analog_io[14] QDLL_TOP_0.CPIN 0.8097f
C1668 user_project_wrapper_0.VDD1 a_79025_125231# 1.84458f
C1669 a_304889_198885# a_304090_197941# 0.08643f
C1670 a_296731_208493# a_309516_194555# 0.16937f
C1671 user_project_wrapper_0.sg13g2_IOPadOut4mA$1_1.c2p a_82645_242401# 0
C1672 a_189756_325263# a_191438_326377# 0.00149f
C1673 a_191234_325263# a_188920_324155# 0
C1674 TOP_ROILIFNEURON_0.MEM a_210007_329719# 0
C1675 user_project_wrapper_0.sg13g2_IOPadAnalog_19.padres a_190824_326377# 0
C1676 a_364458_302395# a_360458_302395# 0.03774f
C1677 w_207887_326203# a_213376_328627# 0
C1678 w_207883_330166# a_208469_330241# 0.01323f
C1679 user_project_wrapper_0.sg13g2_IOPadAnalog_22.padres a_208469_328605# 0.00144f
C1680 user_project_wrapper_0.analog_io[15] QDLL_TOP_0.CPIN 0.81961f
C1681 a_210621_326377# a_209684_326377# 0.00396f
C1682 a_210109_327099# a_209480_326377# 0.01814f
C1683 a_85359_125209# a_84332_125209# 0.02247f
C1684 a_209905_327099# a_210007_326377# 0.1023f
C1685 user_project_wrapper_0.IOVDD2 a_303715_35456# 0.01452f
C1686 a_208920_324155# a_208939_326377# 0
C1687 a_364458_75355# a_360458_75355# 0.03774f
C1688 a_298765_39542# a_298765_35542# 0.03774f
C1689 a_190954_330987# a_190501_329719# 0
C1690 a_299095_360458# a_299425_360458# 0.37213f
C1691 a_208939_325263# a_209905_325263# 0.00596f
C1692 a_83164_127820# a_82527_127455# 0.05286f
C1693 a_87434_127896# a_84332_125209# 0.00803f
C1694 a_189921_330987# user_project_wrapper_0.sg13g2_IOPadAnalog_19.padres 0
C1695 user_project_wrapper_0.VDD1 a_88274_127531# 0
C1696 a_39542_300085# a_35542_300085# 0.03774f
C1697 a_213870_324142# user_project_wrapper_0.analog_io[35] 18.3445f
C1698 a_189729_99046# QDLL_TOP_0.VDD 1.37034f
C1699 user_project_wrapper_0.IOVDD1 user_project_wrapper_0.sg13g2_IOPadAnalog_15.padres 1.36563f
C1700 user_project_wrapper_0.IOVDD4 a_304045_360458# 0
C1701 a_360458_77995# IOVDD3 0
C1702 a_79025_137844# a_79025_135674# 0
C1703 a_78219_135283# a_79038_136536# 0.17968f
C1704 a_79038_137002# a_79025_136081# 0
C1705 user_project_wrapper_0.sg13g2_IOPadAnalog_13.padres a_56308_263818# 0.0512f
C1706 a_79025_138251# a_79038_134832# 0
C1707 a_78655_364458# a_79315_364458# 0.02109f
C1708 a_82348_128838# a_79025_136081# 0.04731f
C1709 w_188704_327938# a_190824_329719# 0
C1710 w_188700_330166# a_191234_329719# 0.22214f
C1711 a_78824_128711# a_79025_129164# 1.02588f
C1712 a_89114_129426# a_89953_129061# 0.08108f
C1713 a_82348_128838# a_82658_129203# 0.06864f
C1714 a_87434_129426# a_83492_127455# 0.17698f
C1715 a_86594_129426# a_86507_127725# 0
C1716 a_208939_329719# a_208367_329719# 0.92013f
C1717 a_83079_128838# a_83389_129203# 0.06746f
C1718 user_project_wrapper_0.sg13g2_IOPadAnalog_21.padres a_208367_329719# 0.01189f
C1719 user_project_wrapper_0.uo_PAD[3] user_project_wrapper_0.sg13g2_IOPadOut4mA$1_0.sg13g2_GateLevelUpInv_noptap$1$1_0.pgate 2.57975f
C1720 a_190319_102855# a_190389_101343# 0
C1721 a_302065_35542# a_302395_35542# 0.37213f
C1722 a_364458_73375# IOVDD3 0.01409f
C1723 a_190501_326377# a_190297_326377# 0.83555f
C1724 a_189184_326377# a_190824_326377# 0.3836f
C1725 a_189184_329719# a_190501_329719# 0.69987f
C1726 user_project_wrapper_0.sg13g2_IOPadAnalog_8.padres a_79038_132196# 0.01719f
C1727 user_project_wrapper_0.sg13g2_IOPadIn$1_2.p2c user_project_wrapper_0.analog_io[30] 0.96331f
C1728 a_117475_35456# a_117805_35542# 0.03774f
C1729 a_79038_130026# a_79025_125231# 0
C1730 a_84598_130577# a_82433_130212# 0
C1731 m1_81998_130507# a_79025_131741# 0
C1732 a_360372_80965# a_360458_81295# 0.03774f
C1733 user_project_wrapper_0.sg13g2_IOPadAnalog_19.padres a_188834_326341# 5.11512f
C1734 user_project_wrapper_0.sg13g2_IOPadAnalog_20.padres user_project_wrapper_0.analog_io[32] 0.33115f
C1735 user_project_wrapper_0.IOVDD4 user_project_wrapper_0.sg13g2_IOPadVdd_3.sg13g2_RCClampResistor_0.p2 68.8754f
C1736 a_41476_197044# user_project_wrapper_0.analog_io[4] 25.1197f
C1737 a_208939_325263# a_210109_326377# 0.00166f
C1738 a_360458_76015# VDD3 0
C1739 a_355784_205261# IOVDD3 1.92793f
C1740 a_211921_328225# a_211921_328693# 0.00322f
C1741 user_project_wrapper_0.analog_io[30] a_194193_328627# 0.00548f
C1742 a_192309_90557# QDLL_TOP_0.CPIN 0
C1743 a_305619_211562# user_project_wrapper_0.sg13g2_IOPadAnalog_26.padres 0.16155f
C1744 a_82872_125209# a_79025_131741# 0
C1745 user_project_wrapper_0.sg13g2_IOPadIn$1_2.p2c a_209638_324119# 0.00251f
C1746 a_35456_76675# a_35456_76015# 0.02109f
C1747 a_82118_240839# a_82645_240231# 0.00561f
C1748 a_79025_127401# user_project_wrapper_0.sg13g2_IOPadAnalog_8.padres 0.1112f
C1749 m1_82116_130103# a_79025_127401# 0.00154f
C1750 a_210417_327491# a_210621_327491# 0.43471f
C1751 a_87851_125174# a_86507_127725# 0.04874f
C1752 a_360458_305695# IOVDD3 0
C1753 user_project_wrapper_0.sg13g2_IOPadAnalog_15.padres user_project_wrapper_0.analog_io[5] 0.33115f
C1754 a_83398_130212# user_project_wrapper_0.sg13g2_IOPadIn$1_0.p2c 0.00598f
C1755 w_188704_326203# a_190926_327099# 0
C1756 a_364458_298435# a_360458_298435# 0.03774f
C1757 a_82658_128838# a_79025_133911# 0.00363f
C1758 a_209480_328605# a_211153_329120# 0
C1759 user_project_wrapper_0.VDD1 a_79025_133911# 1.93879f
C1760 a_208469_325785# a_206547_324106# 0
C1761 TOP_ROILIFNEURON_0.MEM a_211153_328225# 0.00105f
C1762 a_114175_35456# a_114505_35542# 0.03774f
C1763 a_79025_129164# a_79038_127856# 0.71261f
C1764 a_92512_129426# a_93400_129062# 0.00545f
C1765 user_project_wrapper_0.VDD1 a_91911_129060# 0.28965f
C1766 TOP_ROILIFNEURON_0.MEM a_211537_329332# 0.00168f
C1767 a_83050_125173# a_79025_125231# 0.00166f
C1768 VDD3 a_343292_243418# 0
C1769 a_314793_197200# VDD3 0.68895f
C1770 a_190638_90558# a_190638_90472# 0.04209f
C1771 a_185968_102197# user_project_wrapper_0.analog_io[13] 0.5588f
C1772 TOP_ROILIFNEURON_0.MEM a_190954_330987# 0
C1773 a_188802_330987# a_188888_330987# 0.05224f
C1774 user_project_wrapper_0.VDD1 user_project_wrapper_0.sg13g2_IOPadOut4mA$1_0.c2p 7.95564f
C1775 TOP_ROILIFNEURON_0.MEM a_211921_325570# 0.00567f
C1776 a_189184_325263# a_190824_326377# 0
C1777 a_188834_326341# a_189184_326377# 0.14732f
C1778 a_189756_325263# a_190501_326377# 0.02221f
C1779 a_188834_327918# a_190297_326377# 0
C1780 user_project_wrapper_0.sg13g2_IOPadAnalog_17.padres a_189756_326377# 0.00534f
C1781 a_88291_125210# a_88393_125210# 0.3522f
C1782 a_91911_129060# user_project_wrapper_0.sg13g2_IOPadIn$1_1.p2c 0.00766f
C1783 user_project_wrapper_0.sg13g2_IOPadAnalog_21.padres a_210007_327491# 0
C1784 a_364458_303055# a_360458_303055# 0.03774f
C1785 a_211153_325785# a_211153_325570# 0.01056f
C1786 a_355624_237844# IOVDD3 58.9173f
C1787 a_208367_329719# a_210007_328605# 0
C1788 a_208939_329719# a_210417_328605# 0
C1789 a_208939_325263# a_209041_329327# 0
C1790 user_project_wrapper_0.VDD1 a_56308_223018# 0
C1791 a_87627_124843# a_84332_125209# 0.07161f
C1792 a_78220_123062# user_project_wrapper_0.VDD1 0.36571f
C1793 user_project_wrapper_0.IOVDD2 a_302395_35456# 0.01567f
C1794 a_209940_324686# a_206547_324106# 0
C1795 user_project_wrapper_0.sg13g2_IOPadOut4mA$1_0.c2p user_project_wrapper_0.sg13g2_IOPadIn$1_1.p2c 0.02017f
C1796 a_188888_330987# a_188834_327918# 0
C1797 a_188802_330987# a_189756_325263# 0
C1798 a_364458_76015# a_360458_76015# 0.03774f
C1799 a_298105_39542# a_298105_35542# 0.03774f
C1800 a_298435_360458# a_298765_360458# 0.37213f
C1801 user_project_wrapper_0.sg13g2_IOPadAnalog_21.padres w_207989_323975# 0.00149f
C1802 a_86594_127896# a_89114_127896# 0
C1803 a_88274_127896# a_87434_127896# 0.1009f
C1804 a_211153_327104# a_210621_327491# 0
C1805 user_project_wrapper_0.VDD1 a_91090_127895# 0.4969f
C1806 a_39542_300745# a_35542_300745# 0.03774f
C1807 user_project_wrapper_0.IOVDD4 a_302725_360458# 0
C1808 a_185968_98275# QDLL_TOP_0.VDD 0.99451f
C1809 user_project_wrapper_0.sg13g2_IOPadIn$1_2.p2c a_190455_324119# 0.00617f
C1810 a_355624_217444# analog_io[23] 25.1197f
C1811 w_188704_326203# user_project_wrapper_0.sg13g2_IOPadAnalog_19.padres 0.04693f
C1812 a_360458_79315# IOVDD3 0
C1813 a_77995_364458# a_78655_364458# 0.02109f
C1814 a_78218_138281# a_78219_135283# 0
C1815 a_78824_137391# a_79025_137844# 1.02588f
C1816 a_190287_98223# QDLL_TOP_0.CPIN 0
C1817 a_79038_130026# a_79025_133911# 0.00192f
C1818 a_75025_360372# a_75355_360458# 0.03774f
C1819 a_209480_325263# a_208939_326377# 0
C1820 a_191970_325785# a_191438_326377# 0
C1821 a_209684_325263# a_208367_326377# 0
C1822 w_207887_326203# a_209905_326377# 0.01266f
C1823 a_87434_129426# a_89114_129426# 0.05056f
C1824 a_79025_129571# a_83079_128838# 0
C1825 user_project_wrapper_0.sg13g2_IOPadAnalog_22.padres a_208017_327918# 4.08351f
C1826 a_301575_211562# VDD3 0.07851f
C1827 a_208367_325263# a_208017_327918# 0.17497f
C1828 a_211921_325570# a_208855_324776# 0
C1829 user_project_wrapper_0.sg13g2_IOPadAnalog_9.padres a_78824_130881# 0.07869f
C1830 a_91090_127895# user_project_wrapper_0.sg13g2_IOPadIn$1_1.p2c 0.02026f
C1831 a_191970_330241# a_191970_330026# 0.01056f
C1832 a_301405_35542# a_301735_35542# 0.37213f
C1833 user_project_wrapper_0.VDD1 a_82859_239376# 0.09349f
C1834 user_project_wrapper_0.sg13g2_IOPadAnalog_17.padres a_187018_328627# 0.00132f
C1835 a_189286_325785# a_189184_327491# 0.00146f
C1836 a_189858_325785# a_189756_327491# 0.00173f
C1837 a_189184_325263# a_188834_326341# 0.11794f
C1838 a_188834_327918# a_189756_325263# 0.0024f
C1839 user_project_wrapper_0.IOVDD2 a_298435_35542# 0
C1840 user_project_wrapper_0.sg13g2_IOPadAnalog_8.padres a_78219_134797# 0.00431f
C1841 user_project_wrapper_0.IOVDD1 a_35542_74365# 0
C1842 user_project_wrapper_0.IOVDD4 a_80305_360372# 0.01881f
C1843 TOP_ROILIFNEURON_0.MEM a_192354_325358# 0.00168f
C1844 a_360458_77335# VDD3 0
C1845 a_209905_327491# a_209905_328013# 0
C1846 user_project_wrapper_0.sg13g2_IOPadAnalog_21.padres a_208855_324776# 0
C1847 a_343292_141418# VDD3 0
C1848 a_35456_77335# a_35456_76675# 0.02109f
C1849 user_project_wrapper_0.sg13g2_IOPadIn$1_1.p2c a_82859_239376# 0.00852f
C1850 a_58170_281951# user_project_wrapper_0.sg13g2_IOPadOut4mA$1_1.c2p 0.12494f
C1851 a_82846_241091# a_82118_240839# 0
C1852 a_208367_327491# a_208469_328013# 0.22524f
C1853 a_208939_327491# a_209041_328013# 0.22162f
C1854 a_209684_327491# a_210417_327491# 0.00663f
C1855 a_209480_327491# a_210007_327491# 0.20173f
C1856 a_85211_124842# a_83492_127455# 0
C1857 TOP_ROILIFNEURON_0.MEM a_211921_327586# 0.00497f
C1858 w_188704_326203# a_189184_326377# 0.32606f
C1859 a_364458_299095# a_360458_299095# 0.03774f
C1860 a_210007_328605# a_210007_327491# 0.02415f
C1861 w_188704_327938# a_190824_326377# 0
C1862 w_188806_323975# a_187364_324106# 0.055f
C1863 a_189756_327491# a_190722_328013# 0.01267f
C1864 a_211537_327104# a_211537_326892# 0.01085f
C1865 a_210007_328605# a_210417_328605# 0.15379f
C1866 a_209480_328605# a_208469_329327# 0
C1867 a_191462_324119# a_191438_326377# 0
C1868 a_191124_324119# a_189672_324776# 0.22365f
C1869 user_project_wrapper_0.sg13g2_IOPadAnalog_21.padres a_211170_331343# 0
C1870 user_project_wrapper_0.VDD1 a_79038_136536# 0.09632f
C1871 TOP_ROILIFNEURON_0.MEM a_209480_327491# 0
C1872 a_309917_199879# a_311846_195517# 3.0626f
C1873 a_296731_189665# user_project_wrapper_0.sg13g2_IOPadAnalog_29.padres 0.39488f
C1874 a_86594_129426# a_86594_127896# 0.00169f
C1875 a_83079_128838# a_83389_128838# 0.00441f
C1876 a_78824_128711# a_79038_128322# 0.05038f
C1877 a_89953_129061# a_92512_129061# 0.01108f
C1878 a_83492_127455# a_91090_129060# 0
C1879 a_86507_127725# a_88274_129061# 0
C1880 a_299425_39542# a_299755_35542# 0.03774f
C1881 a_299095_35456# a_299755_35456# 0.02109f
C1882 user_project_wrapper_0.VDD1 a_83389_129203# 0.40754f
C1883 a_305365_360372# user_project_wrapper_0.IOVDD4 0.02119f
C1884 a_79025_126994# a_79025_125231# 0.09651f
C1885 TOP_ROILIFNEURON_0.MEM a_210007_328605# 0
C1886 a_188834_326341# a_189286_325263# 0
C1887 a_189756_325263# a_189858_325263# 0.1039f
C1888 w_207887_327938# a_209041_328013# 0.01302f
C1889 user_project_wrapper_0.IOVDD1 a_58798_179249# 0.07576f
C1890 user_project_wrapper_0.IOVDD1 a_39542_298105# 0.04966f
C1891 a_82974_125209# m2_83010_126180# 0.00109f
C1892 a_189524_90558# a_189524_90472# 0.04209f
C1893 w_207887_327938# a_209905_329327# 0
C1894 a_211170_331163# TOP_ROILIFNEURON_0.MEM 0.03818f
C1895 a_305619_187719# VDD3 0.00664f
C1896 user_project_wrapper_0.VDD1 a_57810_281517# 0.00573f
C1897 TOP_ROILIFNEURON_0.MEM w_188806_323975# 0.12847f
C1898 a_190868_330987# w_188700_330166# 0
C1899 a_182931_326125# a_187364_324106# 0.0106f
C1900 TOP_ROILIFNEURON_0.MEM a_211153_325997# 0.00105f
C1901 w_207887_326203# a_211921_325997# 0.0018f
C1902 a_85211_124842# a_88393_125210# 0
C1903 a_85875_125209# a_85977_125209# 0.3522f
C1904 user_project_wrapper_0.sg13g2_IOPadAnalog_22.padres a_208939_327491# 0.00899f
C1905 user_project_wrapper_0.sg13g2_IOPadIn$1_1.sg13g2_LevelDown_noptap$1_0.sg13g2_SecondaryProtection$1$1_0.core user_project_wrapper_0.ui_PAD[9] 0.02881f
C1906 a_79645_360372# user_project_wrapper_0.IOVDD4 0.01881f
C1907 a_39542_304045# a_39542_303385# 0.02109f
C1908 a_208367_325263# a_208939_327491# 0.00125f
C1909 a_364458_303715# a_360458_303715# 0.03774f
C1910 a_210621_325263# a_211921_325997# 0
C1911 a_189184_328605# a_189756_327491# 0.01817f
C1912 user_project_wrapper_0.sg13g2_IOPadAnalog_19.padres a_189286_327491# 0.00111f
C1913 a_82872_125209# a_84332_125209# 0
C1914 a_87468_125419# a_87434_127896# 0
C1915 TOP_ROILIFNEURON_0.MEM a_192738_328905# 0.00699f
C1916 a_85359_125209# user_project_wrapper_0.VDD1 0.14011f
C1917 a_208071_331163# a_208367_329719# 0
C1918 a_208871_330987# a_208939_329719# 0
C1919 a_209104_331163# a_208939_325263# 0
C1920 user_project_wrapper_0.IOVDD2 a_301075_35456# 0.01563f
C1921 user_project_wrapper_0.sg13g2_IOPadAnalog_8.padres a_82846_240684# 0.03277f
C1922 user_project_wrapper_0.sg13g2_IOPadAnalog_22.padres w_207887_327938# 0.05803f
C1923 a_364458_76675# a_360458_76675# 0.03774f
C1924 w_207887_327938# a_208367_325263# 0.01615f
C1925 w_207883_330166# a_208017_327918# 0.08617f
C1926 a_191987_330987# a_191987_330851# 0.29305f
C1927 a_122095_35456# a_122425_35542# 0.03774f
C1928 user_project_wrapper_0.sg13g2_IOPadOut4mA$1_1.sg13g2_GateLevelUpInv_noptap$1$1_0.ngate a_57810_281517# 0.24368f
C1929 a_192354_325570# a_192354_325358# 0.01085f
C1930 a_297775_360458# a_298105_360458# 0.37213f
C1931 a_78220_128192# a_78220_128106# 0.01455f
C1932 a_79038_128322# a_79038_127856# 0.04646f
C1933 a_208367_325263# a_209905_325785# 0.00571f
C1934 a_208939_325263# a_208469_325785# 0
C1935 a_217444_355624# user_project_wrapper_0.IOVDD4 58.9173f
C1936 w_188704_326203# a_189184_325263# 0.27297f
C1937 w_188700_330166# user_project_wrapper_0.sg13g2_IOPadAnalog_17.padres 0.03586f
C1938 user_project_wrapper_0.VDD1 a_87434_127896# 0.4334f
C1939 w_188704_327938# a_188834_326341# 0.17587f
C1940 w_188700_330166# a_189756_329719# 0.21627f
C1941 a_39542_301405# a_35542_301405# 0.03774f
C1942 IOVDD3 analog_io[25] 0.10967p
C1943 user_project_wrapper_0.IOVDD4 a_301405_360458# 0
C1944 a_360458_80635# IOVDD3 0
C1945 user_project_wrapper_0.IOVDD2 a_286861_41636# 1.92793f
C1946 a_77335_364458# a_77995_364458# 0.02109f
C1947 TOP_ROILIFNEURON_0.MEM a_210621_326377# 0.121f
C1948 a_191438_325263# a_191438_326377# 0.04294f
C1949 a_360458_74365# a_360372_74365# 0.03774f
C1950 a_364458_74035# a_364458_74695# 0.02109f
C1951 a_74365_360372# a_74695_360458# 0.03774f
C1952 TOP_ROILIFNEURON_0.MEM a_211928_324776# 0.55512f
C1953 user_project_wrapper_0.sg13g2_IOPadAnalog_22.padres user_project_wrapper_0.analog_io[35] 7.1207f
C1954 a_192354_328905# a_192354_328693# 0.01085f
C1955 a_311108_215937# VDD3 14.6157f
C1956 w_207989_323975# a_211928_324776# 0.13438f
C1957 a_211153_325997# a_208855_324776# 0
C1958 a_191975_108496# a_191975_108410# 0.04185f
C1959 a_190218_102763# user_project_wrapper_0.sg13g2_IOPadAnalog_6.padres 0.02946f
C1960 a_188572_99046# QDLL_TOP_0.VOUT 0.00185f
C1961 a_305035_364458# a_305035_360458# 0.03774f
C1962 user_project_wrapper_0.sg13g2_IOPadAnalog_9.padres a_79025_133504# 0.32292f
C1963 user_project_wrapper_0.sg13g2_IOPadAnalog_17.padres a_189286_328605# 0.00144f
C1964 a_189756_325263# a_190722_328605# 0.00191f
C1965 a_188834_326341# a_189858_328605# 0.01847f
C1966 user_project_wrapper_0.VDD1 a_86407_241748# 0.13303f
C1967 a_300745_35542# a_301075_35542# 0.37213f
C1968 a_191438_329719# a_191970_330241# 0.00381f
C1969 a_182931_326125# a_186202_326221# 4.49535f
C1970 a_211921_327798# a_211921_327586# 0.01085f
C1971 user_project_wrapper_0.IOVDD2 a_121765_35542# 0
C1972 user_project_wrapper_0.sg13g2_IOPadAnalog_8.padres a_79038_137002# 0.06942f
C1973 a_211170_331163# a_211170_331343# 0.12339f
C1974 a_190868_330987# a_190954_331343# 0.00565f
C1975 user_project_wrapper_0.sg13g2_IOPadAnalog_19.padres a_189921_330851# 0
C1976 TOP_ROILIFNEURON_0.MEM a_191970_325570# 0.00105f
C1977 user_project_wrapper_0.IOVDD1 a_35542_75685# 0
C1978 a_360458_78655# VDD3 0
C1979 a_208017_327918# a_208469_327099# 0.00138f
C1980 a_208469_327491# a_209684_327491# 0
C1981 a_211537_327798# a_210007_327491# 0
C1982 a_209905_327491# a_208939_327491# 0.00596f
C1983 a_211153_327798# a_210417_327491# 0
C1984 a_190297_328605# a_190297_329719# 0.03801f
C1985 a_190501_328605# a_190824_329719# 0
C1986 a_189184_326377# a_189286_327491# 0
C1987 a_39542_79645# a_35542_79645# 0.03774f
C1988 user_project_wrapper_0.VDD2 a_121105_35542# 0
C1989 user_project_wrapper_0.IOVDD1 a_35542_304705# 0
C1990 a_210007_325263# a_211153_325570# 0
C1991 a_209480_325263# a_211537_325570# 0
C1992 a_35456_77995# a_35456_77335# 0.02109f
C1993 a_86046_241645# a_86970_241383# 0.01284f
C1994 a_85989_241383# a_82846_241091# 0.13272f
C1995 user_project_wrapper_0.IOVDD1 a_41636_144061# 1.92793f
C1996 TOP_ROILIFNEURON_0.MEM a_211537_327798# 0.01055f
C1997 a_364458_299755# a_360458_299755# 0.03774f
C1998 w_207887_327938# a_209905_327491# 0
C1999 user_project_wrapper_0.analog_io[15] a_237844_29676# 9.69836f
C2000 user_project_wrapper_0.sg13g2_IOPadAnalog_22.padres a_207638_331343# 0.0141f
C2001 a_364458_74035# VDD3 0.00157f
C2002 a_211928_324776# a_208855_324776# 0.42043f
C2003 a_79038_123516# user_project_wrapper_0.sg13g2_IOPadAnalog_9.padres 0
C2004 user_project_wrapper_0.VDD1 a_78218_138281# 0.03121f
C2005 a_296625_189595# a_296731_189665# 16.6941f
C2006 a_211537_330241# a_211537_330026# 0.01056f
C2007 a_301423_196360# a_301509_196360# 0.04805f
C2008 a_307232_196607# user_project_wrapper_0.sg13g2_IOPadAnalog_29.padres 0.02729f
C2009 a_189921_331343# a_189184_329719# 0
C2010 a_208017_326341# a_209480_325263# 0
C2011 a_208939_325263# a_210007_325263# 0.01814f
C2012 a_79025_129571# a_82658_128838# 0.02301f
C2013 user_project_wrapper_0.VDD1 a_79025_129571# 1.66129f
C2014 user_project_wrapper_0.sg13g2_IOPadAnalog_21.padres a_209684_325263# 0
C2015 a_313884_185173# a_311189_185546# 7.71569f
C2016 user_project_wrapper_0.IOVDD1 a_39542_299425# 0.01899f
C2017 a_209041_325785# a_208939_327491# 0.00173f
C2018 a_208469_325785# a_208367_327491# 0.00146f
C2019 a_188408_90558# a_188408_90472# 0.04209f
C2020 a_190954_331163# a_190868_330987# 0.02034f
C2021 a_209904_331163# a_210137_331163# 0.01498f
C2022 a_189756_327491# a_188920_324155# 0.74832f
C2023 a_35456_81295# user_project_wrapper_0.VDD1 0.00177f
C2024 TOP_ROILIFNEURON_0.MEM a_192745_324776# 0.55512f
C2025 user_project_wrapper_0.VDD1 m2_82112_130096# 0.00735f
C2026 a_83490_125209# a_83592_125209# 0.3522f
C2027 a_82826_124842# a_85977_125209# 0
C2028 user_project_wrapper_0.sg13g2_IOPadIn$1_0.p2c a_83164_127820# 0.00835f
C2029 a_85875_125209# a_87851_125174# 0
C2030 a_87468_125419# a_87627_124843# 0.16543f
C2031 a_78325_360372# user_project_wrapper_0.IOVDD4 0.01881f
C2032 a_364458_304375# a_360458_304375# 0.03774f
C2033 a_189858_326377# a_190824_326377# 0
C2034 a_190926_326377# a_190501_326377# 0.00499f
C2035 a_191970_326677# a_189184_326377# 0
C2036 TOP_ROILIFNEURON_0.MEM a_192354_329120# 0.01055f
C2037 user_project_wrapper_0.IOVDD2 a_299755_35456# 0.01452f
C2038 a_87627_124843# user_project_wrapper_0.VDD1 0.82189f
C2039 user_project_wrapper_0.sg13g2_IOPadAnalog_8.padres a_82859_241546# 0.0431f
C2040 a_121435_35542# a_121765_35542# 0.37213f
C2041 a_188802_330987# a_188888_330851# 0.00843f
C2042 TOP_ROILIFNEURON_0.MEM a_191987_330851# 0.00766f
C2043 a_364458_77335# a_360458_77335# 0.03774f
C2044 a_192738_325785# a_192738_325570# 0.01056f
C2045 a_208469_327099# a_208939_327491# 0
C2046 user_project_wrapper_0.VDD1 user_project_wrapper_0.sg13g2_IOPadAnalog_13.padres 1.74533f
C2047 user_project_wrapper_0.VDD1 a_83389_128838# 0
C2048 a_115444_355624# user_project_wrapper_0.IOVDD4 58.9173f
C2049 w_207883_330166# a_210137_330851# 0.05936f
C2050 IOVDD3 a_369296_278644# 0.16358f
C2051 a_39542_302065# a_35542_302065# 0.03774f
C2052 user_project_wrapper_0.IOVDD1 a_41476_237844# 58.9173f
C2053 a_76675_364458# a_77335_364458# 0.02109f
C2054 user_project_wrapper_0.IOVDD2 a_205261_41636# 1.92793f
C2055 user_project_wrapper_0.sg13g2_IOPadAnalog_6.padres a_188296_99070# 0.00159f
C2056 TOP_ROILIFNEURON_0.MEM a_192738_326677# 0.00707f
C2057 a_82118_239118# user_project_wrapper_0.analog_io[4] 0.01116f
C2058 user_project_wrapper_0.IOVDD2 user_project_wrapper_0.analog_io[12] 0.10967p
C2059 a_73705_360372# a_74035_360458# 0.03774f
C2060 a_369296_135844# a_369456_144061# 0.01778f
C2061 a_79038_130026# a_79025_129571# 0.03011f
C2062 a_278644_369296# user_project_wrapper_0.analog_io[35] 9.69836f
C2063 a_84598_130577# a_88274_129426# 0.0044f
C2064 w_188704_326203# a_192738_326465# 0.0018f
C2065 a_190862_108496# a_190862_108410# 0.04185f
C2066 a_192738_329120# a_192738_328905# 0.01056f
C2067 w_207887_326203# a_209869_324119# 0
C2068 a_304375_364458# a_304375_360458# 0.03774f
C2069 w_207989_323975# a_209230_324119# 0.21114f
C2070 user_project_wrapper_0.sg13g2_IOPadAnalog_9.padres a_78824_135221# 0.07869f
C2071 a_189184_329719# a_190722_329327# 0
C2072 a_189756_329719# a_190926_329327# 0
C2073 a_79025_129164# user_project_wrapper_0.sg13g2_IOPadAnalog_9.padres 0.32292f
C2074 a_190297_329719# a_192354_330026# 0
C2075 a_190824_329719# a_191970_330026# 0
C2076 a_300085_35542# a_300415_35542# 0.37213f
C2077 a_188888_330851# a_188834_327918# 0.00318f
C2078 user_project_wrapper_0.IOVDD2 a_120445_35542# 0
C2079 a_57810_180219# user_project_wrapper_0.VDD1 0.00549f
C2080 user_project_wrapper_0.IOVDD1 a_35542_77005# 0
C2081 TOP_ROILIFNEURON_0.MEM a_192738_325997# 0.00499f
C2082 a_74695_360458# user_project_wrapper_0.IOVDD4 0
C2083 user_project_wrapper_0.sg13g2_IOPadVdd_0.sg13g2_RCClampInverter_noptap_0.out VDD3 0.10089p
C2084 QDLL_TOP_0.VOUT user_project_wrapper_0.IOVDD2 0.10967p
C2085 a_360458_79975# VDD3 0
C2086 user_project_wrapper_0.sg13g2_IOPadAnalog_22.padres a_208171_324119# 0
C2087 a_39542_80305# a_35542_80305# 0.03774f
C2088 user_project_wrapper_0.VDD2 a_119785_35542# -0
C2089 a_208367_325263# a_208171_324119# 0.00114f
C2090 w_207887_326203# a_209480_325263# 0.08768f
C2091 a_35456_79315# a_35542_79315# 0.03774f
C2092 a_189756_325263# a_190722_326377# 0.00236f
C2093 a_39542_79645# a_39542_78985# 0.02109f
C2094 a_188834_326341# a_189858_326377# 0.02103f
C2095 a_208939_328605# a_208469_328605# 0
C2096 a_209684_328605# a_211537_329120# 0
C2097 a_209480_325263# a_210621_325263# 0.00342f
C2098 a_210007_325263# a_210109_325785# 0.22366f
C2099 a_35456_78655# a_35456_77995# 0.02109f
C2100 a_85287_241383# a_85591_241748# 0.07713f
C2101 user_project_wrapper_0.sg13g2_IOPadAnalog_6.padres a_190319_97955# 0.10704f
C2102 a_360458_81625# IOVDD3 0
C2103 a_192738_327798# a_192738_327586# 0.01085f
C2104 a_209230_324119# a_208855_324776# 0.32537f
C2105 a_190047_324119# a_187364_324106# 0.29565f
C2106 a_189396_324119# a_189184_326377# 0
C2107 a_189609_324119# a_189756_326377# 0.00128f
C2108 user_project_wrapper_0.VDD1 a_35542_73375# 0.06211f
C2109 a_307232_196607# a_296625_189595# 0.05151f
C2110 TOP_ROILIFNEURON_0.MEM a_191970_328013# 0.00105f
C2111 a_209480_329719# a_211537_329814# 0
C2112 a_309516_194555# a_314697_196700# 0.53087f
C2113 a_304889_199957# a_304196_197873# 0.13697f
C2114 a_300415_364458# a_300745_360458# 0.03774f
C2115 a_300085_360372# a_300745_360372# 0.02109f
C2116 a_209940_324686# a_210983_324119# 0
C2117 a_210307_324119# a_210645_324119# 0.18289f
C2118 a_209869_324119# a_211321_324119# 0
C2119 a_208792_324119# a_208920_324155# 0.2103f
C2120 a_311108_215937# a_311189_211724# 1.46297f
C2121 user_project_wrapper_0.VDD1 a_87105_130470# 0
C2122 a_189756_325263# a_190926_325785# 0.00142f
C2123 a_189184_325263# a_191970_325997# 0
C2124 user_project_wrapper_0.IOVDD1 a_39542_300745# 0.02119f
C2125 a_82667_125418# m2_83010_126180# 0
C2126 a_186731_92558# a_187852_90557# 0
C2127 user_project_wrapper_0.sg13g2_IOPadAnalog_19.padres a_190297_325263# 0.00824f
C2128 a_187294_90558# a_187294_90472# 0.04209f
C2129 a_208071_331163# a_208871_330987# 0.01602f
C2130 a_188888_331163# a_188802_330987# 0.02034f
C2131 analog_io[26] a_369296_278644# 9.69836f
C2132 user_project_wrapper_0.VDD1 a_82859_242012# 0.10213f
C2133 user_project_wrapper_0.sg13g2_IOPadIn$1_2.p2c a_208103_324155# 0.0353f
C2134 a_85127_131750# a_86507_129255# 0.20426f
C2135 user_project_wrapper_0.VDD1 m1_81998_130507# 0.05571f
C2136 a_85211_124842# a_85435_125173# 0.04241f
C2137 a_85052_125418# a_85257_125209# 0.03571f
C2138 a_210417_325263# a_210645_324119# 0.00788f
C2139 w_188704_326203# a_190757_324686# 0
C2140 w_188806_323975# a_190455_324119# 0.10005f
C2141 a_77005_360372# user_project_wrapper_0.IOVDD4 0.01881f
C2142 user_project_wrapper_0.sg13g2_IOPadAnalog_6.padres QDLL_TOP_0.VDD 4.99658f
C2143 a_364458_305035# a_360458_305035# 0.03774f
C2144 a_189756_325263# a_191438_327491# 0.00116f
C2145 a_305365_39542# a_305695_35542# 0.03774f
C2146 a_305035_35456# a_305695_35456# 0.02109f
C2147 a_78221_125094# a_78220_128106# 0.00725f
C2148 a_79038_126152# a_79038_127856# 0.00178f
C2149 a_191970_327104# a_190297_326377# 0
C2150 a_192354_327104# a_190501_326377# 0
C2151 a_79025_125231# a_79038_130492# 0
C2152 a_84288_130212# a_85127_131750# 0
C2153 a_82872_125209# user_project_wrapper_0.VDD1 0.20083f
C2154 user_project_wrapper_0.IOVDD4 user_project_wrapper_0.analog_io[32] 0.10967p
C2155 user_project_wrapper_0.IOVDD2 a_116485_35542# 0
C2156 QDLL_TOP_0.VDD a_269543_100118# 0.27093f
C2157 IOVDD3 a_355624_156244# 58.9173f
C2158 user_project_wrapper_0.sg13g2_IOPadAnalog_8.padres a_85287_241383# 0.00263f
C2159 a_120775_35542# a_121105_35542# 0.37213f
C2160 a_211084_330987# a_211170_330987# 0.01578f
C2161 a_364458_77995# a_360458_77995# 0.03774f
C2162 a_188888_331163# a_188834_327918# 0
C2163 TOP_ROILIFNEURON_0.MEM a_210051_330987# 0.07377f
C2164 user_project_wrapper_0.IOVDD1 user_project_wrapper_0.sg13g2_IOPadIn$1_0.sg13g2_LevelDown_noptap$1_0.sg13g2_SecondaryProtection$1$1_0.core 1.37355f
C2165 user_project_wrapper_0.VDD2 a_115825_35542# 0
C2166 user_project_wrapper_0.VDD1 a_87434_129061# 0
C2167 w_188700_330166# a_190954_330851# 0.05936f
C2168 a_39542_302725# a_35542_302725# 0.03774f
C2169 a_189184_325263# a_189396_324119# 0
C2170 a_188834_327918# a_189756_328605# 0.00999f
C2171 a_76015_364458# a_76675_364458# 0.02109f
C2172 a_79025_125231# a_83925_130212# 0.00815f
C2173 a_82433_130212# a_83796_129203# 0.00503f
C2174 a_190501_329719# a_190722_329719# 0.01614f
C2175 TOP_ROILIFNEURON_0.MEM a_192354_326892# 0.01052f
C2176 a_35542_73705# a_35542_73375# 0.37213f
C2177 a_190824_325263# a_189756_326377# 0
C2178 a_190297_325263# a_189184_326377# 0.00184f
C2179 a_190501_325263# a_190501_326377# 0.00874f
C2180 w_188704_326203# a_189858_326377# 0.01325f
C2181 a_191438_328605# a_191970_328905# 0.00381f
C2182 a_189748_108496# a_189748_108410# 0.04185f
C2183 a_303715_364458# a_303715_360458# 0.03774f
C2184 user_project_wrapper_0.analog_io[15] a_190584_102855# 0.00848f
C2185 a_89114_127531# a_86507_129255# 0.00124f
C2186 user_project_wrapper_0.sg13g2_IOPadAnalog_22.padres a_207985_330987# 0.06845f
C2187 a_189756_327491# a_190501_327491# 0.20572f
C2188 a_207985_330987# a_208367_325263# 0
C2189 user_project_wrapper_0.sg13g2_IOPadAnalog_17.padres a_189184_328605# 0.19304f
C2190 a_188834_327918# a_190824_328605# 0
C2191 a_188834_326341# a_190501_328605# 0
C2192 a_189756_325263# a_190297_328605# 0.02206f
C2193 a_189756_329719# a_189184_328605# 0.00803f
C2194 a_299425_35542# a_299755_35542# 0.37213f
C2195 a_191196_92557# user_project_wrapper_0.analog_io[13] 0.00542f
C2196 a_202114_326125# a_206201_328627# 0.09942f
C2197 a_190824_329719# a_191438_329719# 0.01253f
C2198 a_208103_324155# a_208367_326377# 0.07054f
C2199 a_211921_328225# a_211921_328013# 0.01085f
C2200 user_project_wrapper_0.IOVDD2 a_119125_35542# 0
C2201 a_176644_369296# user_project_wrapper_0.analog_io[30] 9.69836f
C2202 a_39542_79645# user_project_wrapper_0.IOVDD1 0.01881f
C2203 a_29836_123661# a_29676_115444# 0.01778f
C2204 a_78220_128592# user_project_wrapper_0.sg13g2_IOPadAnalog_8.padres 0.00431f
C2205 user_project_wrapper_0.IOVDD1 a_35542_78325# 0
C2206 a_73375_360458# user_project_wrapper_0.IOVDD4 0
C2207 TOP_ROILIFNEURON_0.MEM a_191234_325263# 0.00568f
C2208 a_208367_328605# a_209041_328013# 0.00156f
C2209 a_360458_81295# VDD3 0
C2210 a_208939_325263# a_210417_326377# 0.00216f
C2211 a_39542_80965# a_35542_80965# 0.03774f
C2212 user_project_wrapper_0.VDD2 a_118465_35542# -0
C2213 w_188704_326203# a_190722_325785# 0.01266f
C2214 a_208367_328605# a_209905_329327# 0.01977f
C2215 a_209684_328605# a_209041_329327# 0
C2216 m1_85051_241246# user_project_wrapper_0.sg13g2_IOPadAnalog_8.padres 0
C2217 user_project_wrapper_0.sg13g2_IOPadAnalog_14.padres a_82118_240839# 0
C2218 a_192354_326677# a_192354_326465# 0.01085f
C2219 a_210417_326377# a_211537_326892# 0
C2220 a_209480_329719# a_211153_330026# 0
C2221 user_project_wrapper_0.VDD1 a_57810_179517# 0.00573f
C2222 a_210007_329719# a_208103_324155# 0
C2223 a_237844_29676# user_project_wrapper_0.IOVDD2 0.16358f
C2224 a_301186_192011# a_296731_189665# 12.2074f
C2225 a_296626_197740# a_301423_196360# 0.09804f
C2226 a_209684_329719# a_211537_330026# 0
C2227 a_296732_200582# a_304196_200821# 0.17448f
C2228 user_project_wrapper_0.VDD1 a_35542_74695# 0
C2229 a_301940_196388# a_296625_189595# 4.15033f
C2230 a_304090_197941# a_296732_197880# 0.00942f
C2231 a_84598_130577# a_89114_129061# 0.00109f
C2232 a_211170_331343# a_210051_330987# 0.00565f
C2233 a_208579_324119# a_209940_324686# 0
C2234 a_209230_324119# a_209638_324119# 0.14176f
C2235 a_208792_324119# a_209869_324119# 0
C2236 w_188704_327938# a_192354_328225# 0.0018f
C2237 a_189184_325263# a_190297_325263# 0.61242f
C2238 a_176644_41476# user_project_wrapper_0.analog_io[12] 25.1197f
C2239 user_project_wrapper_0.IOVDD1 a_39542_302065# 0.02119f
C2240 m2_81766_242000# a_82846_242854# 0
C2241 a_78824_126541# m2_81563_127336# 0
C2242 user_project_wrapper_0.sg13g2_IOPadAnalog_9.padres a_79038_128322# 0.16101f
C2243 user_project_wrapper_0.sg13g2_IOPadAnalog_22.padres a_208367_328605# 0.19304f
C2244 a_85211_124842# user_project_wrapper_0.sg13g2_IOPadIn$1_0.p2c 0.05533f
C2245 a_191901_330987# a_191987_331163# 0.01578f
C2246 a_208367_325263# a_208367_328605# 0.76757f
C2247 a_208017_327918# a_208939_328605# 0.00999f
C2248 a_192354_325997# a_192354_326465# 0.00322f
C2249 a_305365_360372# a_304705_360372# 0.02109f
C2250 a_79025_133911# a_79038_130492# 0.00134f
C2251 a_83050_125173# a_82872_125209# 0.19246f
C2252 a_82826_124842# a_83490_125209# 0.04164f
C2253 a_81295_360458# a_81625_360458# 0.37213f
C2254 a_364458_305695# a_360458_305695# 0.03774f
C2255 a_188760_101343# QDLL_TOP_0.VDD 0.29146f
C2256 a_75685_360372# user_project_wrapper_0.IOVDD4 0.01881f
C2257 a_190686_324119# a_192138_324119# 0
C2258 a_190757_324686# a_191800_324119# 0
C2259 a_191124_324119# a_191462_324119# 0.18289f
C2260 a_189609_324119# a_189737_324155# 0.2103f
C2261 user_project_wrapper_0.VDD1 a_82846_242854# 1.75079f
C2262 user_project_wrapper_0.IOVDD4 a_217444_369296# 0.16358f
C2263 user_project_wrapper_0.sg13g2_IOPadAnalog_29.padres analog_io[22] 0.33115f
C2264 a_304705_39542# a_305035_35542# 0.03774f
C2265 a_304375_35456# a_305035_35456# 0.02109f
C2266 a_82746_130212# a_79025_131741# 0.00268f
C2267 a_56308_121018# user_project_wrapper_0.VDD1 0
C2268 user_project_wrapper_0.IOVDD2 a_115165_35542# 0
C2269 user_project_wrapper_0.sg13g2_IOPadAnalog_4.padres user_project_wrapper_0.VDD2 1.74533f
C2270 a_91090_129425# a_87105_130835# 0
C2271 a_120115_35542# a_120445_35542# 0.37213f
C2272 a_209018_330987# a_209104_330987# 0.01534f
C2273 a_209904_331163# a_207985_330987# 0.0384f
C2274 w_188704_327938# a_191234_328605# 0.22627f
C2275 a_364458_78655# a_360458_78655# 0.03774f
C2276 a_190501_325263# a_189858_325263# 0
C2277 a_190297_325263# a_189286_325263# 0
C2278 a_191234_325263# a_192354_325570# 0
C2279 a_190824_325263# a_192738_325570# 0
C2280 user_project_wrapper_0.analog_io[13] QDLL_TOP_0.CPIN 0.6448f
C2281 a_309917_194695# VDD3 10.6661f
C2282 user_project_wrapper_0.VDD2 a_114505_35542# 0
C2283 w_207883_330166# a_207985_330987# 0
C2284 a_39542_303385# a_35542_303385# 0.03774f
C2285 a_190722_328605# a_189756_328605# 0.01221f
C2286 a_189184_325263# a_189286_329719# 0.01854f
C2287 a_189756_329719# a_188920_324155# 0.81415f
C2288 a_85591_241748# a_82846_243261# 0.00183f
C2289 user_project_wrapper_0.sg13g2_IOPadAnalog_17.padres a_188920_324155# 6.14017f
C2290 a_191438_326377# a_191234_327491# 0.002f
C2291 a_35542_298105# a_35542_298435# 0.37213f
C2292 a_79025_127401# a_79025_125231# 2.14934f
C2293 a_270512_100118# a_271172_100118# 0.7244f
C2294 a_35542_74365# a_35542_74035# 0.37213f
C2295 a_360372_300085# IOVDD3 0.02081f
C2296 a_190824_328605# a_190722_328605# 0.20881f
C2297 a_190297_328605# a_190926_328605# 0.01197f
C2298 a_188632_108496# a_188632_108410# 0.04185f
C2299 a_303055_364458# a_303055_360458# 0.03774f
C2300 a_190954_330851# a_190926_329327# 0
C2301 a_121765_39542# user_project_wrapper_0.sg13g2_IOPadVdd_1.sg13g2_RCClampResistor_0.p2 0.02109f
C2302 a_188966_92557# user_project_wrapper_0.analog_io[13] 0.00543f
C2303 a_207985_330987# a_209104_330851# 0.00843f
C2304 a_208071_330987# a_208071_330851# 0.29305f
C2305 a_93461_128591# a_93719_127531# 0.09229f
C2306 user_project_wrapper_0.IOVDD2 a_117805_35542# 0
C2307 a_58170_281951# a_57810_281517# 0.00209f
C2308 a_39542_80965# user_project_wrapper_0.IOVDD1 0.01881f
C2309 a_189921_331163# a_189921_331343# 0.12339f
C2310 TOP_ROILIFNEURON_0.MEM a_211537_326677# 0.01123f
C2311 user_project_wrapper_0.analog_io[15] a_243418_56308# 0.05479f
C2312 a_208939_328605# a_208939_327491# 0.29973f
C2313 user_project_wrapper_0.VDD2 a_117145_35542# -0
C2314 w_207887_326203# a_211153_326465# 0.0018f
C2315 a_213376_328627# a_211921_328693# 0
C2316 a_35542_306025# user_project_wrapper_0.sg13g2_IOPadIOVdd_1.sg13g2_RCClampResistor_0.p2 0.03777f
C2317 a_211153_326465# a_210621_325263# 0
C2318 a_343292_182218# VDD3 0
C2319 user_project_wrapper_0.sg13g2_IOPadIn$1_2.p2c a_208367_326377# 0
C2320 a_311108_179669# analog_io[20] 19.8213f
C2321 a_192738_328225# a_192738_328013# 0.01085f
C2322 a_360458_300745# a_360458_300415# 0.37213f
C2323 w_207883_330166# a_208367_328605# 0.00168f
C2324 w_207887_327938# a_208939_328605# 0.28336f
C2325 a_192738_326892# a_192738_326677# 0.01056f
C2326 user_project_wrapper_0.IOVDD1 user_project_wrapper_0.analog_io[6] 0.10967p
C2327 user_project_wrapper_0.sg13g2_IOPadAnalog_14.padres user_project_wrapper_0.sg13g2_IOPadAnalog_15.padres 0.03718f
C2328 user_project_wrapper_0.VDD1 a_35542_76015# 0
C2329 a_304090_197941# a_296732_200582# 0.01519f
C2330 a_301186_192011# a_307232_196607# 0.17582f
C2331 a_296625_208423# a_304995_198817# 0.0557f
C2332 a_210007_329719# a_210109_330241# 0.22366f
C2333 a_209480_329719# a_210621_329719# 0.00342f
C2334 a_314793_201808# a_309516_194555# 2.28004f
C2335 a_301940_196388# a_301423_202742# 0.04017f
C2336 a_59490_159238# user_project_wrapper_0.sg13g2_IOPadIn$1_0.p2c 0.27409f
C2337 user_project_wrapper_0.sg13g2_IOPadAnalog_8.padres a_82846_243261# 0.06767f
C2338 a_82859_242012# a_82645_242401# 0.05039f
C2339 m1_81768_242005# user_project_wrapper_0.analog_io[4] 0.02426f
C2340 user_project_wrapper_0.VDD1 a_56308_141418# 0
C2341 a_78824_126541# user_project_wrapper_0.sg13g2_IOPadAnalog_8.padres 0.12079f
C2342 user_project_wrapper_0.IOVDD1 a_39542_303385# 0.02079f
C2343 user_project_wrapper_0.sg13g2_IOPadAnalog_22.padres a_208469_329719# 0.01013f
C2344 a_189921_331163# a_190721_331163# 0.01525f
C2345 a_208367_325263# a_208469_329719# 0.01854f
C2346 a_208939_329719# a_208103_324155# 0.81415f
C2347 user_project_wrapper_0.sg13g2_IOPadAnalog_21.padres a_208103_324155# 0.51373f
C2348 a_79025_133911# a_79038_132196# 0.00234f
C2349 a_79025_133504# a_78220_132587# 0
C2350 a_78824_133051# a_78220_130691# 0.00173f
C2351 a_209104_330851# a_208367_328605# 0
C2352 TOP_ROILIFNEURON_0.MEM a_192354_330241# 0.01123f
C2353 a_80635_360458# a_80965_360458# 0.37213f
C2354 a_78221_125094# a_79038_125686# 0.17968f
C2355 a_185968_102197# QDLL_TOP_0.VDD 0.99677f
C2356 a_189396_324119# a_190757_324686# 0
C2357 a_189609_324119# a_190686_324119# 0
C2358 a_190047_324119# a_190455_324119# 0.14176f
C2359 a_208367_328605# a_208469_327099# 0.00118f
C2360 a_208939_328605# a_209041_327099# 0.00123f
C2361 a_304045_39542# a_304375_35542# 0.03774f
C2362 a_303715_35456# a_304375_35456# 0.02109f
C2363 a_79025_127401# a_79025_133911# 0.08498f
C2364 a_208939_326377# a_209684_326377# 0.2047f
C2365 a_119455_35542# a_119785_35542# 0.37213f
C2366 a_192995_331163# a_192995_330987# 0.03126f
C2367 a_364458_79315# a_360458_79315# 0.03774f
C2368 a_189395_101343# QDLL_TOP_0.VOUT 0
C2369 a_304196_197873# VDD3 0.12335f
C2370 user_project_wrapper_0.sg13g2_IOPadAnalog_6.padres a_269931_100182# 0.0071f
C2371 a_35542_303715# a_35542_303385# 0.37213f
C2372 user_project_wrapper_0.ui_PAD[9] user_project_wrapper_0.VDD1 0.06132f
C2373 a_189286_327099# a_189184_327491# 0.03624f
C2374 a_189858_327099# a_189756_327491# 0.0363f
C2375 a_190297_326377# a_190824_327491# 0
C2376 a_190824_326377# a_190297_327491# 0
C2377 a_189756_329719# a_190926_330241# 0
C2378 a_189184_329719# a_190722_330241# 0.00448f
C2379 a_269355_100412# a_269799_100118# 0
C2380 a_269543_100118# a_269931_100182# 0.00413f
C2381 a_300085_360458# user_project_wrapper_0.IOVDD4 0
C2382 a_35542_75025# a_35542_74695# 0.37213f
C2383 user_project_wrapper_0.IOVDD4 a_115444_369296# 0.16358f
C2384 a_360372_301405# IOVDD3 0.02119f
C2385 a_278644_355624# a_286861_355784# 0.01916f
C2386 a_190297_328605# a_192354_329332# 0
C2387 a_191234_328605# a_191438_328605# 0.43471f
C2388 a_186397_108409# a_188632_108496# 0
C2389 a_187518_108496# a_187518_108410# 0.04185f
C2390 a_302395_364458# a_302395_360458# 0.03774f
C2391 a_89114_127896# a_86507_129255# 0.01891f
C2392 a_189921_330851# a_190501_328605# 0
C2393 a_176644_355624# user_project_wrapper_0.analog_io[30] 25.1197f
C2394 a_116155_35542# a_116485_35542# 0.37213f
C2395 a_89953_129061# a_92512_127531# 0.00168f
C2396 a_86507_127725# a_88274_127531# 0.0221f
C2397 a_93204_129062# a_93208_127531# 0
C2398 user_project_wrapper_0.analog_io[13] user_project_wrapper_0.analog_io[12] 0.33116f
C2399 a_186731_92558# user_project_wrapper_0.analog_io[13] 0.02489f
C2400 a_210051_330987# a_210137_330987# 0.05268f
C2401 user_project_wrapper_0.sg13g2_IOPadOut4mA$1_1.sg13g2_GateLevelUpInv_noptap$1$1_0.pgate a_58798_281951# 0.04338f
C2402 IOVDD3 a_369296_258244# 0.16358f
C2403 QDLL_TOP_0.VOUT a_284218_56308# 0.05479f
C2404 a_305695_360458# a_306025_360458# 0.37213f
C2405 a_208103_324155# a_209480_327491# 0.00153f
C2406 a_208103_324155# a_210007_328605# 0
C2407 a_210621_329719# a_211153_329332# 0
C2408 a_190297_325263# a_190757_324686# 0
C2409 a_191438_327491# a_191970_328225# 0.002f
C2410 TOP_ROILIFNEURON_0.MEM a_211921_330241# 0.00639f
C2411 QDLL_TOP_0.VOUT user_project_wrapper_0.analog_io[13] 0.1488f
C2412 a_360458_301405# a_360458_301075# 0.37213f
C2413 a_258244_29676# a_266461_29836# 0.01778f
C2414 a_79038_126152# user_project_wrapper_0.sg13g2_IOPadAnalog_9.padres 0.16101f
C2415 a_301186_192011# a_301940_196388# 0.48021f
C2416 a_209480_329719# a_210417_329719# 0.02229f
C2417 a_296625_208423# a_296626_197740# 1.04041f
C2418 a_188834_326341# a_190297_327491# 0.00125f
C2419 a_189756_325263# a_190824_327491# 0.00304f
C2420 a_189184_325263# a_189286_328013# 0
C2421 user_project_wrapper_0.VDD1 a_35542_77335# 0
C2422 a_189184_329719# a_189184_327491# 0.00332f
C2423 user_project_wrapper_0.VDD1 a_58798_281951# 1.32649f
C2424 user_project_wrapper_0.sg13g2_IOPadAnalog_17.padres a_190501_327491# 0
C2425 user_project_wrapper_0.IOVDD1 a_35542_303715# 0
C2426 a_188920_324155# a_189858_327491# 0
C2427 a_84332_125209# a_87434_127531# 0
C2428 a_208367_329719# a_209905_330241# 0.00448f
C2429 a_35542_299095# a_35542_298765# 0.37213f
C2430 a_208939_329719# a_210109_330241# 0
C2431 a_360372_75025# IOVDD3 0.01881f
C2432 a_82645_242401# a_82846_242854# 1.02452f
C2433 a_78219_134797# a_79025_133911# 0
C2434 a_190501_325263# a_190722_326377# 0.00101f
C2435 user_project_wrapper_0.sg13g2_IOPadOut4mA$1_1.sg13g2_GateLevelUpInv_noptap$1$1_0.ngate a_58798_281951# 0.56967f
C2436 a_79025_129571# a_79038_130492# 0.00145f
C2437 a_86594_129426# a_86507_129255# 0.36662f
C2438 a_78824_126541# a_78221_126292# 0.00301f
C2439 a_89953_129061# a_93204_129062# 0.00529f
C2440 a_86507_127725# a_91911_129060# 0.00397f
C2441 a_189729_101343# a_190389_101343# 0.7244f
C2442 a_303055_35456# a_303715_35456# 0.02109f
C2443 a_303385_39542# a_303715_35542# 0.03774f
C2444 a_83796_129203# a_79025_138251# 0
C2445 user_project_wrapper_0.sg13g2_IOPadAnalog_1.padres a_296731_189665# 0.06016f
C2446 a_118795_35542# a_119125_35542# 0.37213f
C2447 a_82348_128838# a_79025_125231# 0
C2448 analog_io[20] VDD3 97.6892f
C2449 a_364458_79975# a_360458_79975# 0.03774f
C2450 a_189395_99046# a_189016_99480# 0.00555f
C2451 a_309516_194555# VDD3 69.4239f
C2452 user_project_wrapper_0.analog_io[13] a_188074_110495# 0.00333f
C2453 a_187914_101343# QDLL_TOP_0.VOUT 0.43056f
C2454 a_190501_325263# a_190926_325785# 0.00499f
C2455 IOVDD3 a_360372_298105# 0.04966f
C2456 user_project_wrapper_0.sg13g2_IOPadAnalog_22.padres a_205385_326221# 0.00139f
C2457 a_208367_325263# a_205385_326221# 0
C2458 a_190297_328605# a_189756_328605# 0.203f
C2459 a_190501_329719# a_191234_329719# 0.00653f
C2460 a_87851_125174# a_86507_129255# 0
C2461 a_298765_360458# user_project_wrapper_0.IOVDD4 0
C2462 a_35542_75685# a_35542_75355# 0.37213f
C2463 user_project_wrapper_0.sg13g2_IOPadAnalog_19.padres a_190297_329719# 0.00803f
C2464 a_237844_355624# a_246061_355784# 0.01916f
C2465 a_360372_302725# IOVDD3 0.02119f
C2466 a_190501_328605# a_191234_328605# 0.0065f
C2467 a_189184_328605# a_189286_329327# 0.10232f
C2468 a_190297_328605# a_190824_328605# 0.20528f
C2469 a_211153_328905# a_210621_327491# 0
C2470 user_project_wrapper_0.IOVDD1 a_58798_281249# 0.07576f
C2471 a_301735_364458# a_301735_360458# 0.03774f
C2472 a_209041_325263# a_206547_324106# 0.00191f
C2473 a_115495_35542# a_115825_35542# 0.37213f
C2474 a_210621_328605# a_211537_328905# 0.00953f
C2475 a_86507_127725# a_91090_127895# 0
C2476 a_82658_129203# a_83586_127455# 0
C2477 a_89953_129061# a_93208_127531# 0.08095f
C2478 a_301186_192011# user_project_wrapper_0.sg13g2_IOPadAnalog_26.padres 0.01194f
C2479 a_207638_330987# a_207985_330987# 0.00242f
C2480 a_35542_304705# a_35542_304375# 0.37213f
C2481 a_83592_125209# a_79025_125231# 0
C2482 a_41636_144061# a_41476_135844# 0.01916f
C2483 w_188704_327938# a_189286_328013# 0.01306f
C2484 a_208017_326341# a_209684_326377# 0
C2485 a_208939_325263# a_209480_326377# 0.02261f
C2486 a_208017_327918# a_210007_326377# 0
C2487 user_project_wrapper_0.sg13g2_IOPadAnalog_21.padres a_208367_326377# 0.05512f
C2488 a_304889_198885# a_307232_196607# 0.02252f
C2489 user_project_wrapper_0.VDD1 a_87105_130835# 0.92807f
C2490 a_208071_331163# a_208103_324155# 0
C2491 a_78824_124371# a_79038_123982# 0.05038f
C2492 a_78221_124694# a_78220_123062# 0.01711f
C2493 user_project_wrapper_0.sg13g2_IOPadAnalog_19.padres a_189672_324776# 0
C2494 a_360458_302065# a_360458_301735# 0.37213f
C2495 a_217444_29676# a_225661_29836# 0.01778f
C2496 w_207883_330166# a_211921_330453# 0.0018f
C2497 user_project_wrapper_0.sg13g2_IOPadIn$1_1.sg13g2_LevelDown_noptap$1_0.sg13g2_SecondaryProtection$1$1_0.core user_project_wrapper_0.VDD1 0.56648f
C2498 a_190926_328605# a_190824_327491# 0.00167f
C2499 a_35456_79975# user_project_wrapper_0.VDD1 0
C2500 a_211537_326892# a_209480_326377# 0
C2501 a_211153_326892# a_210007_326377# 0
C2502 a_209041_326377# a_208939_326377# 0.22095f
C2503 a_208469_326377# a_208367_326377# 0.23459f
C2504 user_project_wrapper_0.VDD1 a_35542_78655# 0
C2505 a_117145_35542# a_116815_35542# 0.37213f
C2506 user_project_wrapper_0.IOVDD2 a_305035_35542# 0
C2507 a_87105_130835# user_project_wrapper_0.sg13g2_IOPadIn$1_1.p2c 0.0448f
C2508 a_299425_360372# a_300085_360372# 0.02109f
C2509 a_299755_364458# a_300085_360458# 0.03774f
C2510 a_90579_127530# a_91090_127895# 0.06159f
C2511 a_89953_127531# a_91911_127530# 0.12951f
C2512 a_82840_127455# a_83164_127455# 0.00441f
C2513 a_86594_127896# a_88274_127531# 0.00441f
C2514 a_87434_127896# a_86594_127531# 0
C2515 user_project_wrapper_0.sg13g2_IOPadIn$1_2.p2c w_188806_323975# 0.14448f
C2516 user_project_wrapper_0.sg13g2_IOPadIn$1_1.sg13g2_LevelDown_noptap$1_0.sg13g2_SecondaryProtection$1$1_0.core user_project_wrapper_0.sg13g2_IOPadIn$1_1.p2c 0.10336f
C2517 a_208367_329719# a_209480_329719# 0.63564f
C2518 a_208939_329719# a_210007_329719# 0.01075f
C2519 user_project_wrapper_0.IOVDD4 a_305035_360458# 0
C2520 a_35542_299755# a_35542_299425# 0.37213f
C2521 a_360372_76345# IOVDD3 0.01881f
C2522 a_211170_330851# a_211153_330453# 0.00331f
C2523 a_79315_360458# a_79645_360458# 0.37213f
C2524 a_78824_135221# a_78219_134883# 0.00202f
C2525 a_79025_136081# a_79038_134832# 0.00989f
C2526 a_82348_128838# a_79025_133911# 0.01665f
C2527 TOP_ROILIFNEURON_0.MEM a_191234_329719# 0.00574f
C2528 a_84598_130212# a_79025_131741# 0
C2529 w_188700_330166# a_189286_330241# 0.01323f
C2530 a_189609_324119# a_188920_324155# 0.00353f
C2531 a_188760_101343# a_189148_101407# 0.00413f
C2532 a_188572_101637# a_189016_101343# 0
C2533 a_192738_330026# a_192738_329814# 0.01085f
C2534 a_302395_35456# a_303055_35456# 0.02109f
C2535 a_302725_39542# a_303055_35542# 0.03774f
C2536 a_208103_324155# a_209230_324119# 0.00111f
C2537 user_project_wrapper_0.sg13g2_IOPadAnalog_1.padres a_307232_196607# 0
C2538 a_190501_326377# a_191438_326377# 0.00396f
C2539 a_301575_187719# a_304889_199957# 0.07527f
C2540 a_190297_326377# a_190926_327099# 0.01814f
C2541 a_190824_326377# a_190722_327099# 0.1023f
C2542 a_79025_129571# a_79025_127401# 0.08992f
C2543 a_83070_130212# a_83070_130577# 0.0888f
C2544 a_83492_130212# a_79025_125231# 0.00168f
C2545 a_118135_35542# a_118465_35542# 0.37213f
C2546 m1_81998_130507# a_79038_130492# 0
C2547 a_364458_80635# a_360458_80635# 0.03774f
C2548 IOVDD3 a_360372_299425# 0.01899f
C2549 user_project_wrapper_0.sg13g2_IOPadIn$1_0.sg13g2_LevelDown_noptap$1_0.sg13g2_SecondaryProtection$1$1_0.core user_project_wrapper_0.sg13g2_IOPadIn$1_0.p2c 0.10336f
C2550 a_360372_74365# VDD3 0.00299f
C2551 a_210007_326377# a_208939_327491# 0
C2552 a_208367_326377# a_209480_327491# 0.00167f
C2553 a_209684_326377# a_209684_327491# 0.07618f
C2554 a_209480_326377# a_208367_327491# 0
C2555 user_project_wrapper_0.ui_PAD[2] user_project_wrapper_0.sg13g2_IOPadIn$1_0.sg13g2_LevelDown_noptap$1_0.sg13g2_SecondaryProtection$1$1_0.core 0.02881f
C2556 a_190954_330851# a_190926_330241# 0
C2557 a_82118_239118# a_82118_238718# 0.0172f
C2558 a_82846_240684# a_82859_239376# 0.71261f
C2559 a_35542_76345# a_35542_76015# 0.37213f
C2560 a_210621_327491# a_211537_328225# 0
C2561 a_85359_125209# a_86507_127725# 0
C2562 m2_82112_130096# a_79025_127401# 0.02382f
C2563 a_360372_304045# IOVDD3 0.01881f
C2564 a_176644_355624# a_184861_355784# 0.01916f
C2565 a_190501_327491# a_189858_327491# 0
C2566 a_190297_327491# a_189286_327491# 0
C2567 a_191234_327491# a_192354_327798# 0
C2568 a_190824_327491# a_192738_327798# 0
C2569 a_189184_327491# a_190722_327491# 0.01977f
C2570 a_364458_297775# a_360458_297775# 0.03774f
C2571 w_207989_323975# a_208939_326377# 0.0016f
C2572 w_207887_327938# a_210007_326377# 0
C2573 a_301075_364458# a_301075_360458# 0.03774f
C2574 w_207887_326203# a_209684_326377# 0.10257f
C2575 user_project_wrapper_0.sg13g2_IOPadVdd_2.sg13g2_RCClampResistor_0.p2 user_project_wrapper_0.IOVDD1 68.8769f
C2576 a_88274_129061# a_86507_129255# 0.02228f
C2577 a_210007_328605# a_210109_328605# 0.22366f
C2578 a_210621_328605# a_211153_329120# 0.00324f
C2579 a_114835_35542# a_115165_35542# 0.37213f
C2580 user_project_wrapper_0.VDD1 a_79025_131741# 2.18039f
C2581 a_208939_328605# a_208367_328605# 0.57196f
C2582 a_86507_127725# a_87434_127896# 0.49438f
C2583 user_project_wrapper_0.IOVDD1 user_project_wrapper_0.sg13g2_IOPadIOVdd_1.sg13g2_Clamp_N43N43D4R_0.gate 0.15002p
C2584 a_35542_305365# a_35542_305035# 0.37213f
C2585 a_189729_99046# a_190218_98097# 0.0013f
C2586 a_360458_300415# a_360458_300085# 0.37213f
C2587 a_191196_90557# a_191751_90472# 0
C2588 a_191196_92557# a_192309_92557# 0.00943f
C2589 a_190868_330987# a_191987_330987# 0.05255f
C2590 a_210007_329719# a_210007_328605# 0.01118f
C2591 user_project_wrapper_0.VDD1 a_82746_130212# 0.32452f
C2592 a_304889_198885# a_301940_196388# 0.18284f
C2593 user_project_wrapper_0.sg13g2_IOPadOut4mA$1_1.c2p a_82846_243261# 0.00249f
C2594 a_189184_325263# a_189672_324776# 0.00104f
C2595 a_189756_325263# a_190926_327099# 0
C2596 a_190824_325263# a_188920_324155# 0.00133f
C2597 TOP_ROILIFNEURON_0.MEM a_209480_329719# 0
C2598 user_project_wrapper_0.sg13g2_IOPadAnalog_19.padres a_190297_326377# 0.00854f
C2599 a_360458_302725# a_360458_302395# 0.37213f
C2600 w_207887_327938# a_213462_327536# 0
C2601 a_176644_29676# a_184861_29836# 0.01778f
C2602 a_190218_102763# QDLL_TOP_0.CPIN 0.00592f
C2603 a_210621_326377# a_208367_326377# 0.00109f
C2604 a_209905_327099# a_209480_326377# 0.00962f
C2605 a_210109_327099# a_209684_326377# 0.05288f
C2606 a_208855_324776# a_208939_326377# 0
C2607 a_85155_125209# a_84332_125209# 0.017f
C2608 user_project_wrapper_0.IOVDD2 a_303715_35542# 0
C2609 user_project_wrapper_0.analog_io[7] a_87832_241383# 0.06601f
C2610 a_298435_35456# a_298765_35542# 0.03774f
C2611 a_360458_75685# a_360458_75355# 0.37213f
C2612 a_190868_330987# a_190501_329719# 0
C2613 a_299095_364458# a_299425_360458# 0.03774f
C2614 a_298765_360372# a_299425_360372# 0.02109f
C2615 a_88274_127896# a_84332_125209# 0.00281f
C2616 a_89114_127896# a_89953_127531# 0.08108f
C2617 a_82840_127455# a_82527_127455# 0.02784f
C2618 a_208939_325263# a_209041_325263# 0.1039f
C2619 a_208017_326341# a_208469_325263# 0
C2620 a_213462_327536# user_project_wrapper_0.analog_io[35] 0.17614f
C2621 user_project_wrapper_0.IOVDD1 user_project_wrapper_0.sg13g2_IOPadOut4mA$1_0.sg13g2_GateLevelUpInv_noptap$1$1_0.ngate 13.9496f
C2622 user_project_wrapper_0.VDD1 a_87434_127531# 0
C2623 a_35542_300415# a_35542_300085# 0.37213f
C2624 user_project_wrapper_0.IOVDD4 a_303715_360458# 0
C2625 a_189395_99046# QDLL_TOP_0.VDD 0.59666f
C2626 user_project_wrapper_0.sg13g2_IOPadIn$1_2.p2c a_192745_324776# 0.00478f
C2627 a_360372_77665# IOVDD3 0.01881f
C2628 a_79025_137844# a_78824_135221# 0
C2629 a_79038_137002# a_79038_136536# 0.04646f
C2630 a_208071_330851# a_208469_330241# 0
C2631 a_78824_137391# a_79025_135674# 0
C2632 a_58798_179951# user_project_wrapper_0.IOVDD1 0.07206f
C2633 user_project_wrapper_0.analog_io[30] user_project_wrapper_0.IOVDD4 0.10967p
C2634 a_78655_360458# a_78985_360458# 0.37213f
C2635 user_project_wrapper_0.sg13g2_IOPadVdd_2.sg13g2_RCClampInverter_noptap_0.out user_project_wrapper_0.sg13g2_IOPadVdd_2.sg13g2_RCClampResistor_0.p2 22.6715f
C2636 user_project_wrapper_0.VDD1 a_56308_263818# 0
C2637 a_83492_130212# a_79025_133911# 0
C2638 a_84598_130577# a_85127_131750# 0.13345f
C2639 a_78824_128711# a_79025_136081# 0
C2640 a_79038_130026# a_79025_131741# 0.00293f
C2641 a_161818_56308# user_project_wrapper_0.analog_io[11] 0.05479f
C2642 w_188700_330166# a_190824_329719# 0.11271f
C2643 a_88274_129426# a_83492_127455# 0
C2644 a_87434_129426# a_89953_129061# 0
C2645 a_208017_326341# a_208367_329719# 0.01178f
C2646 user_project_wrapper_0.sg13g2_IOPadAnalog_21.padres a_208939_329719# 0.19093f
C2647 a_190319_102855# a_189729_101343# 0.00106f
C2648 a_187914_101343# a_188296_101407# 0.00311f
C2649 a_302065_39542# a_302395_35542# 0.03774f
C2650 a_301735_35456# a_302395_35456# 0.02109f
C2651 a_360458_73705# IOVDD3 0
C2652 a_189756_329719# a_190501_329719# 0.20556f
C2653 a_189184_326377# a_190297_326377# 0.62905f
C2654 a_189756_326377# a_190824_326377# 0.01463f
C2655 user_project_wrapper_0.sg13g2_IOPadAnalog_8.padres a_78220_130691# 0.00431f
C2656 user_project_wrapper_0.sg13g2_IOPadAnalog_17.padres a_190501_329719# 0
C2657 a_117475_35542# a_117805_35542# 0.37213f
C2658 a_84598_130577# a_83070_130577# 0
C2659 a_364458_81295# a_360458_81295# 0.03774f
C2660 user_project_wrapper_0.sg13g2_IOPadAnalog_19.padres a_189756_325263# 4.42403f
C2661 a_211153_326677# a_211153_326465# 0.01085f
C2662 a_223018_343292# user_project_wrapper_0.analog_io[32] 0.05479f
C2663 a_208939_325263# a_209905_326377# 0.00236f
C2664 a_208017_326341# a_209041_326377# 0.02103f
C2665 user_project_wrapper_0.IOVDD4 a_81625_360458# 0
C2666 a_77737_56308# user_project_wrapper_0.ui_PAD[9] 0.04422f
C2667 a_360372_75685# VDD3 0.00199f
C2668 a_191234_328605# a_191438_329719# 0.002f
C2669 a_355624_197044# IOVDD3 58.9173f
C2670 IOVDD3 user_project_wrapper_0.sg13g2_IOPadIOVdd_3.sg13g2_Clamp_N43N43D4R_0.gate 0.15002p
C2671 a_35542_77005# a_35542_76675# 0.37213f
C2672 a_304889_198885# user_project_wrapper_0.sg13g2_IOPadAnalog_26.padres 0.05314f
C2673 user_project_wrapper_0.sg13g2_IOPadIn$1_2.p2c a_209230_324119# 0.03202f
C2674 a_210007_327491# a_210621_327491# 0.01253f
C2675 a_156244_369296# user_project_wrapper_0.analog_io[29] 9.69836f
C2676 a_87627_124843# a_86507_127725# 0.80093f
C2677 TOP_ROILIFNEURON_0.MEM a_191234_326377# 0.00567f
C2678 a_360372_305365# IOVDD3 0.02119f
C2679 a_135844_355624# a_144061_355784# 0.01916f
C2680 a_210417_328605# a_210621_327491# 0.00165f
C2681 a_210621_328605# a_210417_327491# 0.00165f
C2682 a_189184_327491# a_191970_328013# 0
C2683 a_191234_327491# a_191438_327491# 0.43471f
C2684 a_82433_130212# user_project_wrapper_0.sg13g2_IOPadIn$1_0.p2c 0.02771f
C2685 m4_6878_10238# m5_6924_10284# 0.92329p
C2686 a_360458_298765# a_360458_298435# 0.37213f
C2687 w_188704_326203# a_190722_327099# 0
C2688 a_79038_127856# a_79025_136081# 0
C2689 user_project_wrapper_0.VDD1 a_79038_134366# 0.09632f
C2690 a_114175_35542# a_114505_35542# 0.37213f
C2691 TOP_ROILIFNEURON_0.MEM a_210621_327491# 0.121f
C2692 a_79025_129164# a_78220_128106# 0.25146f
C2693 a_84598_130577# a_89114_127531# 0
C2694 a_92512_129426# a_93298_129062# 0.01716f
C2695 user_project_wrapper_0.VDD1 a_91090_129425# 0.49789f
C2696 a_82826_124842# a_79025_125231# 0.0113f
C2697 TOP_ROILIFNEURON_0.MEM a_211153_329332# 0.00105f
C2698 a_186431_99272# a_186430_98275# 0.00515f
C2699 a_190082_92557# a_191196_92557# 0.00941f
C2700 a_190082_90557# a_190638_90472# 0
C2701 a_190584_102855# user_project_wrapper_0.analog_io[13] 0
C2702 TOP_ROILIFNEURON_0.MEM a_190868_330987# 0.07377f
C2703 a_190824_327491# a_189756_328605# 0
C2704 m2_83010_126180# a_82527_127455# 0.0074f
C2705 a_189184_325263# a_190297_326377# 0.00213f
C2706 a_188834_327918# a_190501_326377# 0
C2707 a_188834_326341# a_189756_326377# 0.68786f
C2708 a_189756_325263# a_189184_326377# 0.36532f
C2709 TOP_ROILIFNEURON_0.MEM a_211537_325570# 0.01042f
C2710 user_project_wrapper_0.sg13g2_IOPadAnalog_17.padres a_187364_324106# 0
C2711 a_192738_325997# a_194193_328627# 0
C2712 a_87673_125210# a_88393_125210# 0
C2713 a_91090_129425# user_project_wrapper_0.sg13g2_IOPadIn$1_1.p2c 0.02026f
C2714 a_208017_326341# a_210007_327491# 0
C2715 a_208017_327918# a_208469_328013# 0.02077f
C2716 a_208939_325263# a_210417_327491# 0.00172f
C2717 a_360458_303385# a_360458_303055# 0.37213f
C2718 user_project_wrapper_0.sg13g2_IOPadAnalog_21.padres a_209480_327491# 0.00841f
C2719 a_209905_325785# a_209905_325263# 0
C2720 a_208939_329719# a_210007_328605# 0
C2721 a_208367_329719# a_209480_328605# 0.00102f
C2722 a_189184_328605# a_189858_328013# 0.00156f
C2723 a_190824_328605# a_190824_327491# 0.02415f
C2724 a_87468_125419# a_84332_125209# 0.00928f
C2725 user_project_wrapper_0.sg13g2_IOPadAnalog_21.padres a_210007_328605# 0
C2726 a_79025_124824# user_project_wrapper_0.VDD1 1.50498f
C2727 user_project_wrapper_0.IOVDD2 a_302395_35542# 0
C2728 a_209869_324119# a_206547_324106# 0
C2729 a_209230_324119# a_208367_326377# 0
C2730 a_297775_35456# a_298105_35542# 0.03774f
C2731 w_207989_323975# a_208017_326341# 0
C2732 a_298435_364458# a_298765_360458# 0.03774f
C2733 a_298105_360372# a_298765_360372# 0.02109f
C2734 a_360458_76345# a_360458_76015# 0.37213f
C2735 a_190584_97917# user_project_wrapper_0.analog_io[14] 0.00848f
C2736 a_188888_330987# a_189184_325263# 0
C2737 a_188802_330987# a_188834_327918# 0
C2738 a_86594_127896# a_87434_127896# 0.26531f
C2739 user_project_wrapper_0.VDD1 a_84332_125209# 1.86279f
C2740 a_286861_355784# user_project_wrapper_0.IOVDD4 1.92793f
C2741 a_35542_301075# a_35542_300745# 0.37213f
C2742 user_project_wrapper_0.IOVDD4 a_302395_360458# 0
C2743 user_project_wrapper_0.sg13g2_IOPadIn$1_2.p2c a_190047_324119# 0.05359f
C2744 a_360372_78985# IOVDD3 0.01881f
C2745 a_79025_138251# a_79025_137844# 0
C2746 a_78218_138195# a_78219_136982# 0.01679f
C2747 a_343292_223018# analog_io[23] 0.10599f
C2748 a_190319_97955# QDLL_TOP_0.CPIN 0.23715f
C2749 a_77995_360458# a_78325_360458# 0.37213f
C2750 TOP_ROILIFNEURON_0.MEM a_211921_326892# 0.00631f
C2751 a_75025_360458# a_75355_360458# 0.37213f
C2752 a_83070_130212# a_79025_136081# 0
C2753 a_209684_325263# a_208939_326377# 0.00169f
C2754 a_78220_128592# a_79025_133911# 0
C2755 w_207887_326203# a_209041_326377# 0.01325f
C2756 user_project_wrapper_0.sg13g2_IOPadAnalog_22.padres a_208367_325263# 0.15995f
C2757 a_88274_129426# a_89114_129426# 0.05839f
C2758 a_79025_129571# a_82348_128838# 0.05383f
C2759 a_296731_208493# VDD3 57.8154f
C2760 a_211537_325570# a_208855_324776# 0
C2761 a_189016_99480# QDLL_TOP_0.VOUT 0
C2762 a_211928_324776# a_211921_325570# 0
C2763 a_190722_330241# a_190722_329719# 0
C2764 a_301405_39542# a_301735_35542# 0.03774f
C2765 a_301075_35456# a_301735_35456# 0.02109f
C2766 a_84332_125209# user_project_wrapper_0.sg13g2_IOPadIn$1_1.p2c 0.01437f
C2767 user_project_wrapper_0.VDD1 a_82859_239842# 0.09466f
C2768 a_187018_328627# a_188834_326341# 0
C2769 a_189184_325263# a_189756_325263# 0.97501f
C2770 user_project_wrapper_0.sg13g2_IOPadAnalog_8.padres a_79038_134832# 0.07195f
C2771 user_project_wrapper_0.sg13g2_IOPadAnalog_17.padres a_186202_326221# 0.00139f
C2772 user_project_wrapper_0.IOVDD2 a_298105_35542# 0
C2773 TOP_ROILIFNEURON_0.MEM a_191970_325358# 0.00105f
C2774 user_project_wrapper_0.IOVDD4 a_80305_360458# 0
C2775 a_208017_326341# a_208855_324776# 0
C2776 user_project_wrapper_0.IOVDD1 a_35456_74035# 0.01409f
C2777 a_360372_77005# VDD3 0.00238f
C2778 w_188806_323975# a_192354_325358# 0
C2779 user_project_wrapper_0.sg13g2_IOPadAnalog_21.padres a_210621_326377# 0
C2780 user_project_wrapper_0.VDD2 a_122425_35542# 0
C2781 a_208939_325263# a_208920_324155# 0
C2782 a_35542_77665# a_35542_77335# 0.37213f
C2783 a_58170_281951# a_58798_281951# 0.08391f
C2784 a_57810_282219# user_project_wrapper_0.sg13g2_IOPadOut4mA$1_1.c2p 0.01733f
C2785 user_project_wrapper_0.sg13g2_IOPadIn$1_1.p2c a_82859_239842# 0.00473f
C2786 a_82846_241091# a_85591_241383# 0.00501f
C2787 a_209684_327491# a_210007_327491# 0.35443f
C2788 a_208367_327491# a_210417_327491# 0.01152f
C2789 a_208939_327491# a_208469_328013# 0
C2790 a_85052_125418# a_83492_127455# 0
C2791 QDLL_TOP_0.VDD QDLL_TOP_0.CPIN 2.68946f
C2792 TOP_ROILIFNEURON_0.MEM a_211537_327586# 0.00168f
C2793 user_project_wrapper_0.sg13g2_IOPadAnalog_15.padres a_82118_240839# 0
C2794 a_360458_299425# a_360458_299095# 0.37213f
C2795 a_209480_328605# a_210007_327491# 0
C2796 a_210007_328605# a_209480_327491# 0
C2797 w_188704_326203# a_189756_326377# 0.2909f
C2798 a_209905_327099# a_209905_326377# 0
C2799 a_209104_331343# a_208367_329719# 0
C2800 user_project_wrapper_0.sg13g2_IOPadAnalog_21.padres a_210137_331343# 0
C2801 user_project_wrapper_0.VDD1 a_78219_135283# 0.59724f
C2802 a_209480_328605# a_210417_328605# 0.02229f
C2803 a_296731_189665# a_311846_195517# 0.27477f
C2804 a_190757_324686# a_189672_324776# 0.40357f
C2805 a_309917_199879# a_309917_194695# 4.319f
C2806 TOP_ROILIFNEURON_0.MEM a_209684_327491# 0
C2807 a_84598_130577# a_91911_127530# 0
C2808 a_89953_129061# a_91090_129060# 0.00133f
C2809 a_83492_127455# a_89114_129061# 0
C2810 user_project_wrapper_0.VDD1 a_83079_128838# 0.32538f
C2811 a_299425_39542# a_299425_35542# 0.03774f
C2812 w_207887_326203# a_210007_327491# 0
C2813 a_78824_126541# a_79025_125231# 0
C2814 w_207887_327938# a_208469_328013# 0.01306f
C2815 TOP_ROILIFNEURON_0.MEM a_209480_328605# 0
C2816 a_189184_325263# a_190722_325263# 0.01986f
C2817 user_project_wrapper_0.sg13g2_IOPadIn$1_2.p2c a_191234_325263# 0
C2818 a_78824_124371# user_project_wrapper_0.sg13g2_IOPadAnalog_8.padres 0.12017f
C2819 user_project_wrapper_0.IOVDD1 a_35542_298435# 0
C2820 a_188966_90557# a_189524_90472# 0
C2821 a_188966_92557# a_190082_92557# 0.00939f
C2822 user_project_wrapper_0.IOVDD1 user_project_wrapper_0.analog_io[4] 0.10967p
C2823 a_211084_330987# TOP_ROILIFNEURON_0.MEM 0.00225f
C2824 a_301575_187719# VDD3 0.0783f
C2825 TOP_ROILIFNEURON_0.MEM w_207887_326203# 0.02658f
C2826 TOP_ROILIFNEURON_0.MEM a_210621_325263# 0.12156f
C2827 m1_83011_126179# a_82840_127455# 0
C2828 a_85257_125209# a_85977_125209# 0
C2829 a_85211_124842# a_87775_125210# 0
C2830 w_207887_326203# a_211537_325997# 0.0018f
C2831 user_project_wrapper_0.sg13g2_IOPadIn$1_1.sg13g2_LevelDown_noptap$1_0.sg13g2_SecondaryProtection$1$1_0.core a_77737_56308# 0.0512f
C2832 a_360458_304045# a_360458_303715# 0.37213f
C2833 a_79645_360458# user_project_wrapper_0.IOVDD4 0
C2834 a_210621_325263# a_211537_325997# 0
C2835 a_190926_326377# a_190926_327099# 0
C2836 a_211153_327104# a_211153_327586# 0.0031f
C2837 a_87627_124843# a_86594_127896# 0
C2838 a_83050_125173# a_84332_125209# 0
C2839 a_209904_331163# user_project_wrapper_0.sg13g2_IOPadAnalog_22.padres 0
C2840 a_85155_125209# user_project_wrapper_0.VDD1 0.1432f
C2841 TOP_ROILIFNEURON_0.MEM a_192354_328905# 0.01123f
C2842 user_project_wrapper_0.IOVDD2 a_301075_35542# 0
C2843 user_project_wrapper_0.sg13g2_IOPadAnalog_8.padres a_82118_239118# 0.01256f
C2844 user_project_wrapper_0.sg13g2_IOPadAnalog_22.padres w_207883_330166# 0.03586f
C2845 w_207883_330166# a_208367_325263# 0.07448f
C2846 a_122095_35542# a_122425_35542# 0.37213f
C2847 a_360458_77005# a_360458_76675# 0.37213f
C2848 TOP_ROILIFNEURON_0.MEM a_212178_330851# 0.00974f
C2849 a_297775_364458# a_298105_360458# 0.03774f
C2850 user_project_wrapper_0.sg13g2_IOPadOut4mA$1_0.sg13g2_GateLevelUpInv_noptap$1$1_0.ngate user_project_wrapper_0.uo_PAD[3] 0.9733f
C2851 a_186397_108495# a_186960_108495# 0.0653f
C2852 a_79038_128322# a_78220_128106# 0
C2853 w_188700_330166# a_188834_326341# 0.08203f
C2854 w_188704_326203# a_187018_328627# 0
C2855 a_208017_327918# a_208469_325785# 0.01792f
C2856 a_208367_325263# a_209041_325785# 0.01504f
C2857 w_188704_327938# a_189756_325263# 0.01667f
C2858 a_184861_355784# user_project_wrapper_0.IOVDD4 1.92793f
C2859 user_project_wrapper_0.VDD1 a_88274_127896# 0.49448f
C2860 a_35542_301735# a_35542_301405# 0.37213f
C2861 user_project_wrapper_0.sg13g2_IOPadAnalog_5.padres user_project_wrapper_0.VDD2 1.74533f
C2862 user_project_wrapper_0.IOVDD4 a_301075_360458# 0
C2863 a_360372_80305# IOVDD3 0.01881f
C2864 a_210137_330987# a_209480_329719# 0
C2865 user_project_wrapper_0.sg13g2_IOPadAnalog_6.padres a_188184_99046# 0.0042f
C2866 user_project_wrapper_0.IOVDD2 a_278644_41476# 58.9173f
C2867 a_77335_360458# a_77665_360458# 0.37213f
C2868 a_74365_360458# a_74695_360458# 0.37213f
C2869 a_360458_74695# a_360372_74365# 0.03774f
C2870 w_207887_326203# a_208855_324776# 0.00101f
C2871 TOP_ROILIFNEURON_0.MEM a_211321_324119# 0.01092f
C2872 w_207989_323975# a_211321_324119# 0.23933f
C2873 a_191417_108495# a_191975_108410# 0
C2874 a_191417_110495# QDLL_TOP_0.CPIN 0.04508f
C2875 user_project_wrapper_0.analog_io[15] a_190389_101343# 0.93896f
C2876 a_188296_99070# QDLL_TOP_0.VOUT 0.00186f
C2877 a_211153_325997# a_210621_326377# 0
C2878 a_210621_325263# a_208855_324776# 0.03792f
C2879 a_304705_360372# a_305035_360458# 0.03774f
C2880 user_project_wrapper_0.sg13g2_IOPadAnalog_9.padres a_78824_133051# 0.07869f
C2881 user_project_wrapper_0.sg13g2_IOPadAnalog_22.padres a_209104_330851# 0
C2882 a_208071_330851# a_208017_327918# 0.00318f
C2883 a_190297_329719# a_192354_329814# 0
C2884 a_191438_329719# a_192738_330453# 0
C2885 a_300415_35456# a_301075_35456# 0.02109f
C2886 a_300745_39542# a_301075_35542# 0.03774f
C2887 user_project_wrapper_0.VDD1 a_85989_241748# 0.13303f
C2888 a_190954_330851# a_190501_329719# 0
C2889 user_project_wrapper_0.sg13g2_IOPadAnalog_17.padres user_project_wrapper_0.analog_io[30] 0.28643f
C2890 a_182218_343292# user_project_wrapper_0.analog_io[30] 0.05479f
C2891 user_project_wrapper_0.IOVDD2 a_121765_39542# 0.01881f
C2892 a_78824_128711# user_project_wrapper_0.sg13g2_IOPadAnalog_8.padres 0.12079f
C2893 user_project_wrapper_0.sg13g2_IOPadAnalog_22.padres a_208469_327099# 0.00896f
C2894 user_project_wrapper_0.IOVDD1 a_35456_75355# 0.01409f
C2895 a_208367_325263# a_208469_327099# 0
C2896 TOP_ROILIFNEURON_0.MEM a_192738_325785# 0.00793f
C2897 a_191438_326377# a_191438_327491# 0.03071f
C2898 a_211537_327798# a_209480_327491# 0
C2899 a_211153_327798# a_210007_327491# 0
C2900 a_208469_327491# a_208367_327491# 0.11107f
C2901 a_209041_327491# a_208939_327491# 0.11127f
C2902 user_project_wrapper_0.analog_io[6] user_project_wrapper_0.sg13g2_IOPadAnalog_14.padres 0.33115f
C2903 a_190501_328605# a_190297_329719# 0
C2904 a_35542_79975# a_35542_79645# 0.37213f
C2905 a_360372_78325# VDD3 0.00238f
C2906 a_208939_325263# a_209869_324119# 0.00202f
C2907 user_project_wrapper_0.VDD2 a_121105_39542# 0.00175f
C2908 user_project_wrapper_0.sg13g2_IOPadAnalog_21.padres a_209230_324119# 0.00303f
C2909 user_project_wrapper_0.IOVDD1 a_35456_304375# 0.0145f
C2910 a_210007_325263# a_211921_325785# 0
C2911 a_209684_325263# a_211537_325570# 0
C2912 a_209480_325263# a_211153_325570# 0
C2913 a_35542_78325# a_35542_77995# 0.37213f
C2914 a_86046_241645# a_82846_241091# 0.08395f
C2915 TOP_ROILIFNEURON_0.MEM a_211153_327798# 0.0011f
C2916 user_project_wrapper_0.analog_io[29] user_project_wrapper_0.IOVDD4 0.10967p
C2917 a_360458_300085# a_360458_299755# 0.37213f
C2918 m1_83011_126179# m2_83010_126180# 0.0242f
C2919 a_360458_74365# VDD3 0
C2920 a_296625_189595# a_301509_196360# 0.03706f
C2921 a_296732_197880# a_296731_189665# 0.19757f
C2922 a_210109_330241# a_210109_329719# 0
C2923 a_211321_324119# a_208855_324776# 0.38445f
C2924 a_307232_196607# a_311846_195517# 0.34733f
C2925 a_79038_123982# user_project_wrapper_0.sg13g2_IOPadAnalog_9.padres 0.16088f
C2926 a_208367_325263# a_210417_325263# 0.01189f
C2927 a_208939_325263# a_209480_325263# 0.22762f
C2928 a_89114_129426# a_89114_129061# 0.09189f
C2929 a_84598_130577# a_89114_127896# 0.02434f
C2930 a_189921_331343# a_189756_329719# 0
C2931 a_188888_331343# a_189184_329719# 0
C2932 user_project_wrapper_0.VDD1 a_84598_130212# 0
C2933 a_311189_211724# a_296731_208493# 5.04895f
C2934 a_189921_331343# user_project_wrapper_0.sg13g2_IOPadAnalog_17.padres 0
C2935 QDLL_TOP_0.CPIN a_192492_108495# 0.15064f
C2936 a_189184_325263# a_191970_325785# 0
C2937 user_project_wrapper_0.IOVDD1 a_35542_299755# 0
C2938 a_187852_90557# a_188408_90472# 0
C2939 a_187852_92557# a_188966_92557# 0.00941f
C2940 a_190721_331163# a_190868_330987# 0.03813f
C2941 a_79038_127856# user_project_wrapper_0.sg13g2_IOPadAnalog_8.padres 0.01719f
C2942 user_project_wrapper_0.VDD1 user_project_wrapper_0.sg13g2_IOPadOut4mA$1_1.sg13g2_GateLevelUpInv_noptap$1$1_0.pgate 0.40724f
C2943 TOP_ROILIFNEURON_0.MEM a_192138_324119# 0.01092f
C2944 user_project_wrapper_0.VDD1 m2_81766_242000# 0
C2945 a_82826_124842# a_85359_125209# 0
C2946 user_project_wrapper_0.sg13g2_IOPadIn$1_0.p2c a_82840_127455# 0.01185f
C2947 a_85875_125209# a_87627_124843# 0
C2948 a_82872_125209# a_83592_125209# 0
C2949 a_85211_124842# a_88291_125210# 0
C2950 a_186397_108495# user_project_wrapper_0.analog_io[13] 0.19784f
C2951 a_79025_126994# a_79025_124824# 0
C2952 w_188806_323975# a_192745_324776# 0.13437f
C2953 a_360458_304705# a_360458_304375# 0.37213f
C2954 a_78325_360458# user_project_wrapper_0.IOVDD4 0
C2955 a_189286_326377# a_190824_326377# 0
C2956 a_192738_326892# a_191234_326377# 0
C2957 a_190926_326377# a_189184_326377# 0.026f
C2958 a_190722_326377# a_190501_326377# 0.05425f
C2959 a_191970_327104# a_191438_326377# 0.00193f
C2960 a_87468_125419# user_project_wrapper_0.VDD1 0.61534f
C2961 TOP_ROILIFNEURON_0.MEM a_191970_329120# 0.0011f
C2962 user_project_wrapper_0.IOVDD1 user_project_wrapper_0.sg13g2_IOPadAnalog_28.padres 1.36563f
C2963 QDLL_TOP_0.VDD QDLL_TOP_0.VOUT 3.80343f
C2964 user_project_wrapper_0.IOVDD2 a_299755_35542# 0
C2965 w_188704_327938# a_190926_328605# 0.01287f
C2966 a_82859_242012# a_82859_241546# 0.04646f
C2967 user_project_wrapper_0.sg13g2_IOPadOut4mA$1_1.sg13g2_GateLevelUpInv_noptap$1$1_0.ngate user_project_wrapper_0.sg13g2_IOPadOut4mA$1_1.sg13g2_GateLevelUpInv_noptap$1$1_0.pgate 2.96777f
C2968 a_360458_77665# a_360458_77335# 0.37213f
C2969 a_189921_331163# a_189184_329719# 0
C2970 TOP_ROILIFNEURON_0.MEM a_190954_330851# 0.00132f
C2971 user_project_wrapper_0.VDD1 a_82658_128838# 0
C2972 w_207883_330166# a_209104_330851# 0.06087f
C2973 IOVDD3 a_355784_286861# 1.92793f
C2974 a_35542_302395# a_35542_302065# 0.37213f
C2975 user_project_wrapper_0.IOVDD1 a_41636_246061# 1.92793f
C2976 a_355624_237844# analog_io[23] 25.1197f
C2977 user_project_wrapper_0.sg13g2_IOPadAnalog_6.padres a_187914_99087# 0.00865f
C2978 a_76675_360458# a_77005_360458# 0.37213f
C2979 user_project_wrapper_0.IOVDD2 a_197044_41476# 58.9173f
C2980 a_82645_240231# user_project_wrapper_0.analog_io[4] 0.00706f
C2981 a_82846_240684# a_82846_242854# 0
C2982 TOP_ROILIFNEURON_0.MEM a_192354_326677# 0.01123f
C2983 user_project_wrapper_0.sg13g2_IOPadAnalog_19.padres a_189756_328605# 0.17489f
C2984 a_73705_360458# a_74035_360458# 0.37213f
C2985 a_190926_325785# a_190501_326377# 0
C2986 w_188704_326203# a_192354_326465# 0.0018f
C2987 user_project_wrapper_0.sg13g2_IOPadIn$1_2.sg13g2_LevelDown_noptap$1_0.sg13g2_SecondaryProtection$1$1_0.core user_project_wrapper_0.ui_PAD[31] 0.02881f
C2988 a_78220_128592# a_79025_129571# 0
C2989 a_84598_130577# a_86594_129426# 0.02597f
C2990 a_190304_110495# a_191417_110495# 0.00947f
C2991 a_190304_108495# a_190862_108410# 0
C2992 w_207989_323975# a_208792_324119# 0.09666f
C2993 w_207887_326203# a_209638_324119# 0
C2994 user_project_wrapper_0.sg13g2_IOPadAnalog_9.padres a_79025_136081# 0.00684f
C2995 a_304045_360372# a_304375_360458# 0.03774f
C2996 a_209104_330987# a_208367_329719# 0
C2997 a_189756_329719# a_190722_329327# 0
C2998 a_189756_325263# a_191438_328605# 0.00124f
C2999 a_209940_324686# a_209905_325785# 0
C3000 a_190297_329719# a_191970_330026# 0
C3001 a_190824_329719# a_188920_324155# 0
C3002 a_190824_327491# a_191234_327491# 0.15379f
C3003 a_299755_35456# a_300415_35456# 0.02109f
C3004 a_300085_39542# a_300415_35542# 0.03774f
C3005 user_project_wrapper_0.VDD1 user_project_wrapper_0.sg13g2_IOPadIn$1_1.p2c 7.22264f
C3006 user_project_wrapper_0.VDD1 user_project_wrapper_0.sg13g2_IOPadOut4mA$1_1.sg13g2_GateLevelUpInv_noptap$1$1_0.ngate 0.29858f
C3007 user_project_wrapper_0.sg13g2_IOPadAnalog_19.padres a_190824_328605# 0
C3008 a_188888_330851# a_189184_325263# 0.00373f
C3009 user_project_wrapper_0.IOVDD2 a_120445_39542# 0.01881f
C3010 a_77638_59490# user_project_wrapper_0.sg13g2_IOPadIn$1_1.sg13g2_LevelDown_noptap$1_0.sg13g2_SecondaryProtection$1$1_0.core 0.37988f
C3011 user_project_wrapper_0.sg13g2_IOPadIn$1_0.p2c a_79025_138251# 0.02852f
C3012 user_project_wrapper_0.IOVDD1 a_35456_76675# 0.01409f
C3013 TOP_ROILIFNEURON_0.MEM a_192354_325997# 0.00168f
C3014 a_74695_364458# user_project_wrapper_0.IOVDD4 0.01409f
C3015 a_35542_80635# a_35542_80305# 0.37213f
C3016 a_360372_79645# VDD3 0
C3017 user_project_wrapper_0.VDD2 a_119785_39542# 0.00198f
C3018 w_207887_326203# a_209684_325263# 0.10247f
C3019 a_189184_325263# a_190926_326377# 0
C3020 a_188834_326341# a_189286_326377# 0.0029f
C3021 a_189756_325263# a_189858_326377# 0.00133f
C3022 a_209684_328605# a_211153_329120# 0
C3023 a_209684_325263# a_210621_325263# 0.00396f
C3024 a_209480_325263# a_210109_325785# 0.01192f
C3025 a_210007_325263# a_209905_325785# 0.20881f
C3026 a_190722_325263# a_190757_324686# 0
C3027 user_project_wrapper_0.sg13g2_IOPadAnalog_6.padres a_190218_98097# 0.02946f
C3028 a_35542_78985# a_35542_78655# 0.37213f
C3029 analog_io[25] a_355624_258244# 25.1197f
C3030 w_207887_327938# a_211921_328225# 0.0018f
C3031 m2_83010_126180# user_project_wrapper_0.sg13g2_IOPadIn$1_0.p2c 0.05566f
C3032 user_project_wrapper_0.VDD1 a_35542_73705# 0
C3033 a_304995_198817# a_296625_189595# 0.05092f
C3034 a_307232_196607# a_296732_197880# 0.00228f
C3035 a_208792_324119# a_208855_324776# 0.45527f
C3036 a_309516_194555# a_309917_199879# 6.48455f
C3037 a_209684_329719# a_211537_329814# 0
C3038 a_211153_330453# a_211153_330241# 0.01085f
C3039 a_210621_329719# a_211537_330241# 0.00953f
C3040 a_210007_329719# a_210109_329719# 0.10233f
C3041 a_209480_329719# a_211153_329814# 0
C3042 a_314793_201808# a_314697_196700# 8.55264f
C3043 a_189609_324119# a_187364_324106# 0.25303f
C3044 a_188988_324119# a_189184_326377# 0.00275f
C3045 TOP_ROILIFNEURON_0.MEM a_192738_328225# 0.00499f
C3046 a_189184_326377# a_189756_328605# 0
C3047 a_209940_324686# a_210645_324119# 0
C3048 a_209869_324119# a_210983_324119# 0
C3049 user_project_wrapper_0.VDD1 a_79038_130026# 0.09634f
C3050 a_300415_364458# a_300415_360458# 0.03774f
C3051 a_29836_205261# a_29676_197044# 0.01778f
C3052 a_189184_325263# a_191438_325263# 0.0018f
C3053 a_189756_325263# a_190722_325785# 0.01434f
C3054 a_188834_326341# a_189858_325785# 0.01917f
C3055 user_project_wrapper_0.IOVDD1 a_35542_301075# 0
C3056 a_186731_92558# a_187852_92557# 0.00895f
C3057 user_project_wrapper_0.sg13g2_IOPadAnalog_19.padres a_190501_325263# 0
C3058 a_78824_130881# a_79025_131334# 1.02588f
C3059 a_85127_131750# a_86594_130470# 0.11379f
C3060 a_79025_131741# a_79038_130492# 0.01221f
C3061 analog_io[20] a_369296_156244# 9.69836f
C3062 a_85052_125418# a_85435_125173# 0.02964f
C3063 a_83490_125209# a_85257_125209# 0.00201f
C3064 a_210417_325263# a_210307_324119# 0.00283f
C3065 w_188704_326203# a_190686_324119# 0
C3066 a_192354_328693# a_192354_328225# 0.00322f
C3067 w_188806_323975# a_190047_324119# 0.21114f
C3068 a_268697_100118# QDLL_TOP_0.VDD 0.31645f
C3069 a_360458_305365# a_360458_305035# 0.37213f
C3070 a_77005_360458# user_project_wrapper_0.IOVDD4 0
C3071 a_189756_325263# a_190926_328013# 0.00123f
C3072 a_305365_39542# a_305365_35542# 0.03774f
C3073 user_project_wrapper_0.analog_io[0] user_project_wrapper_0.sg13g2_IOPadAnalog_8.padres 0.33115f
C3074 a_191970_327104# a_190501_326377# 0
C3075 a_83050_125173# user_project_wrapper_0.VDD1 0.25385f
C3076 QDLL_TOP_0.VDD a_269079_100182# 0.19513f
C3077 user_project_wrapper_0.IOVDD2 a_116485_39542# 0.01881f
C3078 a_83925_130212# a_79025_131741# 0.00177f
C3079 a_360458_78325# a_360458_77995# 0.37213f
C3080 a_188888_331163# a_189184_325263# 0
C3081 m1_84637_201313# user_project_wrapper_0.sg13g2_IOPadIn$1_1.p2c 0.02343f
C3082 a_211170_331163# a_210051_330987# 0.02034f
C3083 a_190722_325785# a_190722_325263# 0
C3084 a_369296_135844# IOVDD3 0.16358f
C3085 user_project_wrapper_0.VDD2 a_115825_39542# 0
C3086 user_project_wrapper_0.VDD1 a_86594_129061# 0
C3087 w_188700_330166# a_189921_330851# 0.06087f
C3088 a_35542_303055# a_35542_302725# 0.37213f
C3089 a_189184_325263# a_188988_324119# 0.00114f
C3090 a_189184_325263# a_189756_328605# 0
C3091 a_189184_329719# a_190722_329719# 0.01977f
C3092 a_189756_329719# a_190926_329719# 0
C3093 a_190501_329719# a_189858_329719# 0
C3094 a_86407_241748# a_82846_243261# 0
C3095 a_83070_130577# a_83796_129203# 0.00216f
C3096 a_79025_125231# a_84288_130212# 0
C3097 a_76015_360458# a_76345_360458# 0.37213f
C3098 a_82859_241546# a_82846_242854# 0.71261f
C3099 a_82846_241091# user_project_wrapper_0.analog_io[4] 0
C3100 a_82433_130212# a_83398_130212# 0.05224f
C3101 a_35456_73375# a_35542_73375# 0.03774f
C3102 TOP_ROILIFNEURON_0.MEM a_191970_326892# 0.00109f
C3103 a_190501_325263# a_189184_326377# 0
C3104 a_190297_325263# a_189756_326377# 0
C3105 w_188704_326203# a_189286_326377# 0.01319f
C3106 a_189190_110495# a_190304_110495# 0.00945f
C3107 a_189190_108495# a_189748_108410# 0
C3108 user_project_wrapper_0.sg13g2_IOPadAnalog_9.padres a_78218_138195# 0.00256f
C3109 user_project_wrapper_0.analog_io[15] a_190319_102855# 0.44444f
C3110 a_303385_360372# a_303715_360458# 0.03774f
C3111 a_188834_327918# a_190297_328605# 0
C3112 a_189756_325263# a_190501_328605# 0.02017f
C3113 a_188834_326341# a_189184_328605# 0.02896f
C3114 a_88274_127531# a_86507_129255# 0
C3115 user_project_wrapper_0.sg13g2_IOPadAnalog_22.padres a_207638_330987# 0.01059f
C3116 a_202114_326125# a_205385_326221# 4.49535f
C3117 a_189756_327491# a_189184_327491# 0.83724f
C3118 a_190824_329719# a_190926_330241# 0.22366f
C3119 a_190297_329719# a_191438_329719# 0.00342f
C3120 a_208103_324155# a_208939_326377# 1.04211f
C3121 a_211170_330987# a_211170_330851# 0.29305f
C3122 user_project_wrapper_0.sg13g2_IOPadOut4mA$1_1.c2p user_project_wrapper_0.analog_io[7] 0.06417f
C3123 a_191987_331163# a_191987_331343# 0.12339f
C3124 user_project_wrapper_0.IOVDD2 a_119125_39542# 0.01881f
C3125 a_35542_79975# user_project_wrapper_0.IOVDD1 0
C3126 a_360458_74035# a_360458_73705# 0.37213f
C3127 TOP_ROILIFNEURON_0.MEM a_190824_325263# 0
C3128 a_208367_328605# a_208469_328013# 0.04318f
C3129 a_208939_328605# a_209041_328013# 0.03255f
C3130 user_project_wrapper_0.IOVDD1 a_35456_77995# 0.01409f
C3131 a_73375_364458# user_project_wrapper_0.IOVDD4 0.01409f
C3132 a_35542_81295# a_35542_80965# 0.37213f
C3133 a_360372_80965# VDD3 0.00238f
C3134 w_188806_323975# a_191234_325263# 0
C3135 user_project_wrapper_0.VDD2 a_118465_39542# 0.00238f
C3136 w_188704_326203# a_189858_325785# 0.01319f
C3137 a_211153_329814# a_211153_329332# 0.0031f
C3138 a_208939_328605# a_209905_329327# 0.00596f
C3139 a_209684_328605# a_208469_329327# 0
C3140 a_210417_326377# a_211153_326892# 0
C3141 a_209480_329719# a_208103_324155# 0
C3142 a_210007_329719# a_211921_330241# 0
C3143 a_301940_196388# a_296732_197880# 3.66597f
C3144 a_304090_197941# a_304196_197873# 0.82487f
C3145 user_project_wrapper_0.VDD1 a_35542_75025# 0
C3146 a_296626_197740# a_296625_189595# 0.07461f
C3147 a_209684_329719# a_211153_330026# 0
C3148 a_296732_200582# a_307232_196607# 0
C3149 a_190824_326377# a_188920_324155# 0
C3150 a_369296_237844# a_369456_246061# 0.01778f
C3151 a_210137_331343# a_210051_330987# 0.00565f
C3152 a_208171_324119# a_209940_324686# 0
C3153 a_208792_324119# a_209638_324119# 0
C3154 w_188704_327938# a_191970_328225# 0.0018f
C3155 a_206547_324106# user_project_wrapper_0.analog_io[32] 0
C3156 a_189184_325263# a_190501_325263# 0.76326f
C3157 user_project_wrapper_0.sg13g2_IOPadAnalog_22.padres user_project_wrapper_0.analog_io[34] 0.33125f
C3158 user_project_wrapper_0.IOVDD1 a_35542_302395# 0
C3159 a_208939_329719# a_210109_329719# 0
C3160 a_208367_329719# a_209905_329719# 0.01977f
C3161 user_project_wrapper_0.sg13g2_IOPadAnalog_22.padres a_208939_328605# 0.00777f
C3162 a_85052_125418# user_project_wrapper_0.sg13g2_IOPadIn$1_0.p2c 0.00819f
C3163 a_208367_325263# a_208939_328605# 0
C3164 user_project_wrapper_0.sg13g2_IOPadAnalog_17.padres user_project_wrapper_0.analog_io[29] 0.33125f
C3165 a_79038_132196# a_79025_131741# 0.02952f
C3166 a_79025_133504# a_79025_131334# 0
C3167 a_211921_326677# a_211921_326892# 0.01056f
C3168 a_81295_364458# a_81625_360458# 0.03774f
C3169 a_80965_360372# user_project_wrapper_0.sg13g2_IOPadVdd_3.sg13g2_RCClampResistor_0.p2 0.02109f
C3170 a_82667_125418# a_83490_125209# 0.23138f
C3171 a_82826_124842# a_82872_125209# 0.08174f
C3172 user_project_wrapper_0.analog_io[11] user_project_wrapper_0.VDD2 19.8007f
C3173 a_188296_101407# QDLL_TOP_0.VDD 0.21351f
C3174 a_360458_306025# a_360458_305695# 0.37213f
C3175 w_188704_327938# a_189756_328605# 0.28279f
C3176 a_75685_360458# user_project_wrapper_0.IOVDD4 0
C3177 a_190686_324119# a_191800_324119# 0
C3178 a_190757_324686# a_191462_324119# 0
C3179 user_project_wrapper_0.sg13g2_IOPadAnalog_29.padres a_343292_202618# 0.0512f
C3180 a_304705_39542# a_304705_35542# 0.03774f
C3181 user_project_wrapper_0.VDD1 a_82645_242401# 2.73419f
C3182 a_79025_126994# user_project_wrapper_0.VDD1 1.75375f
C3183 a_79025_127401# a_79025_131741# 0.18001f
C3184 user_project_wrapper_0.IOVDD2 a_115165_39542# 0.01881f
C3185 a_200038_338690# user_project_wrapper_0.sg13g2_IOPadIn$1_2.p2c 0.27409f
C3186 w_188704_327938# a_190824_328605# 0.11541f
C3187 a_360458_78985# a_360458_78655# 0.37213f
C3188 a_86507_127725# a_87105_130835# 0
C3189 w_188704_326203# a_189184_328605# 0
C3190 a_209104_331163# a_207985_330987# 0.02034f
C3191 a_190501_325263# a_189286_325263# 0
C3192 a_190824_325263# a_192354_325570# 0
C3193 a_314697_196700# VDD3 25.4006f
C3194 a_191234_325263# a_191970_325570# 0
C3195 a_210417_326377# a_208939_327491# 0
C3196 a_192354_327104# a_192354_327586# 0.0031f
C3197 user_project_wrapper_0.analog_io[13] a_191975_108410# 0.00725f
C3198 user_project_wrapper_0.VDD2 a_114505_39542# 0.03085f
C3199 a_189858_328605# a_189756_328605# 0.2219f
C3200 a_188834_326341# a_188920_324155# 0.0909f
C3201 a_35456_74035# a_35542_74035# 0.03774f
C3202 a_39542_74365# a_39542_73705# 0.02109f
C3203 a_79025_127401# a_82746_130212# 0.08014f
C3204 a_141418_56308# user_project_wrapper_0.analog_io[10] 0.05479f
C3205 a_364458_300415# IOVDD3 0.01555f
C3206 a_190501_328605# a_190926_328605# 0.00489f
C3207 a_190824_328605# a_189858_328605# 0
C3208 a_189184_328605# a_191970_328905# 0
C3209 a_188074_108495# a_188632_108410# 0
C3210 a_188074_110495# a_189190_110495# 0.00939f
C3211 a_302725_360372# a_303055_360458# 0.03774f
C3212 a_91090_127895# a_86507_129255# 0.0014f
C3213 a_188408_90472# user_project_wrapper_0.analog_io[13] 0.00333f
C3214 a_211537_328905# a_211537_328693# 0.01085f
C3215 user_project_wrapper_0.analog_io[14] a_223018_56308# 0.05479f
C3216 a_207985_330987# a_208071_330851# 0.00843f
C3217 a_57810_282219# a_57810_281517# 0.00446f
C3218 user_project_wrapper_0.IOVDD2 a_117805_39542# 0.01881f
C3219 a_35542_81295# user_project_wrapper_0.IOVDD1 0
C3220 a_360458_74695# a_360458_74365# 0.37213f
C3221 QDLL_TOP_0.VOUT a_278644_29676# 9.69836f
C3222 TOP_ROILIFNEURON_0.MEM a_211153_326677# 0.00105f
C3223 user_project_wrapper_0.VDD2 a_117145_39542# 0.00238f
C3224 user_project_wrapper_0.sg13g2_IOPadAnalog_9.padres user_project_wrapper_0.sg13g2_IOPadAnalog_8.padres 0.14263f
C3225 a_211153_330026# a_210621_328605# 0
C3226 a_314793_198352# user_project_wrapper_0.sg13g2_IOPadAnalog_29.padres 0.00435f
C3227 user_project_wrapper_0.sg13g2_IOPadIn$1_2.p2c a_208939_326377# 0.00123f
C3228 a_190926_325263# a_188920_324155# 0
C3229 a_191438_327491# a_192354_327798# 0.0091f
C3230 IOVDD3 analog_io[26] 0.10967p
C3231 a_190490_102497# QDLL_TOP_0.CPIN 0.10076f
C3232 user_project_wrapper_0.IOVDD1 a_29676_237844# 0.16358f
C3233 a_209684_329719# a_210621_329719# 0.00396f
C3234 a_213462_327536# a_213870_324142# 4.49535f
C3235 a_210007_329719# a_209905_330241# 0.20881f
C3236 a_301940_196388# a_296732_200582# 3.68273f
C3237 a_296626_197740# a_301423_202742# 0.09804f
C3238 a_296625_208423# a_301509_202742# 0.03706f
C3239 a_301186_192011# a_304995_198817# 0.43572f
C3240 a_29836_144061# a_29676_135844# 0.01778f
C3241 a_209480_329719# a_210109_330241# 0.01195f
C3242 a_189672_324776# a_194687_324142# 0.01061f
C3243 a_82859_242012# a_82846_243261# 0.01125f
C3244 user_project_wrapper_0.ui_PAD[2] a_56308_159337# 0.04422f
C3245 a_92512_127896# a_92512_127531# 0.09189f
C3246 a_208017_326341# a_208103_324155# 0.0909f
C3247 a_79025_133911# a_78220_130691# 0
C3248 a_78824_133051# a_78220_132587# 0
C3249 a_79025_133504# a_79038_132662# 0.70614f
C3250 a_208071_330851# a_208367_328605# 0
C3251 a_211537_326677# a_210621_326377# 0.00953f
C3252 user_project_wrapper_0.sg13g2_IOPadOut4mA$1_1.c2p a_86970_241383# 0.10266f
C3253 a_83492_127455# a_85127_131750# 0.22163f
C3254 a_80635_364458# a_80965_360458# 0.03774f
C3255 a_79025_129164# a_79025_131334# 0
C3256 a_80305_360372# a_80965_360372# 0.02109f
C3257 TOP_ROILIFNEURON_0.MEM a_191970_330241# 0.00105f
C3258 a_79038_126152# a_79038_125686# 0.04646f
C3259 a_190584_102855# QDLL_TOP_0.VDD 0
C3260 a_191438_328605# a_191970_328225# 0
C3261 a_189184_328605# a_189286_327491# 0.02124f
C3262 w_188704_326203# a_188920_324155# 0.0253f
C3263 a_93461_128591# a_93204_129062# 0.0497f
C3264 a_188988_324119# a_190757_324686# 0
C3265 a_189609_324119# a_190455_324119# 0
C3266 a_296731_189665# a_314793_197200# 0.34805f
C3267 a_304045_39542# a_304045_35542# 0.03774f
C3268 a_83796_129203# a_79025_136081# 0.00535f
C3269 a_208939_326377# a_208367_326377# 0.8695f
C3270 a_82658_129203# a_83796_129203# 0.04484f
C3271 a_360458_79645# a_360458_79315# 0.37213f
C3272 user_project_wrapper_0.sg13g2_IOPadAnalog_6.padres a_269799_100118# 0.00831f
C3273 a_189148_101407# QDLL_TOP_0.VOUT 0
C3274 user_project_wrapper_0.analog_io[13] a_189748_108410# 0.00725f
C3275 a_304889_199957# VDD3 0.23915f
C3276 a_192354_329332# a_192354_329814# 0.0031f
C3277 a_77737_56308# user_project_wrapper_0.VDD1 0
C3278 a_189756_325263# a_191438_329719# 0
C3279 a_189756_329719# a_190722_330241# 0.01222f
C3280 a_189184_329719# a_189858_330241# 0.01645f
C3281 a_189286_327099# a_189756_327491# 0
C3282 a_190501_326377# a_190824_327491# 0
C3283 a_190824_326377# a_190501_327491# 0
C3284 a_190297_326377# a_190297_327491# 0.03801f
C3285 a_190954_330851# a_190926_329719# 0
C3286 a_269543_100118# a_269799_100118# 0.29685f
C3287 a_35456_74695# a_35542_74695# 0.03774f
C3288 a_39542_75025# a_39542_74365# 0.02109f
C3289 a_299755_360458# user_project_wrapper_0.IOVDD4 0
C3290 a_364458_301735# IOVDD3 0.01567f
C3291 a_190501_328605# a_192354_329332# 0
C3292 a_190824_328605# a_191438_328605# 0.01253f
C3293 a_190297_328605# a_191970_329332# 0
C3294 a_186960_108495# a_187518_108410# 0
C3295 a_186960_110495# a_188074_110495# 0.00945f
C3296 a_186397_108409# a_188074_108495# 0
C3297 user_project_wrapper_0.analog_io[13] a_197044_41476# 25.1197f
C3298 a_302065_360372# a_302395_360458# 0.03774f
C3299 a_87434_127896# a_86507_129255# 0.0076f
C3300 a_189921_330851# a_189184_328605# 0
C3301 a_189858_326377# a_189756_328605# 0
C3302 a_190584_97917# user_project_wrapper_0.analog_io[13] 0
C3303 a_211921_329120# a_211921_328905# 0.01056f
C3304 user_project_wrapper_0.analog_io[13] a_182218_56308# 0.0512f
C3305 a_86507_127725# a_87434_127531# 0
C3306 a_93461_128591# a_93208_127531# 0.07349f
C3307 user_project_wrapper_0.VDD1 a_56308_243418# 0
C3308 IOVDD3 a_355784_266461# 1.92793f
C3309 user_project_wrapper_0.sg13g2_IOPadOut4mA$1_1.sg13g2_GateLevelUpInv_noptap$1$1_0.pgate a_58170_281951# 0.00721f
C3310 a_78824_124371# a_79025_125231# 0.04918f
C3311 a_305695_364458# a_306025_360458# 0.03774f
C3312 a_305365_360372# user_project_wrapper_0.sg13g2_IOPadIOVdd_2.sg13g2_RCClampResistor_0.p2 0.02109f
C3313 a_208103_324155# a_209684_327491# 0
C3314 a_208103_324155# a_209480_328605# 0
C3315 a_210621_329719# a_210621_328605# 0.03071f
C3316 a_296731_208493# a_309917_199879# 1.2179f
C3317 a_190501_325263# a_190757_324686# 0.00141f
C3318 a_190297_325263# a_190686_324119# 0
C3319 TOP_ROILIFNEURON_0.MEM a_211537_330241# 0.01123f
C3320 w_207887_326203# a_208103_324155# 0.02515f
C3321 a_209480_329719# a_210007_329719# 0.20539f
C3322 a_301186_192011# a_296626_197740# 0.34441f
C3323 user_project_wrapper_0.VDD1 a_35542_77665# 0
C3324 a_209684_329719# a_210417_329719# 0.00653f
C3325 a_78221_126292# user_project_wrapper_0.sg13g2_IOPadAnalog_9.padres 0.00707f
C3326 user_project_wrapper_0.VDD1 a_58170_281951# 0.00367f
C3327 user_project_wrapper_0.sg13g2_IOPadAnalog_17.padres a_189184_327491# 0.2073f
C3328 a_189756_325263# a_190297_327491# 0.02326f
C3329 a_188834_327918# a_190824_327491# 0
C3330 a_188834_326341# a_190501_327491# 0
C3331 a_189756_329719# a_189184_327491# 0
C3332 user_project_wrapper_0.IOVDD2 a_135844_29676# 0.16358f
C3333 a_92512_127896# a_93208_127531# 0.11196f
C3334 a_84332_125209# a_86594_127531# 0
C3335 a_188920_324155# a_189286_327491# 0
C3336 a_208939_329719# a_209905_330241# 0.01222f
C3337 a_208367_329719# a_209041_330241# 0.01645f
C3338 a_208939_325263# a_210621_329719# 0
C3339 user_project_wrapper_0.sg13g2_IOPadAnalog_21.padres user_project_wrapper_0.IOVDD4 1.36563f
C3340 a_364458_75355# IOVDD3 0.01409f
C3341 a_79025_135674# a_79025_133504# 0
C3342 a_78219_134797# a_79038_134366# 0.17968f
C3343 a_79038_134832# a_79025_133911# 0.00141f
C3344 a_82846_243261# a_82846_242854# 0
C3345 a_82348_128838# a_79025_131741# 0.04575f
C3346 a_86594_129426# a_86594_130470# 0
C3347 user_project_wrapper_0.sg13g2_IOPadOut4mA$1_1.sg13g2_GateLevelUpInv_noptap$1$1_0.ngate a_58170_281951# 0.61937f
C3348 a_190824_328605# a_190926_328013# 0.00167f
C3349 a_89953_129061# a_93461_128591# 0.1113f
C3350 a_86507_127725# a_91090_129425# 0.04985f
C3351 w_188700_330166# a_192738_330453# 0.0018f
C3352 a_303385_39542# a_303385_35542# 0.03774f
C3353 a_305619_187719# a_296731_189665# 0.00723f
C3354 a_311108_179669# VDD3 14.6157f
C3355 a_84598_130212# a_83925_130212# 0.02474f
C3356 a_83079_128838# a_79025_127401# 0
C3357 a_189148_99070# a_189016_99480# 0.38927f
C3358 a_189729_99046# a_190389_99046# 0.7244f
C3359 a_360458_80305# a_360458_79975# 0.37213f
C3360 user_project_wrapper_0.analog_io[13] a_187518_108410# 0.01104f
C3361 a_190501_325263# a_190722_325785# 0.05425f
C3362 a_314793_201808# VDD3 1.03147f
C3363 IOVDD3 a_364458_298435# 0.01567f
C3364 a_191970_327104# a_191438_327491# 0
C3365 user_project_wrapper_0.sg13g2_IOPadAnalog_22.padres a_202114_326125# 0
C3366 a_190501_328605# a_189756_328605# 0.20478f
C3367 a_189184_329719# a_191234_329719# 0.01121f
C3368 a_190501_329719# a_190824_329719# 0.34427f
C3369 a_87627_124843# a_86507_129255# 0.10861f
C3370 a_298435_360458# user_project_wrapper_0.IOVDD4 0
C3371 a_39542_75685# a_39542_75025# 0.02109f
C3372 a_35456_75355# a_35542_75355# 0.03774f
C3373 a_29836_225661# a_29676_217444# 0.01778f
C3374 user_project_wrapper_0.sg13g2_IOPadAnalog_14.padres user_project_wrapper_0.analog_io[4] 0.03126f
C3375 a_190501_328605# a_190824_328605# 0.34324f
C3376 a_189184_328605# a_191234_328605# 0.0113f
C3377 a_364458_303055# IOVDD3 0.01555f
C3378 user_project_wrapper_0.IOVDD1 a_58170_281249# 0.30985f
C3379 a_301405_360372# a_301735_360458# 0.03774f
C3380 a_208469_325263# a_206547_324106# 0
C3381 user_project_wrapper_0.VDD1 a_79038_130492# 0.09487f
C3382 a_210621_328605# a_211153_328905# 0.00381f
C3383 a_86507_127725# a_84332_125209# 0.4481f
C3384 a_91911_129060# a_89953_127531# 0.00206f
C3385 a_89953_129061# a_92512_127896# 0.04909f
C3386 a_39542_304705# a_39542_304045# 0.02109f
C3387 a_35456_304375# a_35542_304375# 0.03774f
C3388 TOP_ROILIFNEURON_0.MEM a_211921_328693# 0.00499f
C3389 a_82974_125209# a_79025_125231# 0.00156f
C3390 user_project_wrapper_0.analog_io[10] user_project_wrapper_0.VDD2 19.8007f
C3391 user_project_wrapper_0.analog_io[14] a_190490_98199# 0.03478f
C3392 a_192309_90557# a_192826_90558# 0.07486f
C3393 user_project_wrapper_0.analog_io[11] user_project_wrapper_0.sg13g2_IOPadAnalog_6.padres 0.33115f
C3394 w_188704_327938# a_191234_327491# 0.22627f
C3395 a_41636_225661# a_41476_217444# 0.01916f
C3396 user_project_wrapper_0.sg13g2_IOPadAnalog_22.padres a_210007_326377# 0
C3397 a_208367_325263# a_210007_326377# 0
C3398 a_79025_125231# a_79038_127856# 0
C3399 a_87105_130835# a_93400_129062# 0
C3400 a_208017_326341# a_208367_326377# 0.14732f
C3401 a_208939_325263# a_209684_326377# 0.02221f
C3402 a_208017_327918# a_209480_326377# 0
C3403 a_83796_129203# a_83796_128838# 0.09189f
C3404 user_project_wrapper_0.VDD1 a_83925_130212# 0.31434f
C3405 a_210417_329719# a_210621_328605# 0.002f
C3406 user_project_wrapper_0.sg13g2_IOPadAnalog_21.padres a_208939_326377# 0.21115f
C3407 a_304889_198885# a_304995_198817# 1.61338f
C3408 a_78221_124694# a_79025_124824# 0.00112f
C3409 a_78824_124371# a_78220_123062# 0.01884f
C3410 user_project_wrapper_0.sg13g2_IOPadAnalog_19.padres a_191438_326377# 0
C3411 a_77638_59490# user_project_wrapper_0.VDD1 1.1848f
C3412 w_207883_330166# a_211537_330453# 0.0018f
C3413 a_39542_80305# user_project_wrapper_0.VDD1 0.00175f
C3414 a_211537_326892# a_209684_326377# 0
C3415 a_211153_326892# a_209480_326377# 0
C3416 a_208469_326377# a_208939_326377# 0
C3417 user_project_wrapper_0.VDD1 a_35542_78985# -0
C3418 user_project_wrapper_0.IOVDD2 a_304705_35542# 0
C3419 user_project_wrapper_0.sg13g2_IOPadAnalog_23.padres user_project_wrapper_0.IOVDD4 1.36563f
C3420 a_299755_364458# a_299755_360458# 0.03774f
C3421 a_89953_127531# a_91090_127895# 0.05231f
C3422 a_90579_127530# a_84332_125209# 0.07407f
C3423 a_86594_127896# a_87434_127531# 0.00936f
C3424 user_project_wrapper_0.sg13g2_IOPadIn$1_2.p2c w_207887_326203# 0
C3425 a_208939_325263# a_210417_329719# 0
C3426 a_208017_326341# a_210007_329719# 0
C3427 a_208939_329719# a_209480_329719# 0.21118f
C3428 a_208367_329719# a_209684_329719# 0.69987f
C3429 user_project_wrapper_0.IOVDD4 a_305035_364458# 0.01567f
C3430 a_77638_59490# user_project_wrapper_0.sg13g2_IOPadIn$1_1.p2c 0.27409f
C3431 a_364458_76675# IOVDD3 0.01409f
C3432 user_project_wrapper_0.sg13g2_IOPadAnalog_21.padres a_209480_329719# 0.00803f
C3433 a_79025_138251# a_79038_132662# 0
C3434 a_211170_330851# a_210621_329719# 0
C3435 a_79038_136536# a_79038_134832# 0.00178f
C3436 a_78824_135221# a_79025_135674# 1.02588f
C3437 a_78219_135283# a_78219_134797# 0.01252f
C3438 a_78985_360372# a_79645_360372# 0.02109f
C3439 a_79315_364458# a_79645_360458# 0.03774f
C3440 a_87105_130470# a_86507_129255# 0.024f
C3441 a_79038_130026# a_79038_130492# 0.04646f
C3442 a_78824_128711# a_79025_133911# 0
C3443 a_83492_130212# a_79025_131741# 0
C3444 TOP_ROILIFNEURON_0.MEM a_190824_329719# 0
C3445 user_project_wrapper_0.sg13g2_IOPadAnalog_7.padres user_project_wrapper_0.VDD2 1.74533f
C3446 a_189688_330987# a_188920_324155# 0
C3447 a_82658_129203# a_83492_127455# 0.0084f
C3448 w_188704_326203# a_194279_327536# 0
C3449 a_189396_324119# a_188920_324155# 0.00588f
C3450 a_190287_102497# user_project_wrapper_0.sg13g2_IOPadAnalog_6.padres 0
C3451 a_188760_101343# a_189016_101343# 0.29685f
C3452 a_302725_39542# a_302725_35542# 0.03774f
C3453 a_208103_324155# a_208792_324119# 0.00353f
C3454 a_189184_326377# a_191438_326377# 0.00109f
C3455 a_190297_326377# a_190722_327099# 0.00962f
C3456 a_190501_326377# a_190926_327099# 0.05288f
C3457 a_189756_326377# a_189672_324776# 0
C3458 a_210109_327491# a_209480_326377# 0
C3459 a_188572_99046# a_188760_99480# 0.45362f
C3460 a_83070_130212# a_79025_125231# 0.03589f
C3461 a_360458_80965# a_360458_80635# 0.37213f
C3462 user_project_wrapper_0.sg13g2_IOPadIn$1_0.sg13g2_LevelDown_noptap$1_0.sg13g2_SecondaryProtection$1$1_0.core a_59490_159238# 0.37988f
C3463 IOVDD3 a_364458_299755# 0.01452f
C3464 a_208939_326377# a_209480_327491# 0
C3465 a_208367_326377# a_209684_327491# 0
C3466 a_209684_326377# a_208367_327491# 0
C3467 a_209480_326377# a_208939_327491# 0.00215f
C3468 a_364458_74695# VDD3 0
C3469 a_208367_326377# a_209480_328605# 0
C3470 a_39542_76345# a_39542_75685# 0.02109f
C3471 a_35456_76015# a_35542_76015# 0.03774f
C3472 a_82846_240684# a_82859_239842# 0.70614f
C3473 a_82118_239118# a_82859_239376# 0
C3474 a_210621_327491# a_211153_328225# 0.002f
C3475 a_85155_125209# a_86507_127725# 0
C3476 a_364458_304375# IOVDD3 0.0145f
C3477 a_190501_327491# a_189286_327491# 0
C3478 a_191234_327491# a_191970_327798# 0
C3479 a_190824_327491# a_192354_327798# 0
C3480 a_210109_328605# a_209684_327491# 0
C3481 a_189756_327491# a_190722_327491# 0.00596f
C3482 w_207989_323975# a_206547_324106# 0.055f
C3483 a_360458_298105# a_360458_297775# 0.37213f
C3484 w_207887_326203# a_208367_326377# 0.3253f
C3485 m6_7020_10380# m7_6440_9800# 0.13002p
C3486 a_35542_81625# user_project_wrapper_0.IOVDD1 0
C3487 a_300745_360372# a_301075_360458# 0.03774f
C3488 user_project_wrapper_0.IOVDD1 user_project_wrapper_0.uo_PAD[8] 26.991f
C3489 a_82527_127455# a_79025_136081# 0.07801f
C3490 a_210007_328605# a_209905_328605# 0.20881f
C3491 a_209480_328605# a_210109_328605# 0.01197f
C3492 user_project_wrapper_0.VDD1 a_79038_132196# 0.09632f
C3493 a_210109_325785# a_209684_326377# 0
C3494 a_86507_127725# a_88274_127896# 0.06927f
C3495 a_35456_305035# a_35542_305035# 0.03774f
C3496 a_82658_129203# a_82527_127455# 0.01362f
C3497 a_83492_127455# a_89114_127896# 0
C3498 a_39542_305365# a_39542_304705# 0.02109f
C3499 a_360372_300085# a_360458_300085# 0.03774f
C3500 a_191196_90557# a_191751_90558# 0.06676f
C3501 a_364458_300415# a_364458_299755# 0.02109f
C3502 a_190868_330987# a_190954_330987# 0.05268f
C3503 a_79025_127401# a_82658_128838# 0
C3504 a_210007_329719# a_209480_328605# 0
C3505 a_209480_329719# a_210007_328605# 0
C3506 user_project_wrapper_0.VDD1 a_79025_127401# 2.00044f
C3507 a_296731_208493# a_304090_197941# 0.21614f
C3508 a_304889_198885# a_296626_197740# 0.40826f
C3509 a_314793_198352# a_301186_192011# 0.47389f
C3510 a_188834_326341# a_189858_327099# 0.00128f
C3511 a_189756_325263# a_190722_327099# 0.00101f
C3512 user_project_wrapper_0.sg13g2_IOPadAnalog_17.padres a_189286_327099# 0.00896f
C3513 a_190297_325263# a_188920_324155# 0.00256f
C3514 TOP_ROILIFNEURON_0.MEM a_209684_329719# 0
C3515 user_project_wrapper_0.sg13g2_IOPadAnalog_19.padres a_190501_326377# 0
C3516 w_207887_327938# a_213376_328627# 0
C3517 a_191438_328605# a_191234_327491# 0.00165f
C3518 a_209905_327099# a_209684_326377# 0.01614f
C3519 a_208855_324776# a_206547_324106# 0.52327f
C3520 a_209041_327099# a_209480_326377# 0
C3521 a_83592_125209# a_84332_125209# 0
C3522 user_project_wrapper_0.IOVDD2 a_303385_35542# 0
C3523 a_209997_324870# a_206547_324106# 0
C3524 a_298435_35542# a_298765_35542# 0.37213f
C3525 a_299095_364458# a_299095_360458# 0.03774f
C3526 a_87434_127896# a_89953_127531# 0
C3527 a_86594_127896# a_84332_125209# 0.00396f
C3528 a_82840_127455# a_83164_127820# 0.05235f
C3529 a_208367_325263# a_209905_325263# 0.01986f
C3530 a_188802_330987# user_project_wrapper_0.sg13g2_IOPadAnalog_19.padres 0
C3531 user_project_wrapper_0.VDD1 a_86594_127531# 0
C3532 a_189148_99070# QDLL_TOP_0.VDD 0.24991f
C3533 a_213376_328627# user_project_wrapper_0.analog_io[35] 0.00548f
C3534 user_project_wrapper_0.IOVDD4 a_303715_364458# 0.01452f
C3535 a_364458_77995# IOVDD3 0.01409f
C3536 user_project_wrapper_0.sg13g2_IOPadIn$1_2.p2c a_192138_324119# 0.0171f
C3537 a_176644_369296# user_project_wrapper_0.IOVDD4 0.16358f
C3538 a_78824_137391# a_78824_135221# 0
C3539 a_79025_137844# a_79025_136081# 0.09651f
C3540 a_79038_137002# a_78219_135283# 0
C3541 a_78655_364458# a_78985_360458# 0.03774f
C3542 a_78325_360372# a_78985_360372# 0.02109f
C3543 a_58170_179951# user_project_wrapper_0.IOVDD1 0.28809f
C3544 a_83070_130212# a_79025_133911# 0
C3545 a_84598_130577# a_84707_131750# 0
C3546 a_78220_128592# a_79025_131741# 0
C3547 a_192738_325570# a_189672_324776# 0
C3548 a_192738_325358# a_189672_324776# 0
C3549 a_208017_326341# a_208939_329719# 0.50671f
C3550 a_208939_325263# a_208367_329719# 0.09046f
C3551 w_188700_330166# a_190297_329719# 0.08762f
C3552 a_88274_129426# a_89953_129061# 0
C3553 a_86594_129426# a_83492_127455# 0.00287f
C3554 user_project_wrapper_0.sg13g2_IOPadAnalog_21.padres a_208017_326341# 5.11512f
C3555 a_187914_101343# a_188184_101343# 0.26306f
C3556 a_243418_343292# user_project_wrapper_0.sg13g2_IOPadAnalog_21.padres 0.0512f
C3557 a_188920_324155# a_189286_329719# 0
C3558 a_302065_39542# a_302065_35542# 0.03774f
C3559 a_360458_74035# IOVDD3 0
C3560 a_189184_326377# a_190501_326377# 0.73565f
C3561 a_189756_326377# a_190297_326377# 0.20339f
C3562 user_project_wrapper_0.sg13g2_IOPadAnalog_17.padres a_189184_329719# 0.21528f
C3563 a_188834_326341# a_190501_329719# 0
C3564 a_189756_329719# a_189184_329719# 0.92013f
C3565 user_project_wrapper_0.IOVDD2 a_299425_39542# 0.01899f
C3566 a_84598_130577# a_79025_125231# 0
C3567 user_project_wrapper_0.sg13g2_IOPadAnalog_19.padres a_188834_327918# 0.02307f
C3568 a_185968_98275# a_186431_99272# 0.00216f
C3569 a_29676_197044# user_project_wrapper_0.analog_io[4] 9.69836f
C3570 user_project_wrapper_0.IOVDD4 a_81295_360458# 0
C3571 a_208939_325263# a_209041_326377# 0.00133f
C3572 a_208017_326341# a_208469_326377# 0.0029f
C3573 a_208367_325263# a_210109_326377# 0
C3574 a_364458_76015# VDD3 0.00145f
C3575 a_210137_331343# a_209480_329719# 0
C3576 a_191751_90472# QDLL_TOP_0.CPIN 0.04508f
C3577 a_82826_124842# a_79025_131741# 0.00768f
C3578 a_39542_77005# a_39542_76345# 0.02109f
C3579 a_301575_211562# user_project_wrapper_0.sg13g2_IOPadAnalog_26.padres 0.00258f
C3580 a_35456_76675# a_35542_76675# 0.03774f
C3581 user_project_wrapper_0.sg13g2_IOPadIn$1_2.p2c a_208792_324119# 0.22922f
C3582 a_82859_241546# a_82859_239842# 0.00178f
C3583 a_209480_327491# a_210621_327491# 0.00342f
C3584 a_210007_327491# a_210109_328013# 0.22366f
C3585 TOP_ROILIFNEURON_0.MEM a_190824_326377# 0
C3586 a_87468_125419# a_86507_127725# 0.27075f
C3587 a_364458_305695# IOVDD3 0.01587f
C3588 a_83070_130577# user_project_wrapper_0.sg13g2_IOPadIn$1_0.p2c 0.01038f
C3589 a_190824_327491# a_191438_327491# 0.01253f
C3590 user_project_wrapper_0.IOVDD1 user_project_wrapper_0.sg13g2_IOPadAnalog_8.padres 1.36563f
C3591 a_210417_328605# a_210621_328605# 0.43471f
C3592 a_209480_328605# a_211537_329332# 0
C3593 a_189737_324155# a_189672_324776# 0.01192f
C3594 user_project_wrapper_0.VDD1 a_78219_134797# 0.59371f
C3595 a_89114_129426# a_89114_127896# 0
C3596 a_79025_129164# a_78220_128192# 0
C3597 a_92512_129426# a_92512_129061# 0.09189f
C3598 a_84598_130577# a_88274_127531# 0
C3599 user_project_wrapper_0.VDD1 a_86507_127725# 2.95944f
C3600 TOP_ROILIFNEURON_0.MEM a_210621_328605# 0.121f
C3601 a_82667_125418# a_79025_125231# 0.00917f
C3602 a_185968_98275# a_186430_98275# 0.04858f
C3603 a_258244_29676# user_project_wrapper_0.analog_io[16] 9.69836f
C3604 a_190082_90557# a_190638_90558# 0.06657f
C3605 user_project_wrapper_0.sg13g2_IOPadAnalog_19.padres a_189858_325263# 0.00834f
C3606 a_190319_102855# user_project_wrapper_0.analog_io[13] 0.00351f
C3607 a_188455_330987# a_188802_330987# 0.00242f
C3608 user_project_wrapper_0.sg13g2_IOPadOut4mA$1_0.sg13g2_GateLevelUpInv_noptap$1$1_0.ngate user_project_wrapper_0.sg13g2_IOPadOut4mA$1_0.sg13g2_GateLevelUpInv_noptap$1$1_0.pgate 2.96777f
C3609 user_project_wrapper_0.analog_io[7] user_project_wrapper_0.sg13g2_IOPadAnalog_13.padres 0.33115f
C3610 a_190954_331343# a_190297_329719# 0
C3611 a_190297_327491# a_189756_328605# 0.00139f
C3612 m2_81563_127336# a_82527_127455# 0.00365f
C3613 a_58798_179951# user_project_wrapper_0.sg13g2_IOPadOut4mA$1_0.sg13g2_GateLevelUpInv_noptap$1$1_0.pgate 0.04338f
C3614 a_189184_325263# a_190501_326377# 0
C3615 a_189756_325263# a_189756_326377# 0.64568f
C3616 a_188834_326341# a_187364_324106# 0
C3617 a_188834_327918# a_189184_326377# 0.48217f
C3618 TOP_ROILIFNEURON_0.MEM a_211153_325570# 0.00105f
C3619 user_project_wrapper_0.sg13g2_IOPadAnalog_22.padres a_208469_328013# 0.00182f
C3620 a_86507_127725# user_project_wrapper_0.sg13g2_IOPadIn$1_1.p2c 0.01245f
C3621 a_87673_125210# a_87775_125210# 0.3522f
C3622 a_208939_325263# a_210007_327491# 0.00304f
C3623 a_208017_326341# a_209480_327491# 0.00125f
C3624 a_208367_329719# a_208367_327491# 0.00332f
C3625 a_208367_325263# a_208469_328013# 0
C3626 user_project_wrapper_0.sg13g2_IOPadAnalog_21.padres a_209684_327491# 0
C3627 a_211921_325997# a_211921_325785# 0.01085f
C3628 a_208939_325263# a_210417_328605# 0.00184f
C3629 a_208017_327918# a_208469_329327# 0.00157f
C3630 a_208017_326341# a_210007_328605# 0
C3631 a_208939_329719# a_209480_328605# 0.0023f
C3632 a_190297_328605# a_190824_327491# 0
C3633 a_189184_328605# a_189286_328013# 0.04318f
C3634 a_190824_328605# a_190297_327491# 0
C3635 user_project_wrapper_0.sg13g2_IOPadAnalog_21.padres a_209480_328605# 0.00804f
C3636 a_85875_125209# a_84332_125209# 0.10623f
C3637 a_192738_326465# a_191438_326377# 0
C3638 a_78221_124694# user_project_wrapper_0.VDD1 0.00124f
C3639 user_project_wrapper_0.IOVDD2 a_302065_35542# 0
C3640 a_209638_324119# a_206547_324106# 0
C3641 a_208792_324119# a_208367_326377# 0
C3642 user_project_wrapper_0.sg13g2_IOPadAnalog_20.padres user_project_wrapper_0.IOVDD4 1.36563f
C3643 w_207989_323975# a_208939_325263# 0.00284f
C3644 a_188802_330987# a_189184_325263# 0
C3645 a_297775_35542# a_298105_35542# 0.37213f
C3646 a_298435_364458# a_298435_360458# 0.03774f
C3647 user_project_wrapper_0.sg13g2_IOPadAnalog_21.padres w_207887_326203# 0.0468f
C3648 a_208367_325263# a_211153_325785# 0
C3649 user_project_wrapper_0.analog_io[10] a_135844_41476# 25.1197f
C3650 a_86594_127896# a_88274_127896# 0.05732f
C3651 a_210621_326377# a_210621_327491# 0.03071f
C3652 user_project_wrapper_0.VDD1 a_90579_127530# 0.35563f
C3653 a_278644_355624# user_project_wrapper_0.IOVDD4 58.9173f
C3654 user_project_wrapper_0.analog_io[11] a_156244_29676# 9.69836f
C3655 w_188806_323975# user_project_wrapper_0.sg13g2_IOPadAnalog_17.padres 0
C3656 user_project_wrapper_0.IOVDD4 a_302395_364458# 0.01567f
C3657 analog_io[18] IOVDD3 0.10967p
C3658 user_project_wrapper_0.sg13g2_IOPadIn$1_2.p2c a_189609_324119# 0.22652f
C3659 a_314793_198352# a_315347_192648# 0.03572f
C3660 a_364458_79315# IOVDD3 0.01409f
C3661 a_314793_198352# analog_io[23] 0.42683f
C3662 a_78218_138195# a_79025_137844# 0.00113f
C3663 a_79025_138251# a_78824_137391# 0.0472f
C3664 a_77995_364458# a_78325_360458# 0.03774f
C3665 a_77665_360372# a_78325_360372# 0.02109f
C3666 a_190218_98097# QDLL_TOP_0.CPIN 0.0058f
C3667 TOP_ROILIFNEURON_0.MEM a_211537_326892# 0.01052f
C3668 a_190954_331163# a_190297_329719# 0
C3669 w_207887_326203# a_208469_326377# 0.01316f
C3670 a_263818_343292# user_project_wrapper_0.sg13g2_IOPadAnalog_22.padres 0.0512f
C3671 a_88274_129426# a_87434_129426# 0.1009f
C3672 user_project_wrapper_0.analog_io[10] user_project_wrapper_0.sg13g2_IOPadAnalog_6.padres 0.33115f
C3673 a_79025_129571# a_78824_128711# 0.04771f
C3674 a_86594_129426# a_89114_129426# 0
C3675 a_311189_211724# VDD3 16.5007f
C3676 a_211153_325570# a_208855_324776# 0
C3677 a_188184_99046# QDLL_TOP_0.VOUT 0.00856f
C3678 a_90579_127530# user_project_wrapper_0.sg13g2_IOPadIn$1_1.p2c 0.00583f
C3679 a_301405_39542# a_301405_35542# 0.03774f
C3680 user_project_wrapper_0.VDD1 a_82846_240684# 1.50498f
C3681 a_355624_278644# a_355784_286861# 0.01916f
C3682 user_project_wrapper_0.sg13g2_IOPadAnalog_17.padres a_182931_326125# 0
C3683 a_189184_325263# a_188834_327918# 0.17497f
C3684 user_project_wrapper_0.IOVDD2 a_298105_39542# 0.04966f
C3685 user_project_wrapper_0.IOVDD1 a_39542_74365# 0.01881f
C3686 user_project_wrapper_0.IOVDD1 a_58170_179249# 0.30985f
C3687 a_208939_325263# a_208855_324776# 0.00611f
C3688 a_208017_326341# a_210621_326377# 0
C3689 a_364458_77335# VDD3 0.00157f
C3690 a_211537_327798# a_210621_327491# 0.0091f
C3691 a_190926_329327# a_190297_329719# 0
C3692 a_191438_326377# a_191970_327798# 0
C3693 a_79025_125231# user_project_wrapper_0.sg13g2_IOPadAnalog_9.padres 0.00701f
C3694 a_211537_327586# a_209480_327491# 0
C3695 w_188806_323975# a_191970_325358# 0
C3696 user_project_wrapper_0.VDD2 a_122095_35456# 0.00177f
C3697 a_209480_325263# a_211153_325358# 0
C3698 a_210007_325263# a_210109_325263# 0.1023f
C3699 a_35456_77335# a_35542_77335# 0.03774f
C3700 a_39542_77665# a_39542_77005# 0.02109f
C3701 user_project_wrapper_0.sg13g2_IOPadIn$1_1.p2c a_82846_240684# 0.00563f
C3702 a_78824_126541# a_79025_131741# 0
C3703 a_85989_241383# a_85591_241383# 0
C3704 a_57810_282219# a_58798_281951# 0.14668f
C3705 a_208367_327491# a_210007_327491# 0.38483f
C3706 a_209684_327491# a_209480_327491# 0.83555f
C3707 a_208939_327491# a_210417_327491# 0
C3708 TOP_ROILIFNEURON_0.MEM a_211153_327586# 0.00105f
C3709 a_210007_328605# a_209684_327491# 0
C3710 a_209480_328605# a_209480_327491# 0.00495f
C3711 w_188704_326203# a_187364_324106# 0.00558f
C3712 a_208071_331343# a_208367_329719# 0
C3713 a_209104_331343# a_208939_329719# 0
C3714 a_211153_327104# a_211153_326892# 0.01085f
C3715 user_project_wrapper_0.VDD1 a_79038_137002# 0.09497f
C3716 a_209480_328605# a_210007_328605# 0.20528f
C3717 a_190686_324119# a_189672_324776# 0.15708f
C3718 user_project_wrapper_0.sg13g2_IOPadAnalog_21.padres a_209104_331343# 0
C3719 a_296731_189665# a_309917_194695# 1.2953f
C3720 a_79025_129571# a_79038_127856# 0
C3721 a_82348_128838# a_82658_128838# 0.00441f
C3722 a_84598_130577# a_91090_127895# 0.00383f
C3723 user_project_wrapper_0.VDD1 a_82348_128838# 0.33852f
C3724 a_299095_35456# a_299425_35542# 0.03774f
C3725 a_79025_126994# a_79025_127401# 0
C3726 w_207887_327938# a_210417_327491# 0.22627f
C3727 user_project_wrapper_0.IOVDD1 a_35542_298765# 0
C3728 a_188966_90557# a_189524_90558# 0.06619f
C3729 a_210937_330987# TOP_ROILIFNEURON_0.MEM 0.00186f
C3730 a_211084_330987# a_211170_331163# 0.01578f
C3731 a_208017_327918# a_208469_327491# 0.00298f
C3732 TOP_ROILIFNEURON_0.MEM w_188704_326203# 0.02658f
C3733 a_87673_125210# a_88291_125210# 0.02258f
C3734 w_207887_326203# a_211153_325997# 0.0018f
C3735 a_79038_125686# a_79038_123982# 0.00178f
C3736 a_85257_125209# a_85359_125209# 0.3522f
C3737 a_85211_124842# a_87571_125210# 0.01039f
C3738 a_79315_360458# user_project_wrapper_0.IOVDD4 0
C3739 a_210621_325263# a_211153_325997# 0.002f
C3740 a_83490_125209# a_82527_127455# 0
C3741 a_82826_124842# a_84332_125209# 0.10691f
C3742 TOP_ROILIFNEURON_0.MEM a_191970_328905# 0.00105f
C3743 a_209104_331163# user_project_wrapper_0.sg13g2_IOPadAnalog_22.padres 0.002f
C3744 user_project_wrapper_0.IOVDD2 a_300745_35542# 0
C3745 a_83592_125209# user_project_wrapper_0.VDD1 0.14154f
C3746 a_207638_331163# user_project_wrapper_0.sg13g2_IOPadAnalog_21.padres 0
C3747 user_project_wrapper_0.sg13g2_IOPadAnalog_8.padres a_82645_240231# 0.13967f
C3748 TOP_ROILIFNEURON_0.MEM a_211170_330851# 0.00766f
C3749 a_190954_330987# a_190954_330851# 0.29305f
C3750 a_190868_330987# a_191987_330851# 0.00843f
C3751 a_122095_35542# a_122095_35456# 0.03774f
C3752 a_191970_325570# a_191970_325358# 0.01085f
C3753 a_297775_364458# a_297775_360458# 0.03774f
C3754 a_210109_327099# a_209480_327491# 0
C3755 a_208367_325263# a_208469_325785# 0.22414f
C3756 w_188700_330166# a_189756_325263# 0.06115f
C3757 w_188704_327938# a_188834_327918# 0.33497f
C3758 user_project_wrapper_0.VDD1 a_86594_127896# 0.67002f
C3759 a_176644_355624# user_project_wrapper_0.IOVDD4 58.9173f
C3760 w_188704_326203# a_186202_326221# 0
C3761 user_project_wrapper_0.IOVDD4 a_301075_364458# 0.01563f
C3762 a_189756_325263# a_189737_324155# 0
C3763 a_364458_80635# IOVDD3 0.01409f
C3764 a_369296_156244# a_369456_164461# 0.01778f
C3765 user_project_wrapper_0.IOVDD2 a_266461_41636# 1.92793f
C3766 a_77005_360372# a_77665_360372# 0.02109f
C3767 a_77335_364458# a_77665_360458# 0.03774f
C3768 a_210137_330987# a_209684_329719# 0
C3769 a_210051_330987# a_209480_329719# 0
C3770 a_284218_343292# user_project_wrapper_0.sg13g2_IOPadAnalog_23.padres 0.0512f
C3771 TOP_ROILIFNEURON_0.MEM a_210983_324119# 0.00679f
C3772 a_360458_74695# a_364458_74695# 0.03774f
C3773 w_207887_326203# a_210621_326377# 0.08621f
C3774 a_191970_328905# a_191970_328693# 0.01085f
C3775 w_207989_323975# a_210983_324119# 0.23834f
C3776 a_191417_108495# a_191975_108496# 0.06619f
C3777 w_207887_326203# a_211928_324776# 0
C3778 a_210621_325263# a_210621_326377# 0.04294f
C3779 user_project_wrapper_0.sg13g2_IOPadAnalog_9.padres a_79025_133911# 0.00689f
C3780 user_project_wrapper_0.sg13g2_IOPadAnalog_22.padres a_208071_330851# 0.00404f
C3781 a_304705_360458# a_305035_360458# 0.37213f
C3782 a_190218_102763# a_190389_101343# 0
C3783 user_project_wrapper_0.analog_io[15] a_189729_101343# 0.01264f
C3784 a_187914_99087# QDLL_TOP_0.VOUT 0.43133f
C3785 a_208071_330851# a_208367_325263# 0.00373f
C3786 a_190297_329719# a_191970_329814# 0
C3787 a_190824_329719# a_190926_329719# 0.10233f
C3788 a_191438_329719# a_192354_330453# 0
C3789 a_300745_39542# a_300745_35542# 0.03774f
C3790 user_project_wrapper_0.VDD1 a_82859_241546# 0.0976f
C3791 a_208367_328605# a_209480_326377# 0
C3792 a_237844_369296# a_246061_369456# 0.01778f
C3793 a_189921_330851# a_190501_329719# 0.00107f
C3794 a_190954_330851# a_189184_329719# 0
C3795 a_211537_327798# a_211537_327586# 0.01085f
C3796 user_project_wrapper_0.IOVDD2 a_121435_35456# 0.01409f
C3797 user_project_wrapper_0.sg13g2_IOPadAnalog_8.padres a_79025_137844# 0.01067f
C3798 user_project_wrapper_0.sg13g2_IOPadAnalog_19.padres a_188455_330851# 0
C3799 user_project_wrapper_0.IOVDD1 a_39542_75685# 0.01881f
C3800 TOP_ROILIFNEURON_0.MEM a_192354_325785# 0.01146f
C3801 user_project_wrapper_0.sg13g2_IOPadIn$1_0.p2c a_79025_136081# 0.02881f
C3802 a_190584_97917# a_190319_97955# 0
C3803 a_364458_78655# VDD3 0.00146f
C3804 a_211153_327798# a_209480_327491# 0
C3805 a_211537_327798# a_209684_327491# 0
C3806 a_211921_328013# a_210007_327491# 0
C3807 user_project_wrapper_0.analog_io[6] a_41476_237844# 25.1197f
C3808 a_189184_328605# a_190297_329719# 0.00246f
C3809 a_82658_129203# user_project_wrapper_0.sg13g2_IOPadIn$1_0.p2c 0.02958f
C3810 a_208939_325263# a_209638_324119# 0
C3811 a_208017_326341# a_209230_324119# 0.00107f
C3812 a_208367_325263# a_209940_324686# 0.00244f
C3813 user_project_wrapper_0.VDD2 a_120775_35456# 0
C3814 user_project_wrapper_0.analog_io[14] a_217444_29676# 9.69836f
C3815 a_192354_325358# a_192138_324119# 0
C3816 user_project_wrapper_0.IOVDD1 a_39542_304705# 0.02056f
C3817 a_210007_325263# a_211537_325785# 0
C3818 a_209684_325263# a_211153_325570# 0
C3819 user_project_wrapper_0.sg13g2_IOPadIn$1_1.p2c a_82859_241546# 0
C3820 a_86046_241645# a_85989_241383# 0.59815f
C3821 a_39542_78325# a_39542_77665# 0.02109f
C3822 a_85591_241748# a_82846_241091# 0.01445f
C3823 a_35456_77995# a_35542_77995# 0.03774f
C3824 TOP_ROILIFNEURON_0.MEM a_211921_328013# 0.00699f
C3825 a_156244_369296# user_project_wrapper_0.IOVDD4 0.16358f
C3826 a_360458_74695# VDD3 0
C3827 a_191800_324119# a_187364_324106# 0
C3828 a_210983_324119# a_208855_324776# 0.20572f
C3829 a_78220_123062# user_project_wrapper_0.sg13g2_IOPadAnalog_9.padres 0.05255f
C3830 a_296732_197880# a_301509_196360# 0.00168f
C3831 a_296625_189595# a_301423_196360# 0.20064f
C3832 a_211153_330241# a_211153_330026# 0.01056f
C3833 a_307232_196607# a_309917_194695# 3.42701f
C3834 a_258244_41476# a_266461_41636# 0.01916f
C3835 a_208939_325263# a_209684_325263# 0.21029f
C3836 a_208367_325263# a_210007_325263# 0.38521f
C3837 a_84598_130577# a_87434_127896# 0.00644f
C3838 a_189921_331343# a_188834_326341# 0
C3839 a_211321_324119# a_211928_324776# 0.00122f
C3840 a_87434_129426# a_89114_129061# 0.02463f
C3841 a_313884_211353# a_314793_198352# 0.60965f
C3842 a_188888_331343# user_project_wrapper_0.sg13g2_IOPadAnalog_17.padres 0.00395f
C3843 user_project_wrapper_0.sg13g2_IOPadVdd_0.sg13g2_RCClampResistor_0.p2 a_360458_81625# 0.03777f
C3844 a_75355_364458# a_76015_364458# 0.02109f
C3845 a_191975_108410# a_192492_108495# 0.04299f
C3846 user_project_wrapper_0.IOVDD1 a_35542_300085# 0
C3847 a_187852_90557# a_188408_90558# 0.06657f
C3848 a_85977_125209# user_project_wrapper_0.sg13g2_IOPadIn$1_0.p2c 0
C3849 user_project_wrapper_0.sg13g2_IOPadAnalog_29.padres IOVDD3 1.36563f
C3850 a_192995_331163# TOP_ROILIFNEURON_0.MEM 0.01133f
C3851 a_209104_331163# a_209904_331163# 0.01525f
C3852 a_190584_97917# QDLL_TOP_0.VDD 0
C3853 a_78220_128106# user_project_wrapper_0.sg13g2_IOPadAnalog_8.padres 0.00431f
C3854 TOP_ROILIFNEURON_0.MEM a_191800_324119# 0.00679f
C3855 a_82826_124842# a_85155_125209# 0.01109f
C3856 a_85875_125209# a_87468_125419# 0
C3857 w_188806_323975# a_192138_324119# 0.24201f
C3858 a_82872_125209# a_82974_125209# 0.3522f
C3859 a_85211_124842# a_87673_125210# 0
C3860 a_78824_126541# a_79025_124824# 0
C3861 a_77995_360458# user_project_wrapper_0.IOVDD4 0
C3862 a_192354_326892# a_191234_326377# 0
C3863 a_192738_326892# a_190824_326377# 0
C3864 a_210621_326377# a_211153_327798# 0
C3865 a_190722_326377# a_189184_326377# 0.00427f
C3866 a_190926_326377# a_189756_326377# 0
C3867 a_87105_130835# a_86507_129255# 0.06802f
C3868 a_85875_125209# user_project_wrapper_0.VDD1 0.21272f
C3869 TOP_ROILIFNEURON_0.MEM a_192738_329332# 0.00497f
C3870 user_project_wrapper_0.IOVDD2 a_299425_35542# 0
C3871 QDLL_TOP_0.VDD a_271172_100118# 2.53762f
C3872 user_project_wrapper_0.sg13g2_IOPadAnalog_8.padres a_82846_241091# 0.15774f
C3873 w_188704_327938# a_190722_328605# 0.01266f
C3874 a_189921_331163# a_189756_329719# 0
C3875 a_188455_330987# a_188455_330851# 0.07033f
C3876 a_121435_35542# a_121435_35456# 0.03774f
C3877 a_41636_266461# a_41476_258244# 0.01916f
C3878 a_192354_325785# a_192354_325570# 0.01056f
C3879 a_189921_331163# user_project_wrapper_0.sg13g2_IOPadAnalog_17.padres 0.002f
C3880 user_project_wrapper_0.VDD2 a_116815_35456# 0.00145f
C3881 a_188455_331163# user_project_wrapper_0.sg13g2_IOPadAnalog_19.padres 0
C3882 user_project_wrapper_0.VDD1 a_93400_129062# 0
C3883 w_207883_330166# a_208071_330851# 0.06228f
C3884 IOVDD3 a_355624_278644# 58.9173f
C3885 a_189756_325263# a_190686_324119# 0.00202f
C3886 user_project_wrapper_0.sg13g2_IOPadAnalog_6.padres a_186431_99272# 0.27397f
C3887 a_76675_364458# a_77005_360458# 0.03774f
C3888 a_76345_360372# a_77005_360372# 0.02109f
C3889 user_project_wrapper_0.IOVDD2 a_184861_41636# 1.92793f
C3890 a_82846_240684# a_82645_242401# 0
C3891 TOP_ROILIFNEURON_0.MEM a_191970_326677# 0.00105f
C3892 a_82118_240839# user_project_wrapper_0.analog_io[4] 0.02268f
C3893 a_355784_184861# IOVDD3 1.92793f
C3894 a_211153_326677# a_208367_326377# 0
C3895 a_191234_325263# a_191234_326377# 0.02058f
C3896 a_190926_325785# a_189184_326377# 0
C3897 a_190722_325785# a_190501_326377# 0.00101f
C3898 w_188704_326203# a_191970_326465# 0.0018f
C3899 a_200137_343292# user_project_wrapper_0.ui_PAD[31] 0.04422f
C3900 a_192354_329120# a_192354_328905# 0.01056f
C3901 a_190304_108495# a_190862_108496# 0.06619f
C3902 w_207989_323975# a_208579_324119# 0.09567f
C3903 a_304045_360458# a_304375_360458# 0.37213f
C3904 w_207887_326203# a_209230_324119# 0.00152f
C3905 user_project_wrapper_0.sg13g2_IOPadAnalog_9.padres a_79038_136536# 0
C3906 a_189184_329719# a_189286_329327# 0.0352f
C3907 a_208071_330987# a_208367_329719# 0
C3908 a_209104_330987# a_208939_329719# 0
C3909 a_190297_327491# a_191234_327491# 0.02229f
C3910 a_209869_324119# a_209905_325785# 0
C3911 a_189756_329719# a_189858_329327# 0.03526f
C3912 a_189756_325263# a_190926_329327# 0
C3913 a_189184_327491# a_189858_328013# 0.01591f
C3914 user_project_wrapper_0.sg13g2_IOPadAnalog_21.padres a_209104_330987# 0
C3915 a_190824_329719# a_192738_330241# 0
C3916 a_190297_329719# a_188920_324155# 0
C3917 a_192826_90558# user_project_wrapper_0.analog_io[13] 0.01131f
C3918 user_project_wrapper_0.VDD1 a_85287_241383# 0.32334f
C3919 a_300085_39542# a_300085_35542# 0.03774f
C3920 user_project_wrapper_0.sg13g2_IOPadAnalog_19.padres a_190297_328605# 0.00804f
C3921 user_project_wrapper_0.analog_io[32] a_206201_328627# 0.00547f
C3922 a_211921_328013# a_211921_327798# 0.01056f
C3923 user_project_wrapper_0.IOVDD2 a_120115_35456# 0.01409f
C3924 user_project_wrapper_0.IOVDD1 user_project_wrapper_0.sg13g2_IOPadOut4mA$1_1.c2p 0.04287f
C3925 TOP_ROILIFNEURON_0.MEM a_191970_325997# 0.00105f
C3926 user_project_wrapper_0.IOVDD1 a_39542_77005# 0.01881f
C3927 a_74365_360372# user_project_wrapper_0.IOVDD4 0.01881f
C3928 a_364458_79975# VDD3 0
C3929 user_project_wrapper_0.VDD2 a_119455_35456# 0.00146f
C3930 a_189184_325263# a_190722_326377# 0
C3931 a_209684_325263# a_210109_325785# 0.00499f
C3932 a_190722_325263# a_190686_324119# 0
C3933 user_project_wrapper_0.sg13g2_IOPadAnalog_6.padres a_186430_98275# 0.12346f
C3934 a_85287_241383# user_project_wrapper_0.sg13g2_IOPadIn$1_1.p2c 0.1251f
C3935 a_39542_78985# a_39542_78325# 0.02109f
C3936 a_35456_78655# a_35542_78655# 0.03774f
C3937 a_192354_327798# a_192354_327586# 0.01085f
C3938 user_project_wrapper_0.sg13g2_IOPadAnalog_14.padres a_82118_238718# 0.00419f
C3939 a_296731_189665# analog_io[20] 0.25639f
C3940 a_208579_324119# a_208855_324776# 0.03742f
C3941 a_189396_324119# a_187364_324106# 0.03412f
C3942 user_project_wrapper_0.VDD1 a_35456_73375# 0.00178f
C3943 a_304995_198817# a_296732_197880# 0.04958f
C3944 a_304196_200821# a_304889_199957# 1.43523f
C3945 a_307232_196607# a_304196_197873# 0.00538f
C3946 a_309516_194555# a_296731_189665# 0.19148f
C3947 TOP_ROILIFNEURON_0.MEM a_192354_328225# 0.00168f
C3948 a_209684_329719# a_211153_329814# 0
C3949 a_217444_41476# a_225661_41636# 0.01916f
C3950 a_210621_329719# a_211153_330241# 0.00381f
C3951 a_210007_329719# a_209905_329719# 0.1023f
C3952 a_209480_329719# a_210109_329719# 0.01814f
C3953 a_209940_324686# a_210307_324119# 0.16084f
C3954 a_209869_324119# a_210645_324119# 0
C3955 a_300085_360372# a_300415_360458# 0.03774f
C3956 a_189672_324776# a_188920_324155# 0.00517f
C3957 a_189756_326377# a_189756_328605# 0
C3958 user_project_wrapper_0.VDD1 a_78220_128592# 0.59469f
C3959 a_188834_326341# a_189286_325785# 0.00124f
C3960 a_189756_325263# a_189858_325785# 0.22412f
C3961 a_189184_325263# a_190926_325785# 0.02698f
C3962 user_project_wrapper_0.IOVDD1 a_35542_301405# 0
C3963 a_186731_90558# a_187294_90558# 0.0653f
C3964 a_188455_331163# a_188455_330987# 0.03126f
C3965 a_208367_329719# a_209684_328605# 0
C3966 a_189184_328605# a_190297_326377# 0
C3967 a_190297_328605# a_189184_326377# 0
C3968 analog_io[26] a_355624_278644# 25.1197f
C3969 a_79038_132196# a_79038_130492# 0.00178f
C3970 user_project_wrapper_0.VDD1 m1_85051_241246# 0.00219f
C3971 user_project_wrapper_0.sg13g2_IOPadIn$1_0.p2c a_83796_128838# 0
C3972 a_210007_325263# a_210307_324119# 0.00706f
C3973 a_85052_125418# a_85211_124842# 0.16538f
C3974 w_188704_326203# a_190455_324119# 0
C3975 w_188806_323975# a_189609_324119# 0.09666f
C3976 a_190389_101343# QDLL_TOP_0.VDD 2.59008f
C3977 a_76675_360458# user_project_wrapper_0.IOVDD4 0
C3978 a_192138_324119# a_192745_324776# 0.00122f
C3979 a_189756_325263# a_190722_328013# 0.00175f
C3980 a_78221_126292# a_78220_128106# 0.01743f
C3981 a_190490_98199# user_project_wrapper_0.analog_io[13] 0
C3982 a_305035_35456# a_305365_35542# 0.03774f
C3983 TOP_ROILIFNEURON_0.MEM a_191234_328605# 0.00568f
C3984 user_project_wrapper_0.IOVDD2 a_116155_35456# 0.01409f
C3985 a_82826_124842# user_project_wrapper_0.VDD1 0.83755f
C3986 a_84288_130212# a_79025_131741# 0.00127f
C3987 QDLL_TOP_0.VDD a_268967_100118# 0.23953f
C3988 user_project_wrapper_0.sg13g2_IOPadAnalog_0.padres IOVDD3 1.36563f
C3989 a_120775_35542# a_120775_35456# 0.03774f
C3990 user_project_wrapper_0.sg13g2_IOPadAnalog_30.padres user_project_wrapper_0.VDD2 1.74533f
C3991 a_210937_330987# a_210137_330987# 0.01566f
C3992 m1_85051_241246# user_project_wrapper_0.sg13g2_IOPadIn$1_1.p2c 0.01734f
C3993 a_211084_330987# a_210051_330987# 0.02622f
C3994 a_210007_325263# a_210417_325263# 0.15379f
C3995 a_192738_325997# a_192738_325785# 0.01085f
C3996 a_355784_144061# IOVDD3 1.92793f
C3997 user_project_wrapper_0.VDD2 a_115495_35456# 0
C3998 w_188700_330166# a_188888_330851# 0.06228f
C3999 user_project_wrapper_0.sg13g2_IOPadOut4mA$1_0.sg13g2_GateLevelUpInv_noptap$1$1_0.ngate a_58798_179249# 0.04338f
C4000 a_79025_125231# a_83796_129203# 0.00538f
C4001 a_82859_241546# a_82645_242401# 0
C4002 a_85989_241748# a_82846_243261# 0
C4003 a_75685_360372# a_76345_360372# 0.02109f
C4004 a_76015_364458# a_76345_360458# 0.03774f
C4005 a_83070_130577# a_83398_130212# 0.19648f
C4006 a_189756_329719# a_190722_329719# 0.00611f
C4007 a_190501_329719# a_189286_329719# 0
C4008 a_35456_73375# a_35542_73705# 0.03774f
C4009 TOP_ROILIFNEURON_0.MEM a_192738_327104# 0.00497f
C4010 a_58798_179951# a_58798_179249# 0.00123f
C4011 user_project_wrapper_0.sg13g2_IOPadAnalog_15.padres user_project_wrapper_0.analog_io[4] 0.43198f
C4012 a_190501_325263# a_189756_326377# 0.00169f
C4013 a_78220_128592# a_79038_130026# 0.17968f
C4014 a_190926_329327# a_190926_328605# 0
C4015 a_192738_329332# a_192738_329120# 0.01085f
C4016 a_189190_108495# a_189748_108496# 0.06619f
C4017 a_303385_360458# a_303715_360458# 0.37213f
C4018 user_project_wrapper_0.sg13g2_IOPadAnalog_9.padres a_78218_138281# 0
C4019 a_190218_102763# a_190319_102855# 0.02609f
C4020 a_189756_325263# a_189184_328605# 0.39659f
C4021 a_189184_325263# a_190297_328605# 0
C4022 a_188834_327918# a_190501_328605# 0
C4023 a_190638_90558# user_project_wrapper_0.analog_io[13] 0.01131f
C4024 a_190297_329719# a_190926_330241# 0.01195f
C4025 a_190824_329719# a_190722_330241# 0.20881f
C4026 a_79025_129571# user_project_wrapper_0.sg13g2_IOPadAnalog_9.padres 0.00688f
C4027 a_208103_324155# a_206547_324106# 0.24725f
C4028 user_project_wrapper_0.IOVDD2 a_118795_35456# 0.01409f
C4029 a_35542_80305# user_project_wrapper_0.IOVDD1 0
C4030 a_360372_73705# a_360458_73705# 0.03774f
C4031 a_364458_74035# a_364458_73375# 0.02109f
C4032 TOP_ROILIFNEURON_0.MEM a_190297_325263# 0
C4033 user_project_wrapper_0.IOVDD1 a_39542_78325# 0.01881f
C4034 a_209684_328605# a_210007_327491# 0
C4035 a_364458_81295# VDD3 0.00177f
C4036 w_188704_326203# a_189286_325785# 0.01313f
C4037 user_project_wrapper_0.VDD2 a_118135_35456# 0.00157f
C4038 a_211153_329814# a_210621_328605# 0
C4039 a_208367_328605# a_208469_329327# 0.10232f
C4040 a_208939_328605# a_209041_329327# 0.10234f
C4041 a_209684_328605# a_210417_328605# 0.0065f
C4042 TOP_ROILIFNEURON_0.MEM a_209684_328605# 0
C4043 a_192738_328013# a_192738_327798# 0.01056f
C4044 a_191970_326677# a_191970_326465# 0.01085f
C4045 user_project_wrapper_0.sg13g2_IOPadIn$1_0.p2c user_project_wrapper_0.sg13g2_IOPadAnalog_8.padres 0.06178f
C4046 a_176644_41476# a_184861_41636# 0.01916f
C4047 a_301423_202742# a_301509_202742# 0.04805f
C4048 a_309516_194555# a_307232_196607# 0.90622f
C4049 a_210007_329719# a_211537_330241# 0
C4050 a_217444_29676# user_project_wrapper_0.IOVDD2 0.16358f
C4051 a_304090_197941# a_304889_199957# 0.06684f
C4052 a_301940_196388# a_304196_197873# 0.06992f
C4053 user_project_wrapper_0.VDD1 a_35456_74695# 0
C4054 a_296732_200582# a_304995_198817# 0.04909f
C4055 a_209684_329719# a_208103_324155# 0
C4056 a_301186_192011# a_301423_196360# 0.05315f
C4057 a_296626_197740# a_296732_197880# 6.63552f
C4058 user_project_wrapper_0.IOVDD2 user_project_wrapper_0.sg13g2_IOPadVdd_1.sg13g2_RCClampResistor_0.p2 68.8756f
C4059 a_84598_130577# a_87434_129061# 0.00169f
C4060 a_208792_324119# a_209230_324119# 0.01235f
C4061 a_190297_326377# a_188920_324155# 0
C4062 w_188704_327938# a_191438_327491# 0.08621f
C4063 user_project_wrapper_0.sg13g2_IOPadVdd_1.sg13g2_RCClampResistor_0.p2 user_project_wrapper_0.sg13g2_IOPadVdd_1.sg13g2_RCClampInverter_noptap_0.out 22.6715f
C4064 a_79038_125686# user_project_wrapper_0.sg13g2_IOPadAnalog_8.padres 0.01719f
C4065 a_263818_343292# user_project_wrapper_0.analog_io[34] 0.05479f
C4066 user_project_wrapper_0.IOVDD1 a_35542_302725# 0
C4067 a_83490_125209# user_project_wrapper_0.sg13g2_IOPadIn$1_0.p2c 0.10417f
C4068 a_191754_330987# a_191901_330987# 0.17314f
C4069 a_208939_329719# a_209905_329719# 0.00611f
C4070 a_161818_343292# user_project_wrapper_0.analog_io[29] 0.05479f
C4071 a_78220_130691# a_79025_131741# 0
C4072 a_191970_325997# a_191970_326465# 0.00322f
C4073 a_78824_133051# a_79025_131334# 0
C4074 a_79025_133504# a_78824_130881# 0
C4075 a_81295_364458# a_81295_360458# 0.03774f
C4076 a_82826_124842# a_83050_125173# 0.04241f
C4077 a_188888_330987# a_188920_324155# 0
C4078 a_82667_125418# a_82872_125209# 0.03571f
C4079 a_161818_56308# user_project_wrapper_0.VDD2 -0
C4080 a_188184_101343# QDLL_TOP_0.VDD 0.2649f
C4081 a_190757_324686# a_191124_324119# 0.16084f
C4082 a_190686_324119# a_191462_324119# 0
C4083 user_project_wrapper_0.sg13g2_IOPadAnalog_29.padres a_315347_192734# 0
C4084 user_project_wrapper_0.VDD1 a_82846_243261# 2.27233f
C4085 a_304375_35456# a_304705_35542# 0.03774f
C4086 a_78824_126541# user_project_wrapper_0.VDD1 2.73558f
C4087 user_project_wrapper_0.IOVDD2 a_114835_35456# 0.01409f
C4088 a_83796_129203# a_79025_133911# 0.00204f
C4089 a_120115_35542# a_120115_35456# 0.03774f
C4090 a_90579_129060# a_87105_130835# 0
C4091 w_188700_330166# a_190824_328605# 0
C4092 w_188704_327938# a_190297_328605# 0.08797f
C4093 a_209018_330987# a_207985_330987# 0.02597f
C4094 a_208871_330987# a_208071_330987# 0.01602f
C4095 user_project_wrapper_0.analog_io[28] user_project_wrapper_0.IOVDD4 0.10967p
C4096 a_190824_325263# a_191970_325570# 0
C4097 user_project_wrapper_0.analog_io[13] a_191975_108496# 0.0113f
C4098 a_190297_325263# a_192354_325570# 0
C4099 a_309917_199879# VDD3 10.8804f
C4100 user_project_wrapper_0.VDD2 a_114175_35456# 0.00178f
C4101 a_189286_328605# a_189756_328605# 0
C4102 a_56308_121018# user_project_wrapper_0.analog_io[0] 0.05479f
C4103 user_project_wrapper_0.sg13g2_IOPadIn$1_1.p2c a_82846_243261# 0.12479f
C4104 a_189756_325263# a_188920_324155# 0.25375f
C4105 a_189184_329719# a_191970_330241# 0
C4106 a_270178_100118# a_270512_100118# 0.49051f
C4107 a_35456_74035# a_35542_74365# 0.03774f
C4108 a_360458_300745# IOVDD3 0
C4109 a_188074_108495# a_188632_108496# 0.06619f
C4110 a_191438_328605# a_191970_329332# 0.00193f
C4111 a_189184_328605# a_190926_328605# 0.02636f
C4112 a_190501_328605# a_190722_328605# 0.05425f
C4113 a_191234_328605# a_192738_329120# 0
C4114 a_190824_328605# a_189286_328605# 0
C4115 a_302725_360458# a_303055_360458# 0.37213f
C4116 a_84332_125209# a_86507_129255# 0.06525f
C4117 a_116815_35542# a_116815_35456# 0.03774f
C4118 a_188408_90558# user_project_wrapper_0.analog_io[13] 0.02875f
C4119 a_208939_328605# a_209041_327491# 0.02134f
C4120 a_208367_328605# a_208469_327491# 0.02124f
C4121 user_project_wrapper_0.IOVDD2 a_117475_35456# 0.01409f
C4122 a_210109_329719# a_209480_328605# 0
C4123 a_35456_305695# a_35542_306025# 0.03774f
C4124 a_190722_325263# a_188920_324155# 0
C4125 user_project_wrapper_0.sg13g2_IOPadIn$1_2.p2c a_206547_324106# 0.04773f
C4126 a_192354_328225# a_192354_328013# 0.01085f
C4127 a_191438_327491# a_191970_327798# 0.00324f
C4128 a_360458_300745# a_364458_300415# 0.03774f
C4129 a_192354_326892# a_192354_326677# 0.01056f
C4130 a_190287_102497# QDLL_TOP_0.CPIN 0
C4131 a_135844_41476# a_144061_41636# 0.01916f
C4132 a_296626_197740# a_296732_200582# 6.65596f
C4133 a_209684_329719# a_210109_330241# 0.00495f
C4134 user_project_wrapper_0.VDD1 a_35456_76015# 0.00145f
C4135 a_213376_328627# a_213870_324142# 0.09942f
C4136 a_210007_329719# a_209041_330241# 0
C4137 a_296625_208423# a_301423_202742# 0.20064f
C4138 a_189672_324776# a_194279_327536# 0.02043f
C4139 user_project_wrapper_0.sg13g2_IOPadAnalog_19.padres a_190824_327491# 0
C4140 a_91911_127530# a_92512_127531# 0.024f
C4141 user_project_wrapper_0.sg13g2_IOPadIOVdd_2.sg13g2_Clamp_N43N43D4R_0.gate user_project_wrapper_0.IOVDD4 0.15002p
C4142 a_189835_330987# a_189921_331163# 0.01534f
C4143 a_208367_329719# a_211153_330241# 0
C4144 a_208939_325263# a_208103_324155# 0.25375f
C4145 a_35542_298435# a_39542_298105# 0.03774f
C4146 a_210417_325263# a_210417_326377# 0.02058f
C4147 a_78824_133051# a_79038_132662# 0.05038f
C4148 a_211153_326677# a_210621_326377# 0.00381f
C4149 user_project_wrapper_0.sg13g2_IOPadOut4mA$1_1.c2p a_82846_241091# 0
C4150 TOP_ROILIFNEURON_0.MEM a_192738_330453# 0.00436f
C4151 a_79025_129164# a_78824_130881# 0
C4152 a_80635_364458# a_80635_360458# 0.03774f
C4153 a_79038_126152# a_78221_125094# 0
C4154 a_191438_328605# a_191438_327491# 0.04294f
C4155 a_190319_102855# QDLL_TOP_0.VDD 0.23221f
C4156 a_92512_129426# a_93204_129062# 0.06518f
C4157 a_189609_324119# a_190047_324119# 0.01235f
C4158 a_303715_35456# a_304045_35542# 0.03774f
C4159 a_311189_185546# a_314793_197200# 0.07741f
C4160 a_206547_324106# a_208367_326377# 0.00328f
C4161 a_83389_129203# a_83796_129203# 0.07518f
C4162 a_82658_129203# a_83398_130212# 0
C4163 a_119455_35542# a_119455_35456# 0.03774f
C4164 user_project_wrapper_0.sg13g2_IOPadAnalog_6.padres a_269355_100412# 0.01646f
C4165 a_189016_101343# QDLL_TOP_0.VOUT 0
C4166 user_project_wrapper_0.analog_io[13] a_189748_108496# 0.0113f
C4167 a_304196_200821# VDD3 0.12335f
C4168 user_project_wrapper_0.sg13g2_IOPadAnalog_14.padres user_project_wrapper_0.sg13g2_IOPadAnalog_8.padres 0.0071f
C4169 a_35542_303715# a_39542_303385# 0.03774f
C4170 a_223018_343292# user_project_wrapper_0.sg13g2_IOPadAnalog_20.padres 0.0512f
C4171 a_35456_297775# a_35456_298435# 0.02109f
C4172 a_189756_329719# a_189858_330241# 0.21901f
C4173 a_189184_329719# a_189286_330241# 0.22803f
C4174 a_190824_326377# a_189184_327491# 0
C4175 a_191234_326377# a_189756_327491# 0
C4176 a_190297_326377# a_190501_327491# 0
C4177 a_190501_326377# a_190297_327491# 0
C4178 user_project_wrapper_0.sg13g2_IOPadAnalog_17.padres a_189858_330241# 0
C4179 a_269543_100118# a_269355_100412# 0.45362f
C4180 a_35456_74695# a_35542_75025# 0.03774f
C4181 a_299755_364458# user_project_wrapper_0.IOVDD4 0.01452f
C4182 a_360458_302065# IOVDD3 0
C4183 a_190501_328605# a_191970_329332# 0
C4184 a_190297_328605# a_191438_328605# 0.00342f
C4185 a_190824_328605# a_190926_329327# 0.10235f
C4186 user_project_wrapper_0.IOVDD1 user_project_wrapper_0.sg13g2_IOPadOut4mA$1_0.c2p 0.04287f
C4187 a_211537_328693# a_211537_328225# 0.00322f
C4188 a_186960_108495# a_187518_108496# 0.06619f
C4189 a_302065_360458# a_302395_360458# 0.37213f
C4190 a_88274_127896# a_86507_129255# 0.00867f
C4191 a_343292_284218# analog_io[26] 0.05479f
C4192 a_188888_330851# a_189184_328605# 0
C4193 a_83164_127455# a_79025_133911# 0
C4194 a_116155_35542# a_116155_35456# 0.03774f
C4195 a_86507_127725# a_86594_127531# 0.00603f
C4196 a_92512_129426# a_93208_127531# 0
C4197 a_93461_128591# a_92512_127896# 0.0012f
C4198 a_35456_303715# a_35542_304045# 0.03774f
C4199 user_project_wrapper_0.sg13g2_IOPadOut4mA$1_1.sg13g2_GateLevelUpInv_noptap$1$1_0.pgate a_57810_282219# 0.24368f
C4200 IOVDD3 a_355624_258244# 58.9173f
C4201 a_305695_364458# a_305695_360458# 0.03774f
C4202 a_208103_324155# a_208367_327491# 0.14371f
C4203 user_project_wrapper_0.sg13g2_IOPadVdd_3.sg13g2_RCClampInverter_noptap_0.out user_project_wrapper_0.sg13g2_IOPadVdd_3.sg13g2_RCClampResistor_0.p2 22.6705f
C4204 a_79025_125231# a_82527_127455# 0.00653f
C4205 a_296731_208493# a_296731_189665# 0.03842f
C4206 a_190501_325263# a_190686_324119# 0.0054f
C4207 a_190297_325263# a_190455_324119# 0.00107f
C4208 TOP_ROILIFNEURON_0.MEM a_211153_330241# 0.00105f
C4209 user_project_wrapper_0.VDD2 user_project_wrapper_0.analog_io[16] 19.8007f
C4210 user_project_wrapper_0.sg13g2_IOPadAnalog_21.padres user_project_wrapper_0.analog_io[33] 0.33124f
C4211 user_project_wrapper_0.analog_io[7] a_56308_263818# 0.05479f
C4212 a_360458_301405# a_364458_301075# 0.03774f
C4213 a_192738_327104# a_192738_326892# 0.01085f
C4214 a_301186_192011# a_296625_208423# 0.20883f
C4215 a_189756_329719# a_189756_327491# 0
C4216 a_188834_326341# a_189184_327491# 0.03066f
C4217 a_210109_326377# a_210007_326377# 0.22366f
C4218 a_189756_325263# a_190501_327491# 0.01989f
C4219 a_188834_327918# a_190297_327491# 0
C4220 user_project_wrapper_0.VDD1 a_35456_77335# 0.00157f
C4221 a_209684_329719# a_210007_329719# 0.34427f
C4222 user_project_wrapper_0.VDD1 a_57810_282219# 0.00549f
C4223 user_project_wrapper_0.sg13g2_IOPadAnalog_17.padres a_189756_327491# 0.00899f
C4224 user_project_wrapper_0.IOVDD2 a_306025_35542# 0
C4225 a_91911_127530# a_93208_127531# 0
C4226 a_208939_329719# a_209041_330241# 0.21901f
C4227 a_208367_329719# a_208469_330241# 0.22803f
C4228 a_164461_369456# a_156244_369296# 0.01778f
C4229 a_35542_299095# a_39542_298765# 0.03774f
C4230 user_project_wrapper_0.analog_io[5] a_56308_223018# 0.05479f
C4231 a_360458_75685# IOVDD3 0
C4232 a_82846_243261# a_82645_242401# 0.04819f
C4233 a_79025_135674# a_78824_133051# 0
C4234 a_79038_134832# a_79038_134366# 0.04646f
C4235 user_project_wrapper_0.sg13g2_IOPadAnalog_17.padres user_project_wrapper_0.IOVDD4 1.36563f
C4236 a_78824_135221# a_79025_133504# 0
C4237 a_79975_364458# a_79975_360458# 0.03774f
C4238 a_79025_136081# a_79038_132662# 0
C4239 user_project_wrapper_0.sg13g2_IOPadOut4mA$1_1.sg13g2_GateLevelUpInv_noptap$1$1_0.ngate a_57810_282219# 0.01958f
C4240 a_83492_127455# a_79025_133911# 0
C4241 a_87434_129426# a_85127_131750# 0.03835f
C4242 a_78824_128711# a_79025_131741# 0.00139f
C4243 a_78824_126541# a_79025_126994# 1.02588f
C4244 a_83492_127455# a_91911_129060# 0
C4245 a_89953_129061# a_92512_129426# 0.12679f
C4246 a_90579_129060# a_91090_129425# 0.06159f
C4247 user_project_wrapper_0.sg13g2_IOPadIOVdd_1.sg13g2_RCClampResistor_0.p2 a_39542_305365# 0.02109f
C4248 w_188700_330166# a_192354_330453# 0.0018f
C4249 a_189395_101343# a_189729_101343# 0.49051f
C4250 user_project_wrapper_0.sg13g2_IOPadIn$1_2.p2c a_208939_325263# 0.00258f
C4251 a_303055_35456# a_303385_35542# 0.03774f
C4252 a_82433_130212# a_79025_138251# 0.07879f
C4253 a_301575_187719# a_296731_189665# 0.09615f
C4254 a_82348_128838# a_79025_127401# 0.00866f
C4255 a_118795_35542# a_118795_35456# 0.03774f
C4256 a_84598_130212# a_84288_130212# 0.00441f
C4257 a_83492_130212# a_83925_130212# 0
C4258 a_79025_129571# a_83796_129203# 0
C4259 a_369296_135844# analog_io[19] 9.69836f
C4260 a_188760_99480# a_189016_99480# 0.29685f
C4261 user_project_wrapper_0.analog_io[13] a_187518_108496# 0.0352f
C4262 a_304090_197941# VDD3 0.2561f
C4263 a_190824_325263# a_191234_325263# 0.15379f
C4264 IOVDD3 a_360458_298765# 0
C4265 IOVDD3 analog_io[23] 0.2207p
C4266 a_189184_328605# a_189756_328605# 0.57196f
C4267 user_project_wrapper_0.sg13g2_IOPadIOVdd_0.sg13g2_RCClampResistor_0.p2 a_305365_39542# 0.02109f
C4268 a_189756_329719# a_191234_329719# 0
C4269 a_208071_331343# a_208103_324155# 0
C4270 a_190501_329719# a_190297_329719# 0.77558f
C4271 a_189184_329719# a_190824_329719# 0.38724f
C4272 a_188888_330851# a_188920_324155# 0
C4273 a_87468_125419# a_86507_129255# 0.12195f
C4274 a_298435_364458# user_project_wrapper_0.IOVDD4 0.01567f
C4275 a_35456_75355# a_35542_75685# 0.03774f
C4276 a_360458_303385# IOVDD3 0
C4277 user_project_wrapper_0.IOVDD1 a_57810_281517# 0.8844f
C4278 a_189184_328605# a_190824_328605# 0.38387f
C4279 a_190501_328605# a_190297_328605# 0.80083f
C4280 a_301405_360458# a_301735_360458# 0.37213f
C4281 a_79038_127856# a_79025_131741# 0.0025f
C4282 a_82527_127455# a_79025_133911# 0.00141f
C4283 a_115495_35542# a_115495_35456# 0.03774f
C4284 user_project_wrapper_0.VDD1 a_86507_129255# 1.48889f
C4285 a_87434_129426# a_89114_127531# 0
C4286 a_91090_129425# a_89953_127531# 0.00166f
C4287 a_86507_127725# a_90579_127530# 0
C4288 a_89953_129061# a_91911_127530# 0.01534f
C4289 a_35456_304375# a_35542_304705# 0.03774f
C4290 user_project_wrapper_0.sg13g2_IOPadVdd_2.sg13g2_RCClampResistor_0.p2 a_39542_80965# 0.02109f
C4291 a_82770_125209# a_79025_125231# 0.00211f
C4292 user_project_wrapper_0.sg13g2_IOPadAnalog_9.padres a_56308_141418# 0.0512f
C4293 TOP_ROILIFNEURON_0.MEM a_211537_328693# 0.00168f
C4294 a_141418_56308# user_project_wrapper_0.VDD2 -0
C4295 w_188704_326203# a_189184_327491# 0.06305f
C4296 w_188704_327938# a_190824_327491# 0.11519f
C4297 user_project_wrapper_0.analog_io[14] a_190287_98223# 0
C4298 a_192309_92557# a_192826_90558# 0.04299f
C4299 a_161818_56308# user_project_wrapper_0.sg13g2_IOPadAnalog_6.padres 0.0512f
C4300 a_83398_130212# a_83796_128838# 0
C4301 user_project_wrapper_0.sg13g2_IOPadAnalog_22.padres a_209480_326377# 0
C4302 a_87105_130835# a_93298_129062# 0.005f
C4303 a_208939_325263# a_208367_326377# 0.36532f
C4304 a_208017_326341# a_208939_326377# 0.68786f
C4305 a_208017_327918# a_209684_326377# 0
C4306 a_208367_325263# a_209480_326377# 0.00213f
C4307 a_296731_208493# a_307232_196607# 1.51299f
C4308 user_project_wrapper_0.sg13g2_IOPadAnalog_21.padres a_206547_324106# 0.03117f
C4309 user_project_wrapper_0.VDD1 a_84288_130212# 0.3232f
C4310 user_project_wrapper_0.sg13g2_IOPadIn$1_1.p2c a_86507_129255# 0.11232f
C4311 a_78824_124371# a_79025_124824# 1.02588f
C4312 a_360458_302065# a_364458_301735# 0.03774f
C4313 w_207883_330166# a_211153_330453# 0.0018f
C4314 a_190926_328605# a_190501_327491# 0
C4315 a_208939_325263# a_210109_328605# 0.00134f
C4316 a_208939_329719# a_209041_328605# 0.02684f
C4317 a_208367_329719# a_208469_328605# 0.02933f
C4318 a_211153_326892# a_209684_326377# 0
C4319 user_project_wrapper_0.VDD1 a_35456_78655# 0.00146f
C4320 user_project_wrapper_0.IOVDD2 a_304705_39542# 0.02056f
C4321 a_360458_75025# a_364458_74695# 0.03774f
C4322 a_299425_360372# a_299755_360458# 0.03774f
C4323 a_89953_127531# a_84332_125209# 0.03906f
C4324 a_86594_127896# a_86594_127531# 0.09189f
C4325 user_project_wrapper_0.sg13g2_IOPadIn$1_2.p2c w_188704_326203# 0
C4326 a_208939_325263# a_210007_329719# 0.00161f
C4327 a_208017_326341# a_209480_329719# 0.00141f
C4328 user_project_wrapper_0.IOVDD4 a_304705_360372# 0.02056f
C4329 a_35542_299755# a_39542_299425# 0.03774f
C4330 a_208939_329719# a_209684_329719# 0.20556f
C4331 user_project_wrapper_0.sg13g2_IOPadAnalog_21.padres a_209684_329719# 0
C4332 a_360458_77005# IOVDD3 0
C4333 user_project_wrapper_0.sg13g2_IOPadAnalog_5.padres a_243418_56308# 0.0512f
C4334 a_79025_136081# a_79025_135674# 0
C4335 a_355624_258244# a_355784_266461# 0.01916f
C4336 a_210137_330851# a_210621_329719# 0.00268f
C4337 a_79315_364458# a_79315_360458# 0.03774f
C4338 TOP_ROILIFNEURON_0.MEM a_190297_329719# 0
C4339 a_188888_331163# a_188920_324155# 0
C4340 a_83070_130212# a_79025_131741# 0
C4341 analog_io[19] IOVDD3 0.10967p
C4342 a_78220_128592# a_79038_130492# 0
C4343 a_87105_130470# a_86594_130470# 0.00441f
C4344 a_83389_129203# a_83492_127455# 0
C4345 w_188704_326203# a_194193_328627# 0
C4346 a_188760_101343# a_188572_101637# 0.45362f
C4347 a_188988_324119# a_188920_324155# 0.44722f
C4348 a_186430_102197# user_project_wrapper_0.sg13g2_IOPadAnalog_6.padres 0.12335f
C4349 a_188920_324155# a_189756_328605# 1.1099f
C4350 a_192354_330026# a_192354_329814# 0.01085f
C4351 a_302395_35456# a_302725_35542# 0.03774f
C4352 a_208103_324155# a_208579_324119# 0.00588f
C4353 a_190297_326377# a_189858_327099# 0
C4354 a_190501_326377# a_190722_327099# 0.01614f
C4355 a_187364_324106# a_189672_324776# 0.52327f
C4356 a_210109_327491# a_209684_326377# 0
C4357 user_project_wrapper_0.sg13g2_IOPadAnalog_8.padres a_79025_131334# 0.01276f
C4358 a_83070_130212# a_82746_130212# 0.00441f
C4359 a_118135_35542# a_118135_35456# 0.03774f
C4360 a_188296_99070# a_188760_99480# 0.00107f
C4361 user_project_wrapper_0.sg13g2_IOPadIn$1_0.sg13g2_LevelDown_noptap$1_0.sg13g2_SecondaryProtection$1$1_0.core a_56308_159337# 0.0512f
C4362 IOVDD3 a_360458_300085# 0
C4363 a_191970_329332# a_191438_329719# 0
C4364 a_190824_328605# a_188920_324155# 0
C4365 a_360458_75025# VDD3 0
C4366 a_208939_326377# a_209684_327491# 0
C4367 a_208367_326377# a_208367_327491# 0.25139f
C4368 a_209684_326377# a_208939_327491# 0.00209f
C4369 user_project_wrapper_0.sg13g2_IOPadAnalog_1.padres IOVDD3 1.36563f
C4370 a_82118_239118# a_82859_239842# 0.16888f
C4371 a_82645_240231# a_82859_239376# 0
C4372 a_35456_76015# a_35542_76345# 0.03774f
C4373 a_258244_369296# user_project_wrapper_0.analog_io[34] 9.69836f
C4374 user_project_wrapper_0.analog_io[14] user_project_wrapper_0.IOVDD2 0.10967p
C4375 m1_83011_126179# a_79025_125231# 0
C4376 TOP_ROILIFNEURON_0.MEM a_189672_324776# 0.38353f
C4377 a_360458_304705# IOVDD3 0
C4378 a_190297_327491# a_192354_327798# 0
C4379 a_190824_327491# a_191970_327798# 0
C4380 a_209905_328605# a_209684_327491# 0.00101f
C4381 a_210109_328605# a_208367_327491# 0
C4382 a_360458_298105# a_364458_297775# 0.03774f
C4383 m6_6440_9800# m7_6440_9800# 0.20055p
C4384 a_189756_327491# a_189858_327491# 0.11127f
C4385 a_189184_327491# a_189286_327491# 0.11107f
C4386 a_210621_328605# a_211153_328225# 0
C4387 a_300745_360458# a_301075_360458# 0.37213f
C4388 w_207887_326203# a_208939_326377# 0.2909f
C4389 a_83164_127820# a_79025_136081# 0
C4390 a_35456_81295# user_project_wrapper_0.IOVDD1 0.01409f
C4391 a_86594_129061# a_86507_129255# 0.00603f
C4392 a_210007_328605# a_209041_328605# 0
C4393 a_114835_35542# a_114835_35456# 0.03774f
C4394 user_project_wrapper_0.VDD1 a_78220_130691# 0.59508f
C4395 a_210109_325785# a_208367_326377# 0
C4396 a_209905_325785# a_209684_326377# 0.00101f
C4397 a_83492_127455# a_87434_127896# 0.03836f
C4398 a_86507_127725# a_86594_127896# 0.38626f
C4399 a_82658_129203# a_83164_127820# 0.00281f
C4400 user_project_wrapper_0.analog_io[15] user_project_wrapper_0.IOVDD2 0.10967p
C4401 a_83389_129203# a_82527_127455# 0
C4402 a_35456_305035# a_35542_305365# 0.03774f
C4403 a_190638_90472# a_191751_90472# 0.00947f
C4404 a_191196_92557# a_191751_90558# 0.04298f
C4405 a_186431_100948# user_project_wrapper_0.analog_io[13] 0.03466f
C4406 a_209684_329719# a_210007_328605# 0
C4407 a_209480_329719# a_209480_328605# 0.03801f
C4408 user_project_wrapper_0.VDD1 a_78220_130291# 0.01163f
C4409 a_190389_99046# QDLL_TOP_0.CPIN 0.02659f
C4410 a_296731_208493# a_301940_196388# 0.50336f
C4411 a_304889_198885# a_296625_208423# 0.81964f
C4412 a_190501_325263# a_188920_324155# 0.00993f
C4413 TOP_ROILIFNEURON_0.MEM a_211153_325358# 0.00105f
C4414 user_project_wrapper_0.IOVDD1 user_project_wrapper_0.sg13g2_IOPadAnalog_13.padres 1.36563f
C4415 user_project_wrapper_0.sg13g2_IOPadAnalog_19.padres a_189184_326377# 0.05512f
C4416 w_207989_323975# a_211153_325358# 0
C4417 a_360458_302725# a_364458_302395# 0.03774f
C4418 w_207883_330166# a_213376_328627# 0
C4419 a_208939_329719# a_210621_328605# 0
C4420 a_209905_327099# a_208367_326377# 0.01977f
C4421 a_41636_246061# a_41476_237844# 0.01916f
C4422 a_208469_327099# a_209480_326377# 0
C4423 a_209041_327099# a_209684_326377# 0
C4424 a_82974_125209# a_84332_125209# 0
C4425 user_project_wrapper_0.IOVDD2 a_303385_39542# 0.02079f
C4426 a_189921_330987# a_189184_329719# 0
C4427 a_156244_355624# user_project_wrapper_0.analog_io[29] 25.1197f
C4428 a_360458_75685# a_364458_75355# 0.03774f
C4429 a_298765_360372# a_299095_360458# 0.03774f
C4430 a_88274_127896# a_89953_127531# 0
C4431 a_190319_97955# a_190490_98199# 0.37141f
C4432 a_188455_330987# user_project_wrapper_0.sg13g2_IOPadAnalog_19.padres 0
C4433 a_188760_99480# QDLL_TOP_0.VDD 0.29239f
C4434 a_35542_300415# a_39542_300085# 0.03774f
C4435 user_project_wrapper_0.IOVDD4 a_303385_360372# 0.02079f
C4436 a_360458_78325# IOVDD3 0
C4437 user_project_wrapper_0.sg13g2_IOPadIn$1_2.p2c a_191800_324119# 0.0171f
C4438 a_78219_136982# a_78219_135283# 0.01696f
C4439 a_79025_137844# a_79038_136536# 0.71261f
C4440 a_78824_137391# a_79025_136081# 0
C4441 a_210137_330851# a_210417_329719# 0.00903f
C4442 a_208071_330987# a_208103_324155# 0
C4443 a_78655_364458# a_78655_360458# 0.03774f
C4444 a_57810_180219# user_project_wrapper_0.IOVDD1 0.87642f
C4445 a_192354_325570# a_189672_324776# 0
C4446 a_210007_325263# a_210007_326377# 0.02415f
C4447 a_84598_130577# a_79025_131741# 0.00111f
C4448 a_208017_327918# a_208367_329719# 0.40028f
C4449 a_208939_325263# a_208939_329719# 0.26653f
C4450 user_project_wrapper_0.sg13g2_IOPadAnalog_0.padres analog_io[18] 0.33115f
C4451 a_211153_325358# a_208855_324776# 0.00129f
C4452 user_project_wrapper_0.sg13g2_IOPadAnalog_21.padres a_208939_325263# 4.42403f
C4453 a_301735_35456# a_302065_35542# 0.03774f
C4454 a_360372_73705# IOVDD3 0.01881f
C4455 a_189756_325263# a_190501_329719# 0.01748f
C4456 a_188834_326341# a_189184_329719# 0.01178f
C4457 a_189756_326377# a_190501_326377# 0.2047f
C4458 user_project_wrapper_0.sg13g2_IOPadAnalog_8.padres a_79038_132662# 0.07195f
C4459 user_project_wrapper_0.sg13g2_IOPadAnalog_17.padres a_189756_329719# 0.0036f
C4460 a_117475_35542# a_117475_35456# 0.03774f
C4461 user_project_wrapper_0.IOVDD2 a_299095_35456# 0.01447f
C4462 user_project_wrapper_0.sg13g2_IOPadAnalog_19.padres a_189184_325263# 0.07754f
C4463 user_project_wrapper_0.sg13g2_IOPadAnalog_6.padres user_project_wrapper_0.analog_io[16] 0.33115f
C4464 user_project_wrapper_0.IOVDD1 a_35542_73375# 0
C4465 user_project_wrapper_0.sg13g2_IOPadIn$1_0.p2c a_84707_131750# 0
C4466 a_208367_325263# a_209905_326377# 0
C4467 user_project_wrapper_0.IOVDD4 a_81295_364458# 0.01409f
C4468 a_191438_326377# a_191970_327586# 0
C4469 a_190490_98199# QDLL_TOP_0.VDD 0.22591f
C4470 a_190954_330851# a_191234_329719# 0.00903f
C4471 a_210137_331343# a_209684_329719# 0
C4472 a_35456_76675# a_35542_77005# 0.03774f
C4473 a_82667_125418# a_79025_131741# 0
C4474 a_296731_208493# user_project_wrapper_0.sg13g2_IOPadAnalog_26.padres 0.05941f
C4475 a_82846_241091# a_82859_239376# 0
C4476 user_project_wrapper_0.sg13g2_IOPadIn$1_2.p2c a_208579_324119# 0.02625f
C4477 a_209684_327491# a_210621_327491# 0.00396f
C4478 a_209480_327491# a_210109_328013# 0.01192f
C4479 a_210007_327491# a_209905_328013# 0.20881f
C4480 TOP_ROILIFNEURON_0.MEM a_190297_326377# 0
C4481 a_87627_124843# a_83492_127455# 0
C4482 a_85875_125209# a_86507_127725# 0.00309f
C4483 a_360458_306025# IOVDD3 0
C4484 a_190297_327491# a_191438_327491# 0.00342f
C4485 a_190824_327491# a_190926_328013# 0.22366f
C4486 a_210007_328605# a_210109_328013# 0.00167f
C4487 a_360458_298765# a_364458_298435# 0.03774f
C4488 a_79025_125231# user_project_wrapper_0.sg13g2_IOPadIn$1_0.p2c 0.14343f
C4489 m4_6440_9800# m5_6440_9800# 1.03989p
C4490 a_315347_192648# a_315347_192734# 0.07082f
C4491 a_210007_328605# a_210621_328605# 0.01253f
C4492 a_209480_328605# a_211153_329332# 0
C4493 a_190814_324870# a_189672_324776# 0.05065f
C4494 a_114175_35542# a_114175_35456# 0.03774f
C4495 user_project_wrapper_0.VDD1 a_79038_134832# 0.09485f
C4496 a_208103_324155# a_209684_328605# 0
C4497 a_79025_129164# a_79038_128322# 0.70614f
C4498 a_91911_129060# a_92512_129061# 0.02781f
C4499 a_87434_129426# a_89114_127896# 0
C4500 a_79025_129571# a_82527_127455# 0
C4501 a_211921_330026# a_211921_329814# 0.01085f
C4502 a_84598_130577# a_87434_127531# 0
C4503 user_project_wrapper_0.VDD1 a_90579_129060# 0.35674f
C4504 a_355624_217444# a_355784_225661# 0.01916f
C4505 w_207887_327938# a_211537_328225# 0.0018f
C4506 a_79038_125686# a_79025_125231# 0.03129f
C4507 a_82826_124842# a_79025_127401# 0
C4508 a_190082_92557# a_190638_90558# 0.04298f
C4509 a_189524_90472# a_190638_90472# 0.00945f
C4510 user_project_wrapper_0.analog_io[7] a_41476_258244# 25.1197f
C4511 a_360458_81295# a_360458_81625# 0.37213f
C4512 a_190501_327491# a_189756_328605# 0.00156f
C4513 user_project_wrapper_0.VDD1 user_project_wrapper_0.analog_io[7] 19.8429f
C4514 a_58170_179951# user_project_wrapper_0.sg13g2_IOPadOut4mA$1_0.sg13g2_GateLevelUpInv_noptap$1$1_0.pgate 0.00721f
C4515 m2_83010_126180# a_82840_127455# 0
C4516 a_188834_327918# a_189756_326377# 0.01056f
C4517 a_189184_325263# a_189184_326377# 0.6272f
C4518 a_189756_325263# a_187364_324106# 0.01526f
C4519 TOP_ROILIFNEURON_0.MEM a_211921_325785# 0.00793f
C4520 user_project_wrapper_0.analog_io[30] a_189672_324776# 0
C4521 a_87851_125174# a_87775_125210# 0.07227f
C4522 user_project_wrapper_0.sg13g2_IOPadAnalog_7.padres QDLL_TOP_0.VOUT 0.33115f
C4523 a_87627_124843# a_88393_125210# 0.00826f
C4524 a_87673_125210# a_87571_125210# 0.3249f
C4525 a_90579_129060# user_project_wrapper_0.sg13g2_IOPadIn$1_1.p2c 0.00583f
C4526 a_208017_326341# a_209684_327491# 0
C4527 a_208017_327918# a_210007_327491# 0
C4528 a_208939_325263# a_209480_327491# 0.02326f
C4529 a_208939_329719# a_208367_327491# 0
C4530 a_360458_303385# a_364458_303055# 0.03774f
C4531 a_210621_325263# a_211537_325570# 0.0091f
C4532 user_project_wrapper_0.sg13g2_IOPadAnalog_21.padres a_208367_327491# 0.05592f
C4533 a_208939_325263# a_210007_328605# 0.00321f
C4534 a_208017_326341# a_209480_328605# 0.00123f
C4535 a_208367_325263# a_208469_329327# 0
C4536 a_190824_328605# a_190501_327491# 0
C4537 a_190501_328605# a_190824_327491# 0
C4538 a_190297_328605# a_190297_327491# 0.00495f
C4539 user_project_wrapper_0.sg13g2_IOPadAnalog_22.padres a_208469_329327# 0.00883f
C4540 a_85257_125209# a_84332_125209# 0.0728f
C4541 a_192354_326465# a_191438_326377# 0
C4542 a_212178_331163# user_project_wrapper_0.sg13g2_IOPadAnalog_22.padres 0
C4543 a_78824_124371# user_project_wrapper_0.VDD1 2.66954f
C4544 user_project_wrapper_0.IOVDD2 a_302065_39542# 0.02119f
C4545 a_208792_324119# a_208939_326377# 0.00128f
C4546 a_208579_324119# a_208367_326377# 0
C4547 a_209230_324119# a_206547_324106# 0.29565f
C4548 w_207887_326203# a_208017_326341# 0.35328f
C4549 w_207887_327938# a_208367_329719# 0.06543f
C4550 w_207989_323975# a_208017_327918# 0
C4551 a_360458_76345# a_364458_76015# 0.03774f
C4552 a_298105_360372# a_298435_360458# 0.03774f
C4553 a_208469_326377# a_208367_327491# 0.02855f
C4554 a_209041_326377# a_208939_327491# 0.02675f
C4555 user_project_wrapper_0.IOVDD1 user_project_wrapper_0.sg13g2_IOPadIOVdd_1.sg13g2_RCClampResistor_0.p2 0.1048p
C4556 w_188806_323975# a_188834_326341# 0
C4557 user_project_wrapper_0.VDD1 a_89953_127531# 0.86466f
C4558 a_266461_355784# user_project_wrapper_0.IOVDD4 1.92793f
C4559 user_project_wrapper_0.IOVDD4 a_302065_360372# 0.02119f
C4560 a_35542_301075# a_39542_300745# 0.03774f
C4561 a_314793_198352# a_314793_197200# 0.02707f
C4562 a_360458_79645# IOVDD3 0
C4563 w_188704_327938# user_project_wrapper_0.sg13g2_IOPadAnalog_19.padres 0.02376f
C4564 user_project_wrapper_0.sg13g2_IOPadIn$1_2.p2c a_189396_324119# 0.02234f
C4565 a_78218_138195# a_78824_137391# 0.00397f
C4566 a_77995_364458# a_77995_360458# 0.03774f
C4567 TOP_ROILIFNEURON_0.MEM a_211153_326892# 0.00109f
C4568 a_189858_325263# a_189756_326377# 0.02133f
C4569 a_189286_325263# a_189184_326377# 0.0201f
C4570 a_75025_360458# a_75025_360372# 0.03774f
C4571 a_141418_56308# user_project_wrapper_0.sg13g2_IOPadAnalog_6.padres 0.0512f
C4572 a_86594_129426# a_87434_129426# 0.26531f
C4573 a_190319_102855# a_190490_102497# 0.37141f
C4574 a_185968_102197# a_186430_102197# 0.04858f
C4575 a_211921_325785# a_208855_324776# 0
C4576 user_project_wrapper_0.sg13g2_IOPadAnalog_9.padres a_79025_131741# 0.00771f
C4577 a_210137_330851# a_208367_329719# 0
C4578 a_192738_330453# a_192738_330241# 0.01085f
C4579 a_191438_329719# a_192354_330026# 0.0091f
C4580 a_301075_35456# a_301405_35542# 0.03774f
C4581 a_209940_324686# a_209905_325263# 0
C4582 a_89953_127531# user_project_wrapper_0.sg13g2_IOPadIn$1_1.p2c 0.04875f
C4583 IOVDD3 user_project_wrapper_0.sg13g2_IOPadAnalog_25.padres 1.36563f
C4584 user_project_wrapper_0.VDD1 a_82118_239118# 0.37287f
C4585 a_187018_328627# a_188834_327918# 0
C4586 user_project_wrapper_0.sg13g2_IOPadAnalog_8.padres a_79025_135674# 0.01276f
C4587 m1_81567_127343# a_79025_136081# 0.00211f
C4588 user_project_wrapper_0.IOVDD2 a_297775_35456# 0.01588f
C4589 user_project_wrapper_0.sg13g2_IOPadIn$1_0.p2c a_79025_133911# 0.06512f
C4590 user_project_wrapper_0.IOVDD1 a_57810_179517# 0.8844f
C4591 a_208939_325263# a_210621_326377# 0.00149f
C4592 user_project_wrapper_0.IOVDD1 a_35542_74695# 0
C4593 a_211153_327798# a_210621_327491# 0.00324f
C4594 a_211537_328013# a_211537_328225# 0.01085f
C4595 a_360458_77665# VDD3 0
C4596 a_210109_327491# a_210007_327491# 0.1023f
C4597 a_211153_327586# a_209480_327491# 0
C4598 a_190297_326377# a_190926_327491# 0
C4599 a_211537_327586# a_209684_327491# 0
C4600 user_project_wrapper_0.VDD2 a_122095_35542# -0
C4601 a_210007_325263# a_209905_325263# 0.1023f
C4602 a_209684_325263# a_211153_325358# 0
C4603 a_209480_325263# a_210109_325263# 0.01814f
C4604 a_35456_77335# a_35542_77665# 0.03774f
C4605 a_57810_282219# a_58170_281951# 0.3766f
C4606 user_project_wrapper_0.sg13g2_IOPadIn$1_1.p2c a_82118_239118# 0.00346f
C4607 a_82846_241091# a_86407_241748# 0.00696f
C4608 a_85989_241383# a_87832_241383# 0
C4609 a_208367_327491# a_209480_327491# 0.60144f
C4610 a_208939_327491# a_210007_327491# 0.01582f
C4611 a_210007_328605# a_208367_327491# 0
C4612 a_360458_299425# a_364458_299095# 0.03774f
C4613 w_188704_327938# a_189184_326377# 0
C4614 user_project_wrapper_0.sg13g2_IOPadAnalog_22.padres a_212178_331343# 0
C4615 a_360458_73375# VDD3 0.06211f
C4616 a_210621_326377# a_211537_326892# 0.0091f
C4617 a_209104_331343# a_208017_326341# 0
C4618 user_project_wrapper_0.sg13g2_IOPadAnalog_21.padres a_208071_331343# 0
C4619 user_project_wrapper_0.VDD1 a_78219_136982# 0.01233f
C4620 a_190455_324119# a_189672_324776# 0.0523f
C4621 a_84598_130577# a_84332_125209# 0.00401f
C4622 a_304889_198885# a_305619_211562# 0.06883f
C4623 user_project_wrapper_0.VDD1 a_78824_128711# 2.73558f
C4624 a_299095_35542# a_299425_35542# 0.37213f
C4625 a_78824_126541# a_79025_127401# 0.04638f
C4626 w_207887_327938# a_210007_327491# 0.11519f
C4627 a_189184_325263# a_189286_325263# 0.1023f
C4628 user_project_wrapper_0.sg13g2_IOPadIn$1_2.p2c a_190297_325263# 0
C4629 user_project_wrapper_0.IOVDD1 a_35456_298435# 0.01567f
C4630 a_188408_90472# a_189524_90472# 0.00939f
C4631 a_188966_92557# a_189524_90558# 0.04255f
C4632 w_207887_327938# a_210417_328605# 0.22627f
C4633 user_project_wrapper_0.IOVDD2 user_project_wrapper_0.sg13g2_IOPadVdd_1.sg13g2_RCClampInverter_noptap_0.out 49.206f
C4634 a_210137_331163# TOP_ROILIFNEURON_0.MEM 0.00344f
C4635 a_191987_331163# a_191987_330987# 0.13024f
C4636 user_project_wrapper_0.sg13g2_IOPadAnalog_22.padres a_208469_327491# 0.01007f
C4637 TOP_ROILIFNEURON_0.MEM w_207887_327938# 0.02545f
C4638 a_188802_330987# w_188700_330166# 0
C4639 a_191234_327491# a_188920_324155# 0
C4640 a_210007_325263# a_210109_326377# 0.00167f
C4641 a_87851_125174# a_88291_125210# 0.3249f
C4642 a_85257_125209# a_85155_125209# 0.3249f
C4643 a_85211_124842# a_85977_125209# 0.00826f
C4644 a_85435_125173# a_85359_125209# 0.07227f
C4645 w_207887_326203# a_210621_325263# 0.08621f
C4646 user_project_wrapper_0.analog_io[13] a_202618_56308# 0.05479f
C4647 a_360458_304045# a_364458_303715# 0.03774f
C4648 a_79315_364458# user_project_wrapper_0.IOVDD4 0.01409f
C4649 a_189756_325263# a_190926_327491# 0
C4650 a_189184_329719# a_189286_327491# 0
C4651 a_189756_329719# a_189858_327491# 0
C4652 a_210621_326377# a_211153_327586# 0
C4653 a_82872_125209# a_82527_127455# 0
C4654 a_156244_29676# a_164461_29836# 0.01778f
C4655 a_192738_326677# a_190824_326377# 0
C4656 a_210417_326377# a_210007_326377# 0.15379f
C4657 a_190722_326377# a_190722_327099# 0
C4658 a_82667_125418# a_84332_125209# 0.12278f
C4659 a_210137_330851# a_210417_328605# 0
C4660 a_209018_330987# user_project_wrapper_0.sg13g2_IOPadAnalog_22.padres 0
C4661 a_82974_125209# user_project_wrapper_0.VDD1 0.14011f
C4662 user_project_wrapper_0.IOVDD2 a_300745_39542# 0.02119f
C4663 user_project_wrapper_0.sg13g2_IOPadAnalog_4.padres a_223018_56308# 0.0512f
C4664 w_188704_327938# a_192738_328693# 0.0018f
C4665 a_360458_77005# a_364458_76675# 0.03774f
C4666 TOP_ROILIFNEURON_0.MEM a_210137_330851# 0.00132f
C4667 a_190868_330987# a_190954_330851# 0.00843f
C4668 a_186397_108495# a_186397_108409# 0.055f
C4669 a_210109_327099# a_209684_327491# 0
C4670 w_188700_330166# a_188834_327918# 0.08617f
C4671 w_188704_327938# a_189184_325263# 0.01615f
C4672 a_164461_355784# user_project_wrapper_0.IOVDD4 1.92793f
C4673 user_project_wrapper_0.VDD1 a_79038_127856# 0.09619f
C4674 user_project_wrapper_0.IOVDD4 a_300745_360372# 0.02119f
C4675 a_35542_301735# a_39542_301405# 0.03774f
C4676 a_360458_80965# IOVDD3 0
C4677 a_210051_330987# a_209684_329719# 0
C4678 user_project_wrapper_0.analog_io[1] a_56308_141418# 0.05479f
C4679 user_project_wrapper_0.sg13g2_IOPadAnalog_6.padres a_189729_99046# 0.00119f
C4680 user_project_wrapper_0.IOVDD2 a_258244_41476# 58.9173f
C4681 a_77335_364458# a_77335_360458# 0.03774f
C4682 a_74365_360458# a_74365_360372# 0.03774f
C4683 TOP_ROILIFNEURON_0.MEM a_210645_324119# 0.0045f
C4684 w_207887_326203# a_210109_327099# 0
C4685 a_360458_74695# a_360458_75025# 0.37213f
C4686 a_79038_130026# a_78824_128711# 0
C4687 a_191417_110495# a_191975_108496# 0.04279f
C4688 a_190862_108410# a_191975_108410# 0.00943f
C4689 w_207887_326203# a_211321_324119# 0
C4690 w_207989_323975# a_210645_324119# 0.23826f
C4691 a_190218_102763# a_189729_101343# 0.00128f
C4692 a_186431_99272# QDLL_TOP_0.VOUT 0.27781f
C4693 a_188834_327918# a_189286_328605# 0.01947f
C4694 user_project_wrapper_0.sg13g2_IOPadAnalog_9.padres a_79038_134366# 0
C4695 user_project_wrapper_0.sg13g2_IOPadAnalog_22.padres a_207638_330851# 0.01131f
C4696 a_191438_329719# a_191970_330453# 0.002f
C4697 a_300415_35456# a_300745_35542# 0.03774f
C4698 a_211321_324119# a_210621_325263# 0.00257f
C4699 a_190824_329719# a_190722_329719# 0.1023f
C4700 a_190297_329719# a_190926_329719# 0.01814f
C4701 user_project_wrapper_0.VDD1 a_86970_241383# 0.33962f
C4702 a_189921_330851# a_189184_329719# 0.00511f
C4703 user_project_wrapper_0.sg13g2_IOPadAnalog_8.padres a_78824_137391# 0.11331f
C4704 user_project_wrapper_0.IOVDD2 a_121435_35542# 0
C4705 user_project_wrapper_0.IOVDD1 a_35542_76015# 0
C4706 TOP_ROILIFNEURON_0.MEM a_191970_325785# 0.00115f
C4707 a_208855_324776# user_project_wrapper_0.analog_io[35] 0
C4708 a_211153_327798# a_209684_327491# 0
C4709 a_211537_328013# a_210007_327491# 0
C4710 a_360458_78985# VDD3 -0
C4711 a_35542_79975# a_39542_79645# 0.03774f
C4712 a_83389_129203# user_project_wrapper_0.sg13g2_IOPadIn$1_0.p2c 0.00589f
C4713 a_208367_325263# a_209869_324119# 0
C4714 a_208939_325263# a_209230_324119# 0.00768f
C4715 user_project_wrapper_0.VDD2 a_120775_35542# -0
C4716 a_209684_328605# a_210109_328605# 0.00489f
C4717 a_208367_328605# a_211153_328905# 0
C4718 user_project_wrapper_0.IOVDD1 a_35542_305035# 0
C4719 a_210007_325263# a_211153_325785# 0
C4720 a_35456_77995# a_35542_78325# 0.03774f
C4721 user_project_wrapper_0.sg13g2_IOPadIn$1_1.p2c a_86970_241383# 0
C4722 a_85591_241748# a_85989_241383# 0.05195f
C4723 TOP_ROILIFNEURON_0.MEM a_211537_328013# 0.01123f
C4724 m1_81567_127343# m2_81563_127336# 0.00843f
C4725 a_360458_300085# a_364458_299755# 0.03774f
C4726 a_58798_179951# user_project_wrapper_0.sg13g2_IOPadOut4mA$1_0.sg13g2_GateLevelUpInv_noptap$1$1_0.ngate 0.56967f
C4727 a_186430_98275# QDLL_TOP_0.VOUT 0.54485f
C4728 user_project_wrapper_0.analog_io[14] user_project_wrapper_0.analog_io[13] 0.0327f
C4729 a_296732_197880# a_301423_196360# 0.1083f
C4730 a_304889_199957# a_296731_189665# 0.50206f
C4731 a_307232_196607# a_314697_196700# 0.00811f
C4732 a_191462_324119# a_187364_324106# 0
C4733 a_209905_330241# a_209905_329719# 0
C4734 user_project_wrapper_0.sg13g2_IOPadAnalog_22.padres a_209480_325263# 0
C4735 a_210007_329719# a_209684_328605# 0
C4736 a_210645_324119# a_208855_324776# 0.21008f
C4737 a_79025_124824# user_project_wrapper_0.sg13g2_IOPadAnalog_9.padres 0.31205f
C4738 a_208367_325263# a_209480_325263# 0.61242f
C4739 a_84598_130577# a_88274_127896# 0.00887f
C4740 TOP_ROILIFNEURON_0.MEM a_192738_327798# 0.00639f
C4741 a_189858_327099# a_189756_328605# 0.00123f
C4742 a_87434_129426# a_88274_129061# 0.01332f
C4743 a_88274_129426# a_89114_129061# 0.00441f
C4744 user_project_wrapper_0.VDD1 a_83070_130212# 0
C4745 a_189921_331343# a_189756_325263# 0
C4746 a_210983_324119# a_211928_324776# 0
C4747 a_188455_331343# user_project_wrapper_0.sg13g2_IOPadAnalog_17.padres 0.01402f
C4748 a_75355_360458# a_75685_360458# 0.37213f
C4749 a_191975_108496# a_192492_108495# 0.07486f
C4750 user_project_wrapper_0.IOVDD1 a_35456_299755# 0.01452f
C4751 a_187852_92557# a_188408_90558# 0.04298f
C4752 a_187294_90472# a_188408_90472# 0.00945f
C4753 user_project_wrapper_0.analog_io[15] user_project_wrapper_0.analog_io[13] 0.02286f
C4754 a_189921_331163# a_189921_330987# 0.13024f
C4755 a_191987_331163# TOP_ROILIFNEURON_0.MEM 0.03818f
C4756 a_85359_125209# user_project_wrapper_0.sg13g2_IOPadIn$1_0.p2c 0
C4757 TOP_ROILIFNEURON_0.MEM a_191462_324119# 0.0045f
C4758 a_85211_124842# a_87851_125174# 0
C4759 a_79025_126994# a_78824_124371# 0
C4760 user_project_wrapper_0.ui_PAD[9] user_project_wrapper_0.IOVDD1 84.7563f
C4761 a_83050_125173# a_82974_125209# 0.07227f
C4762 a_82826_124842# a_83592_125209# 0.00826f
C4763 a_82872_125209# a_82770_125209# 0.3249f
C4764 a_85052_125418# a_87673_125210# 0
C4765 w_188806_323975# a_191800_324119# 0.2384f
C4766 w_188704_326203# a_192745_324776# 0
C4767 a_360458_304705# a_364458_304375# 0.03774f
C4768 a_77995_364458# user_project_wrapper_0.IOVDD4 0.01409f
C4769 a_191970_326892# a_191234_326377# 0
C4770 a_192354_326892# a_190824_326377# 0
C4771 a_189858_326377# a_189184_326377# 0.01727f
C4772 a_208103_324155# a_206201_328627# 0.02167f
C4773 a_190722_326377# a_189756_326377# 0.0122f
C4774 a_305695_35456# a_306025_35542# 0.03774f
C4775 a_85257_125209# user_project_wrapper_0.VDD1 0.20474f
C4776 QDLL_TOP_0.VDD a_270512_100118# 1.30878f
C4777 a_87105_130835# a_86594_130470# 0.06697f
C4778 a_83925_130212# a_86507_129255# 0
C4779 TOP_ROILIFNEURON_0.MEM a_192354_329332# 0.00168f
C4780 a_360458_77665# a_364458_77335# 0.03774f
C4781 a_82859_242012# a_82846_241091# 0.00148f
C4782 w_188704_327938# a_189858_328605# 0.01323f
C4783 a_121105_39542# a_121765_39542# 0.02109f
C4784 a_189921_331163# a_188834_326341# 0
C4785 a_189835_330987# a_189756_329719# 0
C4786 a_189835_330987# user_project_wrapper_0.sg13g2_IOPadAnalog_17.padres 0
C4787 user_project_wrapper_0.sg13g2_IOPadAnalog_8.padres user_project_wrapper_0.sg13g2_IOPadAnalog_15.padres 0.02276f
C4788 user_project_wrapper_0.VDD2 a_116815_35542# 0
C4789 a_35542_302395# a_39542_302065# 0.03774f
C4790 user_project_wrapper_0.sg13g2_IOPadAnalog_17.padres a_189609_324119# 0.00101f
C4791 a_188834_326341# a_190047_324119# 0.00107f
C4792 a_189184_325263# a_190757_324686# 0.00244f
C4793 a_189756_325263# a_190455_324119# 0
C4794 a_190501_329719# a_189756_328605# 0
C4795 user_project_wrapper_0.sg13g2_IOPadAnalog_6.padres a_185968_98275# 0.03941f
C4796 a_84288_130212# a_83925_130212# 0.07507f
C4797 a_82645_240231# a_82846_242854# 0
C4798 a_76675_364458# a_76675_360458# 0.03774f
C4799 user_project_wrapper_0.IOVDD2 a_176644_41476# 58.9173f
C4800 a_73705_360458# a_73705_360372# 0.03774f
C4801 a_190722_325785# a_189184_326377# 0
C4802 a_355624_176644# IOVDD3 58.9173f
C4803 a_191438_328605# a_192738_328693# 0
C4804 a_84598_130577# a_84598_130212# 0.09189f
C4805 a_189748_108410# a_190862_108410# 0.00941f
C4806 a_190304_110495# a_190862_108496# 0.04279f
C4807 w_207989_323975# a_208171_324119# 0.20828f
C4808 user_project_wrapper_0.VDD1 user_project_wrapper_0.analog_io[0] 19.8007f
C4809 w_207887_326203# a_208792_324119# 0
C4810 user_project_wrapper_0.sg13g2_IOPadAnalog_9.padres a_78219_135283# 0.27505f
C4811 a_190501_329719# a_190824_328605# 0
C4812 a_189756_329719# a_189286_329327# 0
C4813 a_207985_330987# a_208367_329719# 0
C4814 a_209104_330987# a_208017_326341# 0
C4815 a_188834_326341# a_189858_329327# 0.00157f
C4816 a_189756_325263# a_190722_329327# 0.00101f
C4817 a_190824_329719# a_192354_330241# 0
C4818 a_192309_90557# user_project_wrapper_0.analog_io[13] 0.0113f
C4819 a_189756_327491# a_189858_328013# 0.22162f
C4820 a_189184_327491# a_189286_328013# 0.22524f
C4821 user_project_wrapper_0.sg13g2_IOPadAnalog_17.padres a_189286_329327# 0.00883f
C4822 a_190297_327491# a_190824_327491# 0.20173f
C4823 a_190501_327491# a_191234_327491# 0.00663f
C4824 a_299755_35456# a_300085_35542# 0.03774f
C4825 user_project_wrapper_0.sg13g2_IOPadAnalog_19.padres a_190501_328605# 0
C4826 user_project_wrapper_0.analog_io[32] a_205385_326221# 0.17599f
C4827 a_208071_331163# a_208071_331343# 0.12339f
C4828 user_project_wrapper_0.IOVDD2 a_120115_35542# 0
C4829 user_project_wrapper_0.sg13g2_IOPadAnalog_6.padres user_project_wrapper_0.VDD2 5.23632f
C4830 TOP_ROILIFNEURON_0.MEM a_191438_325263# 0.12156f
C4831 user_project_wrapper_0.IOVDD1 a_35542_77335# 0
C4832 a_74365_360458# user_project_wrapper_0.IOVDD4 0
C4833 user_project_wrapper_0.IOVDD1 a_58798_281951# 0.07206f
C4834 a_35542_80635# a_39542_80305# 0.03774f
C4835 a_360458_80305# VDD3 0
C4836 w_188704_326203# a_192738_325997# 0.0018f
C4837 a_79025_129571# user_project_wrapper_0.sg13g2_IOPadIn$1_0.p2c 0.00471f
C4838 user_project_wrapper_0.VDD2 a_119455_35542# 0
C4839 a_209684_328605# a_211537_329332# 0
C4840 a_189184_325263# a_189858_326377# 0.00236f
C4841 a_188834_327918# a_189286_326377# 0.0193f
C4842 a_209684_325263# a_209905_325785# 0.05425f
C4843 a_35456_78655# a_35542_78985# 0.03774f
C4844 a_79025_126994# a_78824_128711# 0
C4845 user_project_wrapper_0.sg13g2_IOPadAnalog_14.padres a_82859_239376# 0.17971f
C4846 a_263818_56308# user_project_wrapper_0.analog_io[16] 0.05479f
C4847 m1_81768_242005# m2_81766_242000# 0.01078f
C4848 user_project_wrapper_0.IOVDD2 user_project_wrapper_0.sg13g2_IOPadIOVdd_0.sg13g2_Clamp_N43N43D4R_0.gate 0.15002p
C4849 a_296731_189665# a_311108_179669# 0.00384f
C4850 a_311189_185546# analog_io[20] 0.12302f
C4851 m2_82112_130096# user_project_wrapper_0.sg13g2_IOPadIn$1_0.p2c 0
C4852 a_304995_198817# a_304196_197873# 6.82922f
C4853 a_307232_196607# a_304889_199957# 0.0087f
C4854 a_208171_324119# a_208855_324776# 0
C4855 user_project_wrapper_0.VDD1 a_39542_73705# 0.03085f
C4856 a_209684_329719# a_210109_329719# 0.05284f
C4857 a_188988_324119# a_187364_324106# 0.13181f
C4858 a_210621_329719# a_211921_330453# 0
C4859 a_209480_329719# a_209905_329719# 0.00962f
C4860 TOP_ROILIFNEURON_0.MEM a_191970_328225# 0.00105f
C4861 a_209869_324119# a_210307_324119# 0.00396f
C4862 user_project_wrapper_0.VDD1 a_84598_130577# 1.21488f
C4863 a_300085_360458# a_300415_360458# 0.37213f
C4864 a_189184_325263# a_190722_325785# 0.00571f
C4865 a_189756_325263# a_189286_325785# 0
C4866 a_369296_197044# a_369456_205261# 0.01778f
C4867 user_project_wrapper_0.IOVDD1 a_35456_301075# 0.01563f
C4868 a_82872_125209# m1_83011_126179# 0
C4869 a_186731_92558# a_187294_90558# 0.05559f
C4870 a_208939_329719# a_209684_328605# 0.00113f
C4871 a_208367_329719# a_208367_328605# 0.19405f
C4872 user_project_wrapper_0.sg13g2_IOPadAnalog_21.padres a_209684_328605# 0
C4873 a_305695_360458# a_305365_360458# 0.37213f
C4874 analog_io[20] a_355624_156244# 25.1197f
C4875 user_project_wrapper_0.sg13g2_IOPadIn$1_0.p2c a_83389_128838# 0
C4876 a_210007_325263# a_209940_324686# 0
C4877 a_83490_125209# a_85211_124842# 0
C4878 a_84598_130577# user_project_wrapper_0.sg13g2_IOPadIn$1_1.p2c 0.00474f
C4879 a_82826_124842# a_85875_125209# 0
C4880 w_188704_326203# a_190047_324119# 0.00152f
C4881 a_191970_328693# a_191970_328225# 0.00322f
C4882 w_188806_323975# a_189396_324119# 0.0962f
C4883 a_189729_101343# QDLL_TOP_0.VDD 1.36782f
C4884 a_76675_364458# user_project_wrapper_0.IOVDD4 0.01409f
C4885 a_360458_305365# a_364458_305035# 0.03774f
C4886 a_191800_324119# a_192745_324776# 0
C4887 a_190287_98223# user_project_wrapper_0.analog_io[13] 0
C4888 a_305035_35542# a_305365_35542# 0.37213f
C4889 a_82667_125418# user_project_wrapper_0.VDD1 0.62099f
C4890 TOP_ROILIFNEURON_0.MEM a_190824_328605# 0
C4891 user_project_wrapper_0.IOVDD2 a_116155_35542# 0
C4892 a_83796_129203# a_79025_131741# 0.00813f
C4893 IOVDD3 a_369296_176644# 0.16358f
C4894 a_120445_39542# a_121105_39542# 0.02109f
C4895 user_project_wrapper_0.sg13g2_IOPadVdd_0.sg13g2_RCClampResistor_0.p2 IOVDD3 68.87679f
C4896 a_360458_78325# a_364458_77995# 0.03774f
C4897 w_188704_327938# a_191438_328605# 0.08621f
C4898 a_210137_331163# a_210137_330987# 0.13024f
C4899 a_210937_330987# a_210051_330987# 0.02617f
C4900 a_209480_325263# a_210417_325263# 0.02229f
C4901 a_191438_325263# a_192354_325570# 0.0091f
C4902 a_190297_325263# a_192354_325358# 0
C4903 a_355624_135844# IOVDD3 58.9173f
C4904 user_project_wrapper_0.VDD2 a_115495_35542# 0
C4905 a_35542_303055# a_39542_302725# 0.03774f
C4906 a_189756_325263# a_190926_329719# 0
C4907 a_189184_329719# a_189286_329719# 0.1142f
C4908 a_189756_329719# a_189858_329719# 0.11442f
C4909 a_82846_241091# a_82846_242854# 0.09651f
C4910 a_82746_130212# a_83796_129203# 0.00133f
C4911 a_82859_241546# a_82846_243261# 0.00287f
C4912 a_76015_364458# a_76015_360458# 0.03774f
C4913 a_83070_130577# a_82433_130212# 0.05292f
C4914 a_79025_125231# a_83398_130212# 0.00631f
C4915 a_39542_73705# a_35542_73705# 0.03774f
C4916 TOP_ROILIFNEURON_0.MEM a_192354_327104# 0.00168f
C4917 user_project_wrapper_0.sg13g2_IOPadAnalog_15.padres a_82118_242359# 0.0041f
C4918 a_189190_110495# a_189748_108496# 0.04279f
C4919 a_188632_108410# a_189748_108410# 0.00939f
C4920 a_189184_325263# a_190501_328605# 0
C4921 a_188834_327918# a_189184_328605# 0.62443f
C4922 a_190082_90557# user_project_wrapper_0.analog_io[13] 0.0113f
C4923 a_190824_329719# a_189858_330241# 0
C4924 a_210137_330987# a_210137_330851# 0.29305f
C4925 a_210051_330987# a_211170_330851# 0.00843f
C4926 user_project_wrapper_0.sg13g2_IOPadIn$1_1.sg13g2_LevelDown_noptap$1_0.sg13g2_SecondaryProtection$1$1_0.core user_project_wrapper_0.IOVDD1 1.37355f
C4927 user_project_wrapper_0.IOVDD2 a_118795_35542# 0
C4928 a_35456_79975# user_project_wrapper_0.IOVDD1 0.01409f
C4929 user_project_wrapper_0.IOVDD4 user_project_wrapper_0.analog_io[33] 0.10967p
C4930 a_360372_73705# a_360458_74035# 0.03774f
C4931 TOP_ROILIFNEURON_0.MEM a_190501_325263# 0
C4932 user_project_wrapper_0.IOVDD1 a_35542_78655# 0
C4933 a_208367_328605# a_210007_327491# 0
C4934 a_35542_81295# a_39542_80965# 0.03774f
C4935 w_188704_326203# a_191234_325263# 0.22627f
C4936 w_188806_323975# a_190297_325263# 0.0015f
C4937 user_project_wrapper_0.VDD2 a_118135_35542# 0
C4938 a_209684_328605# a_210007_328605# 0.34324f
C4939 a_208367_328605# a_210417_328605# 0.0113f
C4940 a_211921_326465# a_211921_325997# 0.00322f
C4941 a_191438_327491# a_191970_327586# 0.00193f
C4942 a_304090_197941# a_304196_200821# 0.82496f
C4943 a_309516_194555# a_304995_198817# 0
C4944 a_210007_329719# a_211153_330241# 0
C4945 a_301940_196388# a_304889_199957# 0.1323f
C4946 user_project_wrapper_0.VDD1 a_39542_75025# 0
C4947 a_296732_200582# a_301509_202742# 0.00168f
C4948 a_296626_197740# a_304196_197873# 0.19542f
C4949 a_301186_192011# a_296625_189595# 0.22991f
C4950 a_84598_130577# a_86594_129061# 0.00356f
C4951 a_190501_326377# a_188920_324155# 0
C4952 w_188704_327938# a_190926_328013# 0.01287f
C4953 a_78221_125094# user_project_wrapper_0.sg13g2_IOPadAnalog_8.padres 0.00431f
C4954 a_217444_369296# a_225661_369456# 0.01778f
C4955 user_project_wrapper_0.IOVDD1 a_35456_302395# 0.01567f
C4956 user_project_wrapper_0.VDD1 user_project_wrapper_0.sg13g2_IOPadAnalog_9.padres 6.53105f
C4957 a_82872_125209# user_project_wrapper_0.sg13g2_IOPadIn$1_0.p2c 0.06615f
C4958 a_208939_329719# a_209041_329719# 0.11442f
C4959 a_208367_329719# a_208469_329719# 0.1142f
C4960 a_208939_325263# a_210109_329719# 0
C4961 user_project_wrapper_0.analog_io[13] user_project_wrapper_0.IOVDD2 0.11103p
C4962 user_project_wrapper_0.sg13g2_IOPadAnalog_21.padres a_209041_329719# 0.01013f
C4963 a_78220_130691# a_79038_132196# 0.17968f
C4964 a_78824_133051# a_78824_130881# 0
C4965 a_191438_325263# a_191970_326465# 0
C4966 a_211537_326677# a_211537_326892# 0.01056f
C4967 a_86507_127725# a_86507_129255# 0.1651f
C4968 a_80965_360372# a_81295_360458# 0.03774f
C4969 a_82667_125418# a_83050_125173# 0.02964f
C4970 a_188802_330987# a_188920_324155# 0
C4971 TOP_ROILIFNEURON_0.MEM a_192738_330026# 0.00657f
C4972 a_186431_100948# QDLL_TOP_0.VDD 0.00296f
C4973 a_360458_306025# a_364458_305695# 0.03774f
C4974 a_29676_237844# user_project_wrapper_0.analog_io[6] 9.69836f
C4975 a_190686_324119# a_191124_324119# 0.00396f
C4976 user_project_wrapper_0.sg13g2_IOPadAnalog_29.padres a_315347_192648# 0.09535f
C4977 a_304375_35542# a_304705_35542# 0.37213f
C4978 a_83398_130212# a_79025_133911# 0
C4979 user_project_wrapper_0.IOVDD2 a_114835_35542# 0
C4980 a_209480_326377# a_210007_326377# 0.20174f
C4981 w_188704_327938# a_190501_328605# 0.10225f
C4982 a_360458_78985# a_364458_78655# 0.03774f
C4983 a_119785_39542# a_120445_39542# 0.02109f
C4984 a_83492_127455# a_87105_130835# 0
C4985 a_208871_330987# a_207985_330987# 0.02649f
C4986 a_208071_331163# a_208071_330987# 0.13024f
C4987 a_190297_325263# a_191970_325570# 0
C4988 a_190824_325263# a_192738_325785# 0
C4989 a_191970_327104# a_191970_327586# 0.0031f
C4990 user_project_wrapper_0.analog_io[13] a_191417_108495# 0.01131f
C4991 a_296731_189665# VDD3 57.9755f
C4992 a_135844_369296# user_project_wrapper_0.IOVDD4 0.16358f
C4993 a_190501_325263# a_192354_325570# 0
C4994 user_project_wrapper_0.VDD2 a_114175_35542# 0.06211f
C4995 a_190926_327099# a_190297_327491# 0
C4996 a_188834_327918# a_188920_324155# 0.15786f
C4997 a_85287_241383# a_82846_243261# 0.09292f
C4998 a_39542_74365# a_35542_74365# 0.03774f
C4999 a_191234_328605# a_192354_329120# 0
C5000 a_360458_301075# IOVDD3 0
C5001 a_189184_328605# a_190722_328605# 0.00477f
C5002 a_190824_328605# a_192738_329120# 0
C5003 a_187518_108410# a_188632_108410# 0.00941f
C5004 a_188074_110495# a_188632_108496# 0.04279f
C5005 a_90579_127530# a_86507_129255# 0.00378f
C5006 a_190824_329719# a_191234_329719# 0.15379f
C5007 a_187852_90557# user_project_wrapper_0.analog_io[13] 0.03525f
C5008 a_211153_328905# a_211153_328693# 0.01085f
C5009 a_79038_130026# user_project_wrapper_0.sg13g2_IOPadAnalog_9.padres 0
C5010 a_91911_129060# a_92512_127531# 0
C5011 a_207638_330987# a_207638_330851# 0.07033f
C5012 user_project_wrapper_0.IOVDD2 a_117475_35542# 0
C5013 a_79025_127401# a_83586_127455# 0.00169f
C5014 a_58170_179249# a_58798_179249# 0.08391f
C5015 a_190722_325785# a_190757_324686# 0
C5016 a_190501_325263# a_190814_324870# 0.00258f
C5017 a_211153_326677# a_210621_325263# 0
C5018 a_135844_369296# user_project_wrapper_0.analog_io[28] 9.69836f
C5019 a_189858_325263# a_188920_324155# 0.00407f
C5020 user_project_wrapper_0.sg13g2_IOPadIn$1_2.p2c a_189672_324776# 0.17689f
C5021 a_360372_300745# a_360372_300085# 0.02109f
C5022 user_project_wrapper_0.VDD1 a_39542_76345# 0.00238f
C5023 a_209684_329719# a_209905_330241# 0.05425f
C5024 a_296625_208423# a_296732_200582# 12.4977f
C5025 a_213376_328627# a_213462_327536# 1.32746f
C5026 a_210007_329719# a_208469_330241# 0
C5027 a_301186_192011# a_301423_202742# 0.05315f
C5028 a_189184_329719# a_189286_328013# 0.00139f
C5029 a_189756_329719# a_189858_328013# 0.00194f
C5030 a_189672_324776# a_194193_328627# 0.28963f
C5031 user_project_wrapper_0.sg13g2_IOPadAnalog_19.padres a_190297_327491# 0.00841f
C5032 m1_85051_241246# a_82846_243261# 0
C5033 a_258244_369296# a_266461_369456# 0.01778f
C5034 a_208017_327918# a_208103_324155# 0.15786f
C5035 a_78219_134797# a_78220_130691# 0.00724f
C5036 a_79025_133911# a_79038_132662# 0.01177f
C5037 a_79025_136081# a_78824_130881# 0
C5038 a_78824_133051# a_79025_133504# 1.02588f
C5039 a_80305_360372# a_80635_360458# 0.03774f
C5040 user_project_wrapper_0.sg13g2_IOPadOut4mA$1_1.c2p a_85989_241383# 0.00927f
C5041 a_78221_126292# a_78221_125094# 0.01813f
C5042 TOP_ROILIFNEURON_0.MEM a_192354_330453# 0.00168f
C5043 a_92512_129426# a_93461_128591# 0.07074f
C5044 a_91911_129060# a_93204_129062# 0
C5045 a_313884_185173# a_314793_197200# 0.70446f
C5046 a_303715_35542# a_304045_35542# 0.37213f
C5047 a_82433_130212# a_79025_136081# 0.04283f
C5048 a_206547_324106# a_208939_326377# 0.00685f
C5049 a_343292_121018# analog_io[18] 0.05479f
C5050 a_360458_79645# a_364458_79315# 0.03774f
C5051 a_93204_129062# user_project_wrapper_0.sg13g2_IOPadOut4mA$1_0.c2p 0.11054f
C5052 a_119125_39542# a_119785_39542# 0.02109f
C5053 a_83389_129203# a_83398_130212# 0
C5054 a_89114_129426# a_87105_130835# 0.00179f
C5055 a_83079_128838# a_83796_129203# 0.00373f
C5056 a_82658_129203# a_82433_130212# 0.01586f
C5057 user_project_wrapper_0.sg13g2_IOPadAnalog_6.padres a_269543_100118# 0.00996f
C5058 a_188572_101637# QDLL_TOP_0.VOUT 0.00187f
C5059 user_project_wrapper_0.analog_io[13] a_189190_108495# 0.01131f
C5060 IOVDD3 user_project_wrapper_0.sg13g2_IOPadAnalog_27.padres 1.36563f
C5061 a_307232_196607# VDD3 1.91034f
C5062 a_190722_329327# a_189756_328605# 0.00596f
C5063 user_project_wrapper_0.sg13g2_IOPadAnalog_3.padres IOVDD3 1.36563f
C5064 a_191970_329332# a_191970_329814# 0.0031f
C5065 user_project_wrapper_0.sg13g2_IOPadAnalog_21.padres a_206201_328627# 0.14027f
C5066 a_189756_329719# a_189286_330241# 0.00123f
C5067 a_188834_326341# a_189858_330241# 0.01434f
C5068 a_190824_326377# a_189756_327491# 0
C5069 a_190297_326377# a_189184_327491# 0
C5070 a_190501_326377# a_190501_327491# 0.07618f
C5071 a_189184_326377# a_190297_327491# 0.00167f
C5072 a_176644_29676# user_project_wrapper_0.analog_io[12] 9.69836f
C5073 a_39542_75025# a_35542_75025# 0.03774f
C5074 a_299425_360372# user_project_wrapper_0.IOVDD4 0.01899f
C5075 user_project_wrapper_0.sg13g2_IOPadAnalog_17.padres a_189286_330241# 0.00126f
C5076 a_269079_100182# a_269355_100412# 0.16781f
C5077 a_360458_302395# IOVDD3 0
C5078 a_190501_328605# a_191438_328605# 0.00395f
C5079 a_190297_328605# a_190926_329327# 0.01814f
C5080 a_190824_328605# a_190722_329327# 0.1023f
C5081 a_186960_110495# a_187518_108496# 0.04279f
C5082 a_186397_108409# a_187518_108410# 0.00895f
C5083 a_190218_102763# user_project_wrapper_0.analog_io[15] 0.14984f
C5084 a_86594_127896# a_86507_129255# 0
C5085 a_82527_127455# a_79025_131741# 0.10714f
C5086 a_115825_39542# a_116485_39542# 0.02109f
C5087 a_211537_329120# a_211537_328905# 0.01056f
C5088 a_83492_127455# a_87434_127531# 0.02398f
C5089 a_92512_129426# a_92512_127896# 0
C5090 a_208103_324155# a_210109_327491# 0
C5091 a_39542_304045# a_35542_304045# 0.03774f
C5092 a_79975_364458# a_80635_364458# 0.02109f
C5093 TOP_ROILIFNEURON_0.MEM a_191234_327491# 0.00575f
C5094 user_project_wrapper_0.IOVDD1 a_41476_217444# 58.9173f
C5095 a_305365_360372# a_305695_360458# 0.03774f
C5096 a_208103_324155# a_208939_327491# 0.74832f
C5097 a_304889_198885# a_296625_189595# 0.06805f
C5098 a_190501_325263# a_190455_324119# 0.0029f
C5099 a_190297_325263# a_190047_324119# 0.00209f
C5100 a_78220_123062# a_78220_122262# 0.01975f
C5101 a_79038_123982# a_79038_123516# 0.04646f
C5102 TOP_ROILIFNEURON_0.MEM a_211921_330453# 0.00436f
C5103 a_243418_343292# user_project_wrapper_0.analog_io[33] 0.05479f
C5104 user_project_wrapper_0.VDD2 a_263818_56308# -0
C5105 w_207887_327938# a_208103_324155# 0.0241f
C5106 a_360372_301405# a_360372_300745# 0.02109f
C5107 a_35542_79645# user_project_wrapper_0.VDD1 0
C5108 a_210109_326377# a_209480_326377# 0.01192f
C5109 a_79025_126994# user_project_wrapper_0.sg13g2_IOPadAnalog_9.padres 0.32292f
C5110 a_209684_329719# a_209480_329719# 0.77558f
C5111 a_209905_326377# a_210007_326377# 0.20881f
C5112 user_project_wrapper_0.VDD1 a_39542_77665# 0.00238f
C5113 a_189756_325263# a_189184_327491# 0.25529f
C5114 a_188834_326341# a_189756_327491# 0.46504f
C5115 a_189184_325263# a_190297_327491# 0
C5116 a_188834_327918# a_190501_327491# 0
C5117 user_project_wrapper_0.IOVDD2 a_305695_35456# 0.01587f
C5118 a_91911_127530# a_92512_127896# 0.05556f
C5119 user_project_wrapper_0.sg13g2_IOPadAnalog_27.padres analog_io[26] 0.33115f
C5120 a_208017_326341# a_209041_330241# 0.01434f
C5121 a_208939_329719# a_208469_330241# 0.00123f
C5122 a_35456_299095# a_35456_298435# 0.02109f
C5123 user_project_wrapper_0.analog_io[5] a_41476_217444# 25.1197f
C5124 a_360458_76015# IOVDD3 0
C5125 a_78824_135221# a_78824_133051# 0
C5126 a_79038_134832# a_78219_134797# 0
C5127 a_79025_135674# a_79025_133911# 0.09651f
C5128 a_79645_360372# a_79975_360458# 0.03774f
C5129 a_79025_129571# a_79025_131334# 0.09651f
C5130 a_190954_330987# a_190297_329719# 0
C5131 a_190501_328605# a_190926_328013# 0
C5132 user_project_wrapper_0.sg13g2_IOPadOut4mA$1_0.sg13g2_GateLevelUpInv_noptap$1$1_0.pgate user_project_wrapper_0.sg13g2_IOPadOut4mA$1_0.c2p 0.03147f
C5133 a_83492_127455# a_91090_129425# 0.00137f
C5134 a_89953_129061# a_91911_129060# 0.18434f
C5135 a_90579_129060# a_86507_127725# 0.07412f
C5136 w_188700_330166# a_191970_330453# 0.0018f
C5137 a_35456_305695# a_35456_305035# 0.02109f
C5138 a_208103_324155# a_209041_327099# 0
C5139 a_303055_35542# a_303385_35542# 0.37213f
C5140 a_83070_130577# a_79025_138251# 0
C5141 user_project_wrapper_0.sg13g2_IOPadIn$1_2.p2c a_189756_325263# 0.00258f
C5142 a_78824_128711# a_79025_127401# 0
C5143 a_188572_99046# a_189016_99480# 0
C5144 a_118465_39542# a_119125_39542# 0.02109f
C5145 a_189395_99046# a_189729_99046# 0.49051f
C5146 a_360458_80305# a_364458_79975# 0.03774f
C5147 a_84598_130212# a_83796_129203# 0
C5148 a_89953_129061# user_project_wrapper_0.sg13g2_IOPadOut4mA$1_0.c2p 0
C5149 user_project_wrapper_0.analog_io[13] a_186960_108495# 0.04255f
C5150 a_186430_102197# QDLL_TOP_0.VOUT 0.54485f
C5151 a_190297_325263# a_191234_325263# 0.02229f
C5152 user_project_wrapper_0.sg13g2_IOPadAnalog_28.padres user_project_wrapper_0.analog_io[4] 0.33115f
C5153 IOVDD3 a_360458_299095# 0
C5154 a_301940_196388# VDD3 13.6854f
C5155 a_191438_328605# a_191970_330026# 0
C5156 a_189756_329719# a_190824_329719# 0.01075f
C5157 a_189184_329719# a_190297_329719# 0.63564f
C5158 a_191987_330851# a_192738_330453# 0.00195f
C5159 a_39542_75685# a_35542_75685# 0.03774f
C5160 a_298105_360372# user_project_wrapper_0.IOVDD4 0.04966f
C5161 a_82770_125209# a_79025_131741# 0
C5162 a_189184_328605# a_190297_328605# 0.64006f
C5163 a_360458_303715# IOVDD3 0
C5164 a_190297_327491# a_192354_327586# 0
C5165 a_355624_115444# a_355784_123661# 0.01916f
C5166 a_83164_127820# a_79025_133911# 0.00198f
C5167 a_211921_329332# a_211921_329120# 0.01085f
C5168 a_78220_128106# a_79025_131741# 0
C5169 a_210109_329327# a_210109_328605# 0
C5170 user_project_wrapper_0.VDD1 a_86594_130470# 0.35772f
C5171 a_115165_39542# a_115825_39542# 0.02109f
C5172 a_39542_304705# a_35542_304705# 0.03774f
C5173 a_90579_129060# a_90579_127530# 0
C5174 a_86507_127725# a_89953_127531# 0.10554f
C5175 a_83492_127455# a_84332_125209# 0.00869f
C5176 a_89953_129061# a_91090_127895# 0
C5177 a_35456_81295# a_35456_80635# 0.02109f
C5178 TOP_ROILIFNEURON_0.MEM a_211153_328693# 0.00105f
C5179 user_project_wrapper_0.analog_io[14] a_190319_97955# 0.44444f
C5180 w_188704_327938# a_190297_327491# 0.08768f
C5181 user_project_wrapper_0.sg13g2_IOPadAnalog_19.padres user_project_wrapper_0.analog_io[27] 6.13884f
C5182 w_188704_326203# a_189756_327491# 0.0623f
C5183 a_192309_92557# a_192309_90557# 0.04185f
C5184 user_project_wrapper_0.sg13g2_IOPadAnalog_22.padres a_209684_326377# 0
C5185 a_79025_127401# a_79038_127856# 0.03243f
C5186 a_208017_327918# a_208367_326377# 0.48217f
C5187 a_208017_326341# a_206547_324106# 0
C5188 a_208939_325263# a_208939_326377# 0.64568f
C5189 a_208367_325263# a_209684_326377# 0
C5190 user_project_wrapper_0.VDD1 a_83796_129203# 0.56121f
C5191 a_314793_198352# a_309516_194555# 0.03574f
C5192 a_78824_124371# a_78221_124694# 0.0063f
C5193 TOP_ROILIFNEURON_0.MEM a_213870_324142# 0
C5194 w_207883_330166# a_210621_329719# 0.07951f
C5195 a_360372_302065# a_360372_301405# 0.02109f
C5196 a_190722_328605# a_190501_327491# 0.00101f
C5197 a_208939_325263# a_209905_328605# 0.00191f
C5198 a_35542_80965# user_project_wrapper_0.VDD1 0
C5199 a_208017_326341# a_209041_328605# 0.01847f
C5200 a_190926_328605# a_189184_327491# 0
C5201 a_115444_369296# a_123661_369456# 0.01778f
C5202 user_project_wrapper_0.VDD1 a_39542_78985# 0.00198f
C5203 a_88393_125210# a_84332_125209# 0
C5204 a_211537_327104# a_209480_326377# 0
C5205 a_117145_39542# a_116485_39542# 0.02109f
C5206 user_project_wrapper_0.IOVDD2 a_304375_35456# 0.0145f
C5207 a_299095_35542# a_299095_35456# 0.03774f
C5208 a_360372_75025# a_360372_74365# 0.02109f
C5209 a_299425_360458# a_299755_360458# 0.37213f
C5210 a_89953_127531# a_90579_127530# 0.04426f
C5211 VDD3 user_project_wrapper_0.sg13g2_IOPadAnalog_26.padres 3.66671f
C5212 user_project_wrapper_0.VDD1 a_93719_127531# 0
C5213 a_208017_327918# a_210007_329719# 0
C5214 a_208939_325263# a_209480_329719# 0.0176f
C5215 a_35456_299755# a_35456_299095# 0.02109f
C5216 a_208017_326341# a_209684_329719# 0
C5217 user_project_wrapper_0.analog_io[14] QDLL_TOP_0.VDD 4.11947f
C5218 user_project_wrapper_0.IOVDD4 a_304705_360458# 0
C5219 a_360458_77335# IOVDD3 0
C5220 a_78219_135283# a_78219_134883# 0.05038f
C5221 a_79025_136081# a_78824_135221# 0.04829f
C5222 a_210137_330851# a_210109_330241# 0
C5223 a_78985_360372# a_79315_360458# 0.03774f
C5224 a_192354_325358# a_189672_324776# 0.00141f
C5225 user_project_wrapper_0.analog_io[15] QDLL_TOP_0.VDD 4.18174f
C5226 a_190490_102497# a_189729_101343# 0
C5227 a_188296_101407# a_188572_101637# 0.16781f
C5228 a_185968_102197# user_project_wrapper_0.sg13g2_IOPadAnalog_6.padres 0.03955f
C5229 a_213870_324142# a_208855_324776# 0.01061f
C5230 a_301186_192011# a_315347_192648# 0
C5231 a_302395_35542# a_302725_35542# 0.37213f
C5232 a_208103_324155# a_208171_324119# 0.44722f
C5233 a_190501_326377# a_189858_327099# 0
C5234 a_189184_326377# a_190722_327099# 0.01977f
C5235 a_209905_327491# a_209684_326377# 0
C5236 a_190824_326377# a_191234_326377# 0.15379f
C5237 a_190297_326377# a_189286_327099# 0
C5238 user_project_wrapper_0.sg13g2_IOPadAnalog_8.padres a_78824_130881# 0.12051f
C5239 a_84598_130577# a_83925_130212# 0.04364f
C5240 a_117805_39542# a_118465_39542# 0.02109f
C5241 a_188296_99070# a_188572_99046# 0.16781f
C5242 a_360458_80965# a_364458_80635# 0.03774f
C5243 a_141418_343292# user_project_wrapper_0.sg13g2_IOPadAnalog_19.padres 0.0512f
C5244 a_190297_328605# a_188920_324155# 0
C5245 a_191438_328605# a_191438_329719# 0.03071f
C5246 a_208939_326377# a_208367_327491# 0.01078f
C5247 a_208367_326377# a_208939_327491# 0.00811f
C5248 a_39542_76345# a_35542_76345# 0.03774f
C5249 a_58170_281249# a_58798_281249# 0.08391f
C5250 a_82118_239118# a_82846_240684# 0.31359f
C5251 a_82645_240231# a_82859_239842# 0.05039f
C5252 m1_81567_127343# a_79025_125231# 0
C5253 user_project_wrapper_0.VDD1 user_project_wrapper_0.analog_io[1] 19.8007f
C5254 TOP_ROILIFNEURON_0.MEM a_191438_326377# 0.121f
C5255 a_360458_305035# IOVDD3 0
C5256 a_209905_328605# a_208367_327491# 0
C5257 w_188806_323975# a_189672_324776# 0.35309f
C5258 w_207887_326203# a_206547_324106# 0.00557f
C5259 a_210621_328605# a_210621_327491# 0.04294f
C5260 a_190824_327491# a_192738_328013# 0
C5261 a_190501_327491# a_192354_327798# 0
C5262 a_190297_327491# a_191970_327798# 0
C5263 user_project_wrapper_0.IOVDD1 user_project_wrapper_0.sg13g2_IOPadOut4mA$1_1.sg13g2_GateLevelUpInv_noptap$1$1_0.pgate 15.518f
C5264 w_207887_327938# a_208367_326377# 0
C5265 a_210007_328605# a_208469_328605# 0
C5266 a_210417_328605# a_211921_329120# 0
C5267 a_210621_328605# a_211153_329332# 0.00193f
C5268 a_82840_127455# a_79025_136081# 0.00139f
C5269 a_210109_329719# a_209684_328605# 0
C5270 a_114505_39542# a_115165_39542# 0.02109f
C5271 a_209905_325785# a_208367_326377# 0
C5272 user_project_wrapper_0.VDD1 a_78220_132587# 0.01163f
C5273 a_82658_129203# a_82840_127455# 0.00154f
C5274 a_83492_127455# a_88274_127896# 0
C5275 a_83389_129203# a_83164_127820# 0
C5276 a_39542_305365# a_35542_305365# 0.03774f
C5277 TOP_ROILIFNEURON_0.MEM a_211921_329120# 0.00639f
C5278 analog_io[22] VDD3 19.8007f
C5279 w_207887_327938# a_210109_328605# 0.01287f
C5280 a_191196_92557# a_191196_90557# 0.04185f
C5281 a_187914_101343# user_project_wrapper_0.analog_io[13] 0
C5282 a_189729_99046# QDLL_TOP_0.CPIN 0.00243f
C5283 a_209684_329719# a_209480_328605# 0
C5284 a_304889_198885# a_301186_192011# 0.10216f
C5285 a_296731_208493# a_296626_197740# 0.58647f
C5286 a_188834_326341# a_191234_326377# 0
C5287 user_project_wrapper_0.IOVDD1 a_41476_258244# 58.9173f
C5288 user_project_wrapper_0.sg13g2_IOPadAnalog_17.padres a_190824_326377# 0
C5289 user_project_wrapper_0.VDD1 user_project_wrapper_0.IOVDD1 0.1586p
C5290 a_208939_325263# a_210621_327491# 0.00116f
C5291 user_project_wrapper_0.sg13g2_IOPadAnalog_19.padres a_189756_326377# 0.21115f
C5292 w_207883_330166# a_210417_329719# 0.22214f
C5293 w_207887_327938# a_210007_329719# 0
C5294 a_360372_302725# a_360372_302065# 0.02109f
C5295 a_211921_325785# a_211921_325570# 0.01056f
C5296 a_208939_329719# a_210109_329327# 0
C5297 a_208367_329719# a_209905_329327# 0
C5298 a_208469_327099# a_209684_326377# 0
C5299 a_82770_125209# a_84332_125209# 0
C5300 a_209905_327099# a_208939_326377# 0.00596f
C5301 user_project_wrapper_0.IOVDD2 a_303055_35456# 0.01555f
C5302 a_189921_330987# a_189756_329719# 0
C5303 a_188888_330987# a_189184_329719# 0
C5304 a_298435_35542# a_298435_35456# 0.03774f
C5305 a_360372_75685# a_360372_75025# 0.02109f
C5306 a_298765_360458# a_299095_360458# 0.37213f
C5307 a_189921_330987# user_project_wrapper_0.sg13g2_IOPadAnalog_17.padres 0
C5308 user_project_wrapper_0.sg13g2_IOPadAnalog_22.padres a_208469_325263# 0.00801f
C5309 a_190319_97955# a_190287_98223# 0.00976f
C5310 a_190218_98097# a_190490_98199# 0.01008f
C5311 a_208367_325263# a_208469_325263# 0.1023f
C5312 user_project_wrapper_0.VDD1 a_83164_127455# 0
C5313 user_project_wrapper_0.IOVDD1 user_project_wrapper_0.sg13g2_IOPadOut4mA$1_1.sg13g2_GateLevelUpInv_noptap$1$1_0.ngate 13.9496f
C5314 a_35456_300415# a_35456_299755# 0.02109f
C5315 a_188572_99046# QDLL_TOP_0.VDD 0.31147f
C5316 user_project_wrapper_0.IOVDD4 a_303385_360458# 0
C5317 a_360458_78655# IOVDD3 0
C5318 user_project_wrapper_0.sg13g2_IOPadIn$1_2.p2c a_191462_324119# 0.01709f
C5319 a_210137_330851# a_210007_329719# 0.00339f
C5320 a_78325_360372# a_78655_360458# 0.03774f
C5321 a_78824_137391# a_79038_136536# 0
C5322 a_79025_137844# a_78219_135283# 0.25167f
C5323 a_79025_138251# a_79025_136081# 2.44287f
C5324 a_207985_330987# a_208103_324155# 0
C5325 user_project_wrapper_0.sg13g2_IOPadAnalog_15.padres a_56308_223018# 0.0512f
C5326 a_78220_128592# a_78220_130691# 0.00732f
C5327 a_191970_325570# a_189672_324776# 0
C5328 a_210007_325263# a_209480_326377# 0
C5329 a_209480_325263# a_210007_326377# 0
C5330 user_project_wrapper_0.sg13g2_IOPadAnalog_22.padres a_208367_329719# 0.21528f
C5331 a_208939_325263# a_208017_326341# 0.45505f
C5332 a_208367_325263# a_208367_329719# 0.34198f
C5333 a_208017_327918# a_208939_329719# 0.03192f
C5334 a_343292_223018# VDD3 0
C5335 user_project_wrapper_0.sg13g2_IOPadAnalog_0.padres a_343292_121018# 0.0512f
C5336 a_210109_325263# a_208855_324776# 0
C5337 user_project_wrapper_0.sg13g2_IOPadAnalog_21.padres a_208017_327918# 0.02307f
C5338 user_project_wrapper_0.sg13g2_IOPadAnalog_9.padres a_79038_130492# 0.16101f
C5339 user_project_wrapper_0.VDD1 user_project_wrapper_0.analog_io[5] 19.8007f
C5340 a_364458_74035# IOVDD3 0.01409f
C5341 a_301735_35542# a_302065_35542# 0.37213f
C5342 a_192738_330241# a_192738_330026# 0.01056f
C5343 a_200137_343292# user_project_wrapper_0.sg13g2_IOPadIn$1_2.sg13g2_LevelDown_noptap$1_0.sg13g2_SecondaryProtection$1$1_0.core 0.0512f
C5344 user_project_wrapper_0.sg13g2_IOPadAnalog_17.padres a_188834_326341# 0.0213f
C5345 a_188834_327918# a_190501_329719# 0
C5346 a_188834_326341# a_189756_329719# 0.50671f
C5347 a_189756_325263# a_189184_329719# 0.09046f
C5348 a_189756_326377# a_189184_326377# 0.8695f
C5349 user_project_wrapper_0.IOVDD2 a_299095_35542# 0
C5350 a_161818_343292# user_project_wrapper_0.sg13g2_IOPadAnalog_17.padres 0.0512f
C5351 user_project_wrapper_0.sg13g2_IOPadAnalog_8.padres a_79025_133504# 0.01276f
C5352 user_project_wrapper_0.sg13g2_IOPadAnalog_19.padres a_187018_328627# 0.14027f
C5353 a_78220_128592# a_78220_130291# 0.01772f
C5354 a_117145_39542# a_117805_39542# 0.02109f
C5355 user_project_wrapper_0.IOVDD1 a_35542_73705# 0
C5356 user_project_wrapper_0.sg13g2_IOPadIn$1_0.p2c a_79025_131741# 0.11804f
C5357 user_project_wrapper_0.IOVDD4 a_80965_360372# 0.01881f
C5358 user_project_wrapper_0.sg13g2_IOPadAnalog_6.padres a_263818_56308# 0.0512f
C5359 a_208367_325263# a_209041_326377# 0.00236f
C5360 a_208017_327918# a_208469_326377# 0.0193f
C5361 user_project_wrapper_0.sg13g2_IOPadVdd_2.sg13g2_RCClampInverter_noptap_0.out user_project_wrapper_0.VDD1 0.10089p
C5362 a_360458_76675# VDD3 0
C5363 a_211153_327586# a_210621_327491# 0.00193f
C5364 a_190287_98223# QDLL_TOP_0.VDD 0.01446f
C5365 a_190954_330851# a_190824_329719# 0.00339f
C5366 user_project_wrapper_0.sg13g2_IOPadIn$1_2.p2c a_208171_324119# 0.0214f
C5367 a_39542_77005# a_35542_77005# 0.03774f
C5368 a_82846_241091# a_82859_239842# 0.01043f
C5369 a_208367_327491# a_210621_327491# 0.00152f
C5370 a_209684_327491# a_210109_328013# 0.00499f
C5371 TOP_ROILIFNEURON_0.MEM a_190501_326377# 0
C5372 a_85257_125209# a_86507_127725# 0
C5373 a_82746_130212# user_project_wrapper_0.sg13g2_IOPadIn$1_0.p2c 0.01016f
C5374 a_190501_327491# a_191438_327491# 0.00396f
C5375 a_190297_327491# a_190926_328013# 0.01192f
C5376 a_190824_327491# a_190722_328013# 0.20881f
C5377 w_188704_326203# a_191234_326377# 0.22627f
C5378 a_360372_298765# a_360372_298105# 0.02109f
C5379 a_79038_128322# a_79025_136081# 0
C5380 a_314793_197200# a_315347_192734# 0.0179f
C5381 a_209480_328605# a_210621_328605# 0.00342f
C5382 a_210007_328605# a_210109_329327# 0.10235f
C5383 a_192745_324776# a_189672_324776# 0.42043f
C5384 a_208103_324155# a_208367_328605# 0.05728f
C5385 a_311846_195517# user_project_wrapper_0.sg13g2_IOPadAnalog_29.padres 2.86201f
C5386 user_project_wrapper_0.VDD1 a_78219_134883# 0.00986f
C5387 a_84598_130577# a_86594_127531# 0
C5388 a_87434_129426# a_87434_127896# 0
C5389 user_project_wrapper_0.VDD1 a_83492_127455# 0.89486f
C5390 user_project_wrapper_0.sg13g2_IOPadIOVdd_2.sg13g2_RCClampResistor_0.p2 user_project_wrapper_0.IOVDD4 0.10479p
C5391 w_207887_327938# a_211153_328225# 0.0018f
C5392 a_78221_125094# a_79025_125231# 0
C5393 a_79038_123516# user_project_wrapper_0.sg13g2_IOPadAnalog_8.padres 0.01071f
C5394 a_190082_92557# a_190082_90557# 0.04185f
C5395 a_189184_327491# a_189756_328605# 0.03209f
C5396 a_57810_180219# user_project_wrapper_0.sg13g2_IOPadOut4mA$1_0.sg13g2_GateLevelUpInv_noptap$1$1_0.pgate 0.24368f
C5397 a_188834_327918# a_187364_324106# 0.00188f
C5398 a_189184_325263# a_189756_326377# 0.0304f
C5399 TOP_ROILIFNEURON_0.MEM a_211537_325785# 0.01146f
C5400 a_83492_127455# user_project_wrapper_0.sg13g2_IOPadIn$1_1.p2c 0.00394f
C5401 a_87851_125174# a_87571_125210# 0
C5402 a_87627_124843# a_87775_125210# 0.02262f
C5403 user_project_wrapper_0.sg13g2_IOPadAnalog_22.padres a_210007_327491# 0
C5404 a_87468_125419# a_88393_125210# 0.07815f
C5405 a_208017_327918# a_209480_327491# 0
C5406 a_208939_325263# a_209684_327491# 0.01989f
C5407 a_208939_329719# a_208939_327491# 0
C5408 a_208017_326341# a_208367_327491# 0.03066f
C5409 a_360372_303385# a_360372_302725# 0.02109f
C5410 user_project_wrapper_0.sg13g2_IOPadAnalog_21.padres a_208939_327491# 0.2146f
C5411 a_211537_325997# a_211537_325785# 0.01085f
C5412 a_210621_325263# a_211153_325570# 0.00324f
C5413 a_190824_328605# a_189184_327491# 0
C5414 a_189184_328605# a_190824_327491# 0
C5415 a_208939_325263# a_209480_328605# 0.02206f
C5416 a_208017_327918# a_210007_328605# 0
C5417 a_85435_125173# a_84332_125209# 0.04786f
C5418 a_191970_326465# a_191438_326377# 0.002f
C5419 a_88291_125210# a_87434_127896# 0
C5420 user_project_wrapper_0.IOVDD2 a_301735_35456# 0.01567f
C5421 TOP_ROILIFNEURON_0.MEM user_project_wrapper_0.sg13g2_IOPadAnalog_22.padres 0.00622f
C5422 a_88393_125210# user_project_wrapper_0.VDD1 0.14154f
C5423 a_208171_324119# a_208367_326377# 0.00275f
C5424 a_208792_324119# a_206547_324106# 0.25303f
C5425 user_project_wrapper_0.sg13g2_IOPadAnalog_22.padres w_207989_323975# 0
C5426 w_207887_326203# a_208939_325263# 0.24283f
C5427 w_207883_330166# a_208367_329719# 0.23499f
C5428 w_207887_327938# a_208939_329719# 0.06272f
C5429 a_360372_76345# a_360372_75685# 0.02109f
C5430 w_207989_323975# a_208367_325263# 0.00143f
C5431 a_297775_35542# a_297775_35456# 0.03774f
C5432 a_298105_360458# a_298435_360458# 0.37213f
C5433 user_project_wrapper_0.sg13g2_IOPadAnalog_21.padres w_207887_327938# 0.02378f
C5434 a_208939_325263# a_210621_325263# 0.00116f
C5435 user_project_wrapper_0.IOVDD1 a_35542_306025# 0
C5436 user_project_wrapper_0.VDD1 a_82527_127455# 0.30755f
C5437 w_188806_323975# a_189756_325263# 0.00284f
C5438 a_258244_355624# user_project_wrapper_0.IOVDD4 58.9173f
C5439 user_project_wrapper_0.IOVDD4 a_302065_360458# 0
C5440 a_35456_301075# a_35456_300415# 0.02109f
C5441 w_188704_326203# user_project_wrapper_0.sg13g2_IOPadAnalog_17.padres 0.02796f
C5442 a_360458_79975# IOVDD3 0
C5443 w_188700_330166# user_project_wrapper_0.sg13g2_IOPadAnalog_19.padres 0.00127f
C5444 user_project_wrapper_0.sg13g2_IOPadVdd_0.sg13g2_RCClampInverter_noptap_0.out IOVDD3 49.206f
C5445 user_project_wrapper_0.sg13g2_IOPadIn$1_2.p2c a_188988_324119# 0.00692f
C5446 a_77665_360372# a_77995_360458# 0.03774f
C5447 a_78218_138195# a_79025_138251# 0
C5448 TOP_ROILIFNEURON_0.MEM a_211921_327104# 0.00497f
C5449 a_192738_325997# a_189672_324776# 0
C5450 a_189858_325263# a_187364_324106# 0.00191f
C5451 a_74695_364458# a_75355_364458# 0.02109f
C5452 a_86594_129426# a_88274_129426# 0.05732f
C5453 a_84598_130577# a_86507_127725# 0.35409f
C5454 a_211537_325785# a_208855_324776# 0
C5455 user_project_wrapper_0.sg13g2_IOPadAnalog_21.padres user_project_wrapper_0.analog_io[35] 0.01217f
C5456 a_190319_102855# a_190287_102497# 0.00976f
C5457 user_project_wrapper_0.sg13g2_IOPadAnalog_9.padres a_79038_132196# 0
C5458 a_209104_330851# a_208367_329719# 0.00511f
C5459 a_209869_324119# a_209905_325263# 0
C5460 a_191438_329719# a_191970_330026# 0.00324f
C5461 a_301075_35542# a_301405_35542# 0.37213f
C5462 user_project_wrapper_0.VDD1 a_82645_240231# 2.66954f
C5463 a_186202_326221# a_188834_327918# 0
C5464 a_187018_328627# a_189184_325263# 0
C5465 user_project_wrapper_0.sg13g2_IOPadAnalog_8.padres a_78824_135221# 0.12051f
C5466 user_project_wrapper_0.IOVDD2 a_297775_35542# 0.06232f
C5467 m1_82112_127957# a_79025_136081# 0
C5468 a_79025_129164# user_project_wrapper_0.sg13g2_IOPadAnalog_8.padres 0.01276f
C5469 user_project_wrapper_0.IOVDD1 a_35542_75025# 0
C5470 a_208367_325263# a_208855_324776# 0.00104f
C5471 a_208939_325263# a_210109_327099# 0
C5472 a_79025_127401# user_project_wrapper_0.sg13g2_IOPadAnalog_9.padres 0.00688f
C5473 user_project_wrapper_0.sg13g2_IOPadAnalog_21.padres a_209041_327099# 0.00916f
C5474 a_191234_328605# a_191234_329719# 0.03297f
C5475 a_360458_77995# VDD3 0
C5476 a_209905_327491# a_210007_327491# 0.1023f
C5477 a_210109_327491# a_209480_327491# 0.01814f
C5478 a_211153_327586# a_209684_327491# 0
C5479 a_190501_326377# a_190926_327491# 0
C5480 user_project_wrapper_0.VDD2 a_121765_35542# 0
C5481 a_209480_325263# a_209905_325263# 0.00962f
C5482 a_209684_325263# a_210109_325263# 0.05288f
C5483 user_project_wrapper_0.IOVDD1 a_35542_304045# 0
C5484 a_85591_241748# a_85591_241383# 0.11299f
C5485 a_82846_241091# a_85989_241748# 0.00111f
C5486 a_86046_241645# a_87832_241383# 0
C5487 a_85989_241383# a_86407_241748# 0.00668f
C5488 user_project_wrapper_0.sg13g2_IOPadIn$1_1.p2c a_82645_240231# 0
C5489 a_39542_77665# a_35542_77665# 0.03774f
C5490 a_355624_176644# a_355784_184861# 0.01916f
C5491 a_208367_327491# a_209684_327491# 0.73864f
C5492 a_208939_327491# a_209480_327491# 0.21292f
C5493 a_35542_81625# user_project_wrapper_0.sg13g2_IOPadVdd_2.sg13g2_RCClampResistor_0.p2 0.03777f
C5494 a_209480_328605# a_208367_327491# 0.00158f
C5495 a_360372_299425# a_360372_298765# 0.02109f
C5496 user_project_wrapper_0.sg13g2_IOPadAnalog_22.padres a_211170_331343# 0.00147f
C5497 a_364458_73375# VDD3 0.00178f
C5498 a_209104_331343# a_208939_325263# 0
C5499 a_210621_326377# a_211153_326892# 0.00324f
C5500 user_project_wrapper_0.VDD1 a_79025_137844# 1.75746f
C5501 a_190047_324119# a_189672_324776# 0.32537f
C5502 user_project_wrapper_0.sg13g2_IOPadOut4mA$1_0.c2p a_58798_179249# 1.43646f
C5503 TOP_ROILIFNEURON_0.MEM a_192738_327586# 0.00497f
C5504 user_project_wrapper_0.sg13g2_IOPadAnalog_21.padres a_207638_331343# 0
C5505 a_296731_189665# a_309917_199879# 0.13988f
C5506 a_208103_324155# a_208469_329719# 0
C5507 user_project_wrapper_0.sg13g2_IOPadAnalog_16.padres user_project_wrapper_0.analog_io[27] 0.33115f
C5508 a_84598_130577# a_90579_127530# 0.11659f
C5509 a_296731_208493# a_314793_198352# 0.17986f
C5510 user_project_wrapper_0.VDD1 a_89114_129426# 0.50578f
C5511 w_207887_326203# a_208367_327491# 0.06221f
C5512 w_207887_327938# a_209480_327491# 0.08768f
C5513 user_project_wrapper_0.sg13g2_IOPadIn$1_2.p2c a_190501_325263# 0
C5514 user_project_wrapper_0.IOVDD1 a_39542_298765# 0.02181f
C5515 w_207887_327938# a_210007_328605# 0.11541f
C5516 a_188966_92557# a_188966_90557# 0.04185f
C5517 a_210937_330987# a_211084_330987# 0.17314f
C5518 a_191901_330987# a_191987_330987# 0.01578f
C5519 TOP_ROILIFNEURON_0.MEM w_207883_330166# 0.01187f
C5520 user_project_wrapper_0.sg13g2_IOPadIOVdd_2.sg13g2_RCClampResistor_0.p2 user_project_wrapper_0.sg13g2_IOPadIOVdd_2.sg13g2_Clamp_N43N43D4R_0.gate 22.6705f
C5521 a_190824_327491# a_188920_324155# 0
C5522 w_207887_326203# a_210109_325785# 0.01287f
C5523 a_89114_129426# user_project_wrapper_0.sg13g2_IOPadIn$1_1.p2c 0
C5524 a_78221_125094# a_78220_123062# 0.00716f
C5525 a_85052_125418# a_85977_125209# 0.07815f
C5526 a_85435_125173# a_85155_125209# 0
C5527 a_85211_124842# a_85359_125209# 0.02262f
C5528 a_87851_125174# a_87673_125210# 0.19246f
C5529 a_87627_124843# a_88291_125210# 0.04164f
C5530 user_project_wrapper_0.sg13g2_IOPadIn$1_0.p2c a_84332_125209# 0.17099f
C5531 a_78985_360372# user_project_wrapper_0.IOVDD4 0.01881f
C5532 a_360372_304045# a_360372_303385# 0.02109f
C5533 user_project_wrapper_0.sg13g2_IOPadAnalog_17.padres a_189286_327491# 0.01007f
C5534 a_189756_325263# a_190722_327491# 0.00101f
C5535 a_188834_326341# a_189858_327491# 0.00271f
C5536 a_210417_326377# a_209480_326377# 0.02229f
C5537 a_192354_326677# a_190824_326377# 0
C5538 a_83050_125173# a_82527_127455# 0
C5539 a_210137_330851# a_210007_328605# 0
C5540 a_208871_330987# user_project_wrapper_0.sg13g2_IOPadAnalog_22.padres 0
C5541 user_project_wrapper_0.IOVDD2 a_300415_35456# 0.01555f
C5542 a_208071_331163# a_208017_327918# 0
C5543 a_82770_125209# user_project_wrapper_0.VDD1 0.14984f
C5544 user_project_wrapper_0.sg13g2_IOPadAnalog_8.padres a_85591_241383# 0
C5545 a_360372_77005# a_360372_76345# 0.02109f
C5546 a_121765_35542# a_122095_35542# 0.37213f
C5547 w_188704_327938# a_192354_328693# 0.0018f
C5548 a_210621_326377# a_208939_327491# 0
C5549 a_209905_327099# a_209684_327491# 0
C5550 w_188704_327938# a_187018_328627# 0
C5551 a_156244_355624# user_project_wrapper_0.IOVDD4 58.9173f
C5552 w_188700_330166# a_189184_325263# 0.07448f
C5553 user_project_wrapper_0.VDD1 a_78220_128106# 0.55406f
C5554 user_project_wrapper_0.IOVDD4 a_300745_360458# 0
C5555 a_35456_301735# a_35456_301075# 0.02109f
C5556 a_360458_81295# IOVDD3 0
C5557 a_313884_211353# analog_io[23] 5.40271f
C5558 user_project_wrapper_0.sg13g2_IOPadAnalog_6.padres a_189395_99046# 0
C5559 a_77005_360372# a_77335_360458# 0.03774f
C5560 user_project_wrapper_0.IOVDD2 a_246061_41636# 1.92793f
C5561 user_project_wrapper_0.sg13g2_IOPadAnalog_23.padres user_project_wrapper_0.analog_io[35] 0.33115f
C5562 a_74035_364458# a_74695_364458# 0.02109f
C5563 TOP_ROILIFNEURON_0.MEM a_210307_324119# 0
C5564 a_191234_325263# a_189672_324776# 0.02406f
C5565 w_207887_326203# a_209905_327099# 0
C5566 a_78220_128592# a_78824_128711# 0.00892f
C5567 a_304705_360458# a_304705_360372# 0.03774f
C5568 w_207887_326203# a_210983_324119# 0
C5569 a_191417_110495# a_191417_108495# 0.04209f
C5570 w_207989_323975# a_210307_324119# 0.23842f
C5571 user_project_wrapper_0.sg13g2_IOPadAnalog_9.padres a_78219_134797# 0.16775f
C5572 a_185968_98275# QDLL_TOP_0.VOUT 0.01219f
C5573 a_210983_324119# a_210621_325263# 0.00336f
C5574 a_300415_35542# a_300745_35542# 0.37213f
C5575 user_project_wrapper_0.VDD1 a_82846_241091# 1.58603f
C5576 user_project_wrapper_0.VDD2 user_project_wrapper_0.analog_io[12] 19.8007f
C5577 a_190297_329719# a_190722_329719# 0.00962f
C5578 user_project_wrapper_0.sg13g2_IOPadIOVdd_3.sg13g2_RCClampResistor_0.p2 user_project_wrapper_0.sg13g2_IOPadIOVdd_3.sg13g2_Clamp_N43N43D4R_0.gate 22.6705f
C5579 a_208367_328605# a_208367_326377# 0
C5580 user_project_wrapper_0.sg13g2_IOPadAnalog_17.padres a_189921_330851# 0
C5581 a_188888_330851# a_189184_329719# 0.00338f
C5582 a_189921_330851# a_189756_329719# 0.00656f
C5583 a_211153_327798# a_211153_327586# 0.01085f
C5584 user_project_wrapper_0.sg13g2_IOPadAnalog_8.padres a_79025_138251# 0.0787f
C5585 user_project_wrapper_0.IOVDD2 a_121105_35542# 0
C5586 m1_82116_130103# a_79025_138251# 0
C5587 TOP_ROILIFNEURON_0.MEM a_192995_331343# 0.00415f
C5588 a_188802_330987# a_189921_331343# 0.00565f
C5589 a_210137_331163# a_210137_331343# 0.12339f
C5590 a_360372_305365# user_project_wrapper_0.sg13g2_IOPadIOVdd_3.sg13g2_RCClampResistor_0.p2 0.02109f
C5591 a_79025_129571# m1_81567_127343# 0
C5592 user_project_wrapper_0.IOVDD1 a_35542_76345# 0
C5593 TOP_ROILIFNEURON_0.MEM a_210417_325263# 0.00568f
C5594 a_75355_360458# user_project_wrapper_0.IOVDD4 0
C5595 a_360458_79315# VDD3 0
C5596 a_83079_128838# user_project_wrapper_0.sg13g2_IOPadIn$1_0.p2c 0.01054f
C5597 a_35456_79975# a_35456_79315# 0.02109f
C5598 user_project_wrapper_0.sg13g2_IOPadAnalog_1.padres analog_io[19] 0.33115f
C5599 a_211153_328013# a_210007_327491# 0
C5600 w_207989_323975# a_210417_325263# 0
C5601 user_project_wrapper_0.VDD2 a_120445_35542# 0
C5602 a_208367_325263# a_209638_324119# 0.0018f
C5603 a_208939_325263# a_208792_324119# 0.0033f
C5604 a_208367_328605# a_210109_328605# 0.02636f
C5605 a_209684_328605# a_209905_328605# 0.05425f
C5606 a_191970_325358# a_191800_324119# 0
C5607 user_project_wrapper_0.IOVDD1 a_35542_305365# 0
C5608 a_39542_78325# a_35542_78325# 0.03774f
C5609 user_project_wrapper_0.sg13g2_IOPadIn$1_1.p2c a_82846_241091# 0.29168f
C5610 a_85591_241748# a_86046_241645# 0.05352f
C5611 QDLL_TOP_0.VOUT user_project_wrapper_0.VDD2 19.8008f
C5612 TOP_ROILIFNEURON_0.MEM a_211153_328013# 0.00105f
C5613 a_58170_179951# user_project_wrapper_0.sg13g2_IOPadOut4mA$1_0.sg13g2_GateLevelUpInv_noptap$1$1_0.ngate 0.61937f
C5614 a_191124_324119# a_187364_324106# 0
C5615 a_190455_324119# a_190501_326377# 0
C5616 a_78221_124694# user_project_wrapper_0.sg13g2_IOPadAnalog_9.padres 0.00862f
C5617 a_210645_324119# a_210621_326377# 0
C5618 a_210307_324119# a_208855_324776# 0.22365f
C5619 a_208367_325263# a_209684_325263# 0.76326f
C5620 a_296732_197880# a_296625_189595# 12.4977f
C5621 TOP_ROILIFNEURON_0.MEM a_192354_327798# 0.01055f
C5622 user_project_wrapper_0.sg13g2_IOPadAnalog_22.padres a_209684_325263# 0
C5623 a_209480_329719# a_209684_328605# 0
C5624 a_307232_196607# a_309917_199879# 3.27523f
C5625 a_84598_130577# a_86594_127896# 0.00987f
C5626 a_88274_129426# a_88274_129061# 0.09189f
C5627 a_87434_129426# a_87434_129061# 0.09399f
C5628 a_210983_324119# a_211321_324119# 0.18349f
C5629 a_210645_324119# a_211928_324776# 0
C5630 a_58170_179951# a_58798_179951# 0.08391f
C5631 a_75355_364458# a_75685_360458# 0.03774f
C5632 a_75025_360372# a_75685_360372# 0.02109f
C5633 user_project_wrapper_0.IOVDD1 a_39542_300085# 0.02081f
C5634 a_187852_92557# a_187852_90557# 0.04185f
C5635 a_186731_92558# a_188966_90557# 0
C5636 a_190218_102763# user_project_wrapper_0.analog_io[13] 0.00156f
C5637 a_189835_330987# a_189921_330987# 0.01534f
C5638 a_190721_331163# a_188802_330987# 0.0384f
C5639 a_85155_125209# user_project_wrapper_0.sg13g2_IOPadIn$1_0.p2c 0
C5640 user_project_wrapper_0.sg13g2_IOPadAnalog_4.padres user_project_wrapper_0.analog_io[14] 0.33115f
C5641 a_209018_330987# a_209104_331163# 0.01534f
C5642 a_191901_330987# TOP_ROILIFNEURON_0.MEM 0.00225f
C5643 a_79038_128322# user_project_wrapper_0.sg13g2_IOPadAnalog_8.padres 0.07195f
C5644 a_210417_325263# a_208855_324776# 0.02406f
C5645 user_project_wrapper_0.VDD1 m1_83011_126179# 0.08843f
C5646 TOP_ROILIFNEURON_0.MEM a_191124_324119# 0
C5647 a_85211_124842# a_87627_124843# 0.16064f
C5648 a_85257_125209# a_85875_125209# 0.02258f
C5649 a_78824_126541# a_78824_124371# 0
C5650 a_82826_124842# a_82974_125209# 0.02262f
C5651 a_83050_125173# a_82770_125209# 0
C5652 a_82667_125418# a_83592_125209# 0.07815f
C5653 w_188806_323975# a_191462_324119# 0.23826f
C5654 w_188704_326203# a_192138_324119# 0
C5655 a_77665_360372# user_project_wrapper_0.IOVDD4 0.01881f
C5656 a_360372_304705# a_360372_304045# 0.02109f
C5657 a_192354_326892# a_190297_326377# 0
C5658 a_191970_326892# a_190824_326377# 0
C5659 a_189286_326377# a_189184_326377# 0.23459f
C5660 a_189858_326377# a_189756_326377# 0.22095f
C5661 a_305695_35542# a_306025_35542# 0.37213f
C5662 a_208103_324155# a_205385_326221# 0
C5663 a_85435_125173# user_project_wrapper_0.VDD1 0.25385f
C5664 TOP_ROILIFNEURON_0.MEM a_191970_329332# 0.00105f
C5665 QDLL_TOP_0.VDD a_270178_100118# 0.55905f
C5666 a_135844_369296# a_144061_369456# 0.01778f
C5667 a_121105_35542# a_121435_35542# 0.37213f
C5668 a_188888_331163# a_189184_329719# 0
C5669 a_189688_330987# a_189756_329719# 0
C5670 a_189921_331163# a_189756_325263# 0
C5671 w_188704_327938# a_189286_328605# 0.01323f
C5672 a_360372_77665# a_360372_77005# 0.02109f
C5673 a_212178_331163# a_212178_330987# 0.03126f
C5674 a_191970_325785# a_191970_325570# 0.01056f
C5675 a_189688_330987# user_project_wrapper_0.sg13g2_IOPadAnalog_17.padres 0
C5676 a_82859_242012# user_project_wrapper_0.sg13g2_IOPadAnalog_15.padres 0.1697f
C5677 a_93298_129062# a_93400_129062# 0.0757f
C5678 user_project_wrapper_0.VDD2 a_116485_35542# 0
C5679 user_project_wrapper_0.VDD1 a_92512_129061# 0
C5680 a_35456_302395# a_35456_301735# 0.02109f
C5681 a_189184_325263# a_190686_324119# 0
C5682 a_189756_325263# a_190047_324119# 0.00768f
C5683 user_project_wrapper_0.sg13g2_IOPadAnalog_17.padres a_189396_324119# 0.00132f
C5684 a_83796_129203# a_83925_130212# 0.08565f
C5685 a_189184_329719# a_189756_328605# 0.01087f
C5686 a_369296_176644# a_369456_184861# 0.01778f
C5687 user_project_wrapper_0.IOVDD2 a_164461_41636# 1.92793f
C5688 a_76345_360372# a_76675_360458# 0.03774f
C5689 a_82645_240231# a_82645_242401# 0
C5690 a_73375_364458# a_74035_364458# 0.02109f
C5691 TOP_ROILIFNEURON_0.MEM a_211921_325358# 0.00436f
C5692 a_190824_325263# a_190824_326377# 0.02415f
C5693 a_189858_325785# a_189184_326377# 0.00113f
C5694 a_355624_135844# a_355784_144061# 0.01916f
C5695 a_191438_328605# a_192354_328693# 0
C5696 a_190304_110495# a_190304_108495# 0.04209f
C5697 a_191970_329120# a_191970_328905# 0.01056f
C5698 w_207989_323975# a_211921_325358# 0
C5699 a_304045_360458# a_304045_360372# 0.03774f
C5700 w_207887_326203# a_208579_324119# 0
C5701 user_project_wrapper_0.analog_io[15] a_190490_102497# 0.03478f
C5702 user_project_wrapper_0.sg13g2_IOPadAnalog_9.padres a_79038_137002# 0.16101f
C5703 a_92512_129061# user_project_wrapper_0.sg13g2_IOPadIn$1_1.p2c 0
C5704 a_189756_327491# a_189286_328013# 0
C5705 a_189184_327491# a_191234_327491# 0.01152f
C5706 a_189756_325263# a_189858_329327# 0
C5707 a_190501_329719# a_190297_328605# 0
C5708 a_189756_329719# a_191234_328605# 0
C5709 a_189184_329719# a_190824_328605# 0
C5710 a_207985_330987# a_208939_329719# 0
C5711 a_209104_330987# a_208939_325263# 0
C5712 a_190501_327491# a_190824_327491# 0.35443f
C5713 a_190824_329719# a_191970_330241# 0
C5714 a_192309_92557# user_project_wrapper_0.analog_io[13] 0.00542f
C5715 a_299755_35542# a_300085_35542# 0.37213f
C5716 user_project_wrapper_0.sg13g2_IOPadAnalog_21.padres a_207985_330987# 0
C5717 user_project_wrapper_0.sg13g2_IOPadAnalog_19.padres a_189184_328605# 0.03078f
C5718 user_project_wrapper_0.analog_io[32] a_202114_326125# 18.2614f
C5719 a_211537_328013# a_211537_327798# 0.01056f
C5720 user_project_wrapper_0.IOVDD2 a_119785_35542# 0
C5721 VDD3 analog_io[25] 19.8007f
C5722 user_project_wrapper_0.IOVDD1 a_58170_281951# 0.28809f
C5723 user_project_wrapper_0.IOVDD1 a_35542_77665# 0
C5724 a_74035_360458# user_project_wrapper_0.IOVDD4 0
C5725 a_84598_130212# user_project_wrapper_0.sg13g2_IOPadIn$1_0.p2c 0
C5726 user_project_wrapper_0.VDD2 a_119125_35542# -0
C5727 a_35456_80635# a_35456_79975# 0.02109f
C5728 w_188704_326203# a_192354_325997# 0.0018f
C5729 a_189184_325263# a_189286_326377# 0.00236f
C5730 a_209684_328605# a_211153_329332# 0
C5731 a_39542_78985# a_35542_78985# 0.03774f
C5732 user_project_wrapper_0.sg13g2_IOPadAnalog_25.padres analog_io[23] 0.33115f
C5733 a_191970_327798# a_191970_327586# 0.01085f
C5734 a_78824_126541# a_78824_128711# 0
C5735 a_35542_298105# a_35542_297775# 0.37213f
C5736 user_project_wrapper_0.sg13g2_IOPadAnalog_14.padres a_82859_239842# 0
C5737 user_project_wrapper_0.analog_io[10] a_135844_29676# 9.69836f
C5738 user_project_wrapper_0.sg13g2_IOPadAnalog_6.padres QDLL_TOP_0.CPIN 0.00644f
C5739 a_313884_185173# analog_io[20] 5.40261f
C5740 a_311189_185546# a_311108_179669# 1.46297f
C5741 a_211921_325358# a_208855_324776# 0
C5742 user_project_wrapper_0.VDD1 a_35542_74035# 0
C5743 a_301186_192011# a_311846_195517# 0
C5744 a_209684_329719# a_209905_329719# 0.01614f
C5745 TOP_ROILIFNEURON_0.MEM a_191438_327491# 0.121f
C5746 a_209480_329719# a_209041_329719# 0
C5747 a_210417_329719# a_211921_330026# 0
C5748 a_210621_329719# a_211537_330453# 0
C5749 a_304995_198817# a_304889_199957# 1.5837f
C5750 a_278644_29676# user_project_wrapper_0.IOVDD2 0.16358f
C5751 a_307232_196607# a_304196_200821# 0
C5752 a_209869_324119# a_209940_324686# 0.52811f
C5753 a_188834_327918# a_189286_325785# 0.01792f
C5754 a_189184_325263# a_189858_325785# 0.01504f
C5755 a_189756_325263# a_191234_325263# 0.00252f
C5756 user_project_wrapper_0.IOVDD1 a_39542_301405# 0.02119f
C5757 user_project_wrapper_0.sg13g2_IOPadAnalog_17.padres a_190297_325263# 0
C5758 a_83050_125173# m1_83011_126179# 0
C5759 a_186731_92558# a_186731_90558# 0.055f
C5760 a_208367_329719# a_208939_328605# 0.01087f
C5761 a_208939_329719# a_208367_328605# 0.00803f
C5762 a_208017_326341# a_209684_328605# 0
C5763 user_project_wrapper_0.sg13g2_IOPadAnalog_21.padres a_208367_328605# 0.03078f
C5764 a_189184_328605# a_189184_326377# 0
C5765 a_79025_131741# a_79025_131334# 0
C5766 analog_io[20] a_343292_161818# 0.10599f
C5767 user_project_wrapper_0.sg13g2_IOPadIn$1_0.p2c a_82658_128838# 0
C5768 a_209480_325263# a_209940_324686# 0
C5769 a_83490_125209# a_85052_125418# 0
C5770 a_82826_124842# a_85257_125209# 0
C5771 user_project_wrapper_0.sg13g2_IOPadOut4mA$1_0.sg13g2_GateLevelUpInv_noptap$1$1_0.ngate a_58170_179249# 0.00721f
C5772 TOP_ROILIFNEURON_0.MEM a_192738_329814# 0.00497f
C5773 w_188704_326203# a_189609_324119# 0
C5774 w_188806_323975# a_188988_324119# 0.20833f
C5775 a_191970_328693# a_191438_327491# 0
C5776 a_76345_360372# user_project_wrapper_0.IOVDD4 0.01881f
C5777 a_189395_101343# QDLL_TOP_0.VDD 0.59508f
C5778 user_project_wrapper_0.VDD1 user_project_wrapper_0.sg13g2_IOPadIn$1_0.p2c 4.21737f
C5779 a_360372_305365# a_360372_304705# 0.02109f
C5780 a_191800_324119# a_192138_324119# 0.18349f
C5781 a_191462_324119# a_192745_324776# 0
C5782 user_project_wrapper_0.VDD1 user_project_wrapper_0.ui_PAD[2] 0.06132f
C5783 a_208367_328605# a_208469_326377# 0
C5784 a_208939_328605# a_209041_326377# 0
C5785 a_190319_97955# user_project_wrapper_0.analog_io[13] 0.00378f
C5786 a_79025_126994# a_78220_128106# 0
C5787 a_78824_126541# a_79038_127856# 0
C5788 TOP_ROILIFNEURON_0.MEM a_190297_328605# 0
C5789 a_83398_130212# a_79025_131741# 0.00244f
C5790 user_project_wrapper_0.IOVDD2 a_115825_35542# 0
C5791 a_79038_125686# user_project_wrapper_0.VDD1 0.09619f
C5792 a_120445_35542# a_120775_35542# 0.37213f
C5793 a_93204_129062# a_87105_130835# 0.13981f
C5794 a_360372_78325# a_360372_77665# 0.02109f
C5795 w_188704_327938# a_190926_329327# 0
C5796 a_210137_331163# a_210051_330987# 0.02034f
C5797 a_210417_326377# a_210417_327491# 0.03297f
C5798 a_190501_325263# a_192354_325358# 0
C5799 a_190297_325263# a_191970_325358# 0
C5800 a_190824_325263# a_190926_325263# 0.1023f
C5801 a_191438_325263# a_191970_325570# 0.00324f
C5802 a_209480_325263# a_210007_325263# 0.20188f
C5803 a_192354_325997# a_192354_325785# 0.01085f
C5804 a_209684_325263# a_210417_325263# 0.00662f
C5805 user_project_wrapper_0.VDD2 a_115165_35542# 0
C5806 a_35456_303055# a_35456_302395# 0.02109f
C5807 user_project_wrapper_0.sg13g2_IOPadAnalog_17.padres a_189286_329719# 0.01013f
C5808 a_79025_127401# a_83796_129203# 0.00222f
C5809 a_190501_329719# a_192354_330026# 0
C5810 a_189756_325263# a_190722_329719# 0.00101f
C5811 a_188834_326341# a_189858_329719# 0.00271f
C5812 a_189756_329719# a_189286_329719# 0
C5813 user_project_wrapper_0.sg13g2_IOPadIn$1_2.p2c a_205385_326221# 0.01089f
C5814 a_82846_241091# a_82645_242401# 0
C5815 a_75685_360372# a_76015_360458# 0.03774f
C5816 a_79025_125231# a_82433_130212# 0.14317f
C5817 a_56308_202618# user_project_wrapper_0.analog_io[4] 0.05479f
C5818 TOP_ROILIFNEURON_0.MEM a_191970_327104# 0.00105f
C5819 a_35542_74035# a_35542_73705# 0.37213f
C5820 user_project_wrapper_0.sg13g2_IOPadAnalog_15.padres a_82846_242854# 0.25253f
C5821 user_project_wrapper_0.sg13g2_IOPadAnalog_19.padres a_188920_324155# 0.51373f
C5822 a_278644_355624# user_project_wrapper_0.analog_io[35] 25.1197f
C5823 a_190722_329327# a_190722_328605# 0
C5824 a_190824_328605# a_192738_328905# 0
C5825 a_192354_329332# a_192354_329120# 0.01085f
C5826 a_189190_110495# a_189190_108495# 0.04209f
C5827 a_303385_360458# a_303385_360372# 0.03774f
C5828 a_189184_325263# a_189184_328605# 0.76757f
C5829 a_122425_35542# user_project_wrapper_0.sg13g2_IOPadVdd_1.sg13g2_RCClampResistor_0.p2 0.03777f
C5830 a_190824_329719# a_189286_330241# 0
C5831 a_190082_92557# user_project_wrapper_0.analog_io[13] 0.00542f
C5832 a_210051_330987# a_210137_330851# 0.00843f
C5833 user_project_wrapper_0.sg13g2_IOPadOut4mA$1_1.c2p a_58798_281249# 1.43646f
C5834 QDLL_TOP_0.VDD user_project_wrapper_0.analog_io[13] 3.34275f
C5835 user_project_wrapper_0.IOVDD2 a_118465_35542# 0
C5836 a_39542_80305# user_project_wrapper_0.IOVDD1 0.01881f
C5837 user_project_wrapper_0.IOVDD4 a_237844_369296# 0.16358f
C5838 a_364458_74035# a_360458_74035# 0.03774f
C5839 TOP_ROILIFNEURON_0.MEM a_211921_326465# 0.00499f
C5840 user_project_wrapper_0.IOVDD1 a_35542_78985# 0
C5841 a_209684_328605# a_209684_327491# 0.00874f
C5842 a_208367_328605# a_209480_327491# 0.00251f
C5843 a_208939_328605# a_210007_327491# 0
C5844 w_188704_326203# a_190824_325263# 0.11519f
C5845 w_188806_323975# a_190501_325263# 0
C5846 user_project_wrapper_0.VDD2 a_117805_35542# -0
C5847 a_87105_130835# a_93208_127531# 0
C5848 a_208367_328605# a_210007_328605# 0.38387f
C5849 a_209684_328605# a_209480_328605# 0.80083f
C5850 a_35456_297775# a_35542_297775# 0.03774f
C5851 a_192354_328013# a_192354_327798# 0.01056f
C5852 a_208103_324155# a_210109_325263# 0
C5853 a_197044_29676# user_project_wrapper_0.IOVDD2 0.16358f
C5854 a_296732_200582# a_301423_202742# 0.1083f
C5855 a_301186_192011# a_296732_197880# 0.0077f
C5856 a_296626_197740# a_304889_199957# 0.32268f
C5857 a_304090_197941# a_307232_196607# 0.03538f
C5858 a_301940_196388# a_304196_200821# 0.03031f
C5859 a_208579_324119# a_208792_324119# 0.14709f
C5860 a_189184_326377# a_188920_324155# 0.07054f
C5861 user_project_wrapper_0.sg13g2_IOPadAnalog_8.padres user_project_wrapper_0.analog_io[4] 0.01728f
C5862 w_188704_327938# a_190722_328013# 0.01266f
C5863 user_project_wrapper_0.IOVDD1 a_39542_302725# 0.02119f
C5864 a_79038_126152# user_project_wrapper_0.sg13g2_IOPadAnalog_8.padres 0.07195f
C5865 analog_io[20] IOVDD3 0.2207p
C5866 a_83050_125173# user_project_wrapper_0.sg13g2_IOPadIn$1_0.p2c 0.04708f
C5867 a_190954_331163# a_191754_330987# 0.01566f
C5868 a_208939_329719# a_208469_329719# 0
C5869 a_208017_326341# a_209041_329719# 0.00271f
C5870 a_208939_325263# a_209905_329719# 0.00101f
C5871 a_79038_132662# a_79025_131741# 0.00141f
C5872 a_79025_133911# a_78824_130881# 0
C5873 a_360458_81625# VDD3 0
C5874 a_80965_360458# a_81295_360458# 0.37213f
C5875 a_82667_125418# a_82826_124842# 0.16543f
C5876 TOP_ROILIFNEURON_0.MEM a_192354_330026# 0.01062f
C5877 a_209480_325263# a_211537_325358# 0
C5878 a_187914_101343# QDLL_TOP_0.VDD 0.34479f
C5879 a_190686_324119# a_190757_324686# 0.52811f
C5880 user_project_wrapper_0.sg13g2_IOPadAnalog_4.padres user_project_wrapper_0.IOVDD2 1.36563f
C5881 user_project_wrapper_0.sg13g2_IOPadAnalog_29.padres a_314793_197200# 0.15949f
C5882 a_82433_130212# a_79025_133911# 0.00923f
C5883 user_project_wrapper_0.IOVDD2 a_114505_35542# 0
C5884 a_78220_130291# a_78220_130691# 0.01698f
C5885 a_209684_326377# a_210007_326377# 0.35443f
C5886 a_119785_35542# a_120115_35542# 0.37213f
C5887 a_89953_129061# a_87105_130835# 0.17885f
C5888 a_360372_78985# a_360372_78325# 0.02109f
C5889 w_188704_327938# a_189184_328605# 0.33727f
C5890 a_208071_331163# a_207985_330987# 0.02034f
C5891 a_190501_325263# a_191970_325570# 0
C5892 a_190824_325263# a_192354_325785# 0
C5893 a_191438_325263# a_192738_325997# 0
C5894 a_301509_196360# VDD3 0.00511f
C5895 user_project_wrapper_0.sg13g2_IOPadAnalog_6.padres QDLL_TOP_0.VOUT 1.21272f
C5896 a_311189_185546# VDD3 16.5006f
C5897 a_190926_327099# a_190501_327491# 0
C5898 a_189184_325263# a_188920_324155# 4.38251f
C5899 a_35542_74695# a_35542_74365# 0.37213f
C5900 a_269931_100182# a_270178_100118# 0.24485f
C5901 a_360372_300745# IOVDD3 0.02119f
C5902 a_121018_343292# user_project_wrapper_0.sg13g2_IOPadAnalog_16.padres 0.0512f
C5903 a_188074_110495# a_188074_108495# 0.04209f
C5904 a_189184_328605# a_189858_328605# 0.01812f
C5905 a_190824_328605# a_192354_329120# 0
C5906 a_191234_328605# a_191970_329120# 0
C5907 a_302725_360458# a_302725_360372# 0.03774f
C5908 a_89953_127531# a_86507_129255# 0.01061f
C5909 a_116485_35542# a_116815_35542# 0.37213f
C5910 a_190954_330851# a_191234_328605# 0
C5911 a_190297_329719# a_191234_329719# 0.02229f
C5912 a_187852_92557# user_project_wrapper_0.analog_io[13] 0.00922f
C5913 a_78220_128592# user_project_wrapper_0.sg13g2_IOPadAnalog_9.padres 0.16508f
C5914 a_79038_123516# a_79025_125231# 0
C5915 user_project_wrapper_0.IOVDD2 a_117145_35542# 0
C5916 user_project_wrapper_0.VDD1 user_project_wrapper_0.sg13g2_IOPadAnalog_14.padres 2.10897f
C5917 a_188888_331163# a_188888_331343# 0.12339f
C5918 user_project_wrapper_0.sg13g2_IOPadAnalog_28.padres a_56308_202618# 0.0512f
C5919 a_57810_179517# a_58798_179249# 0.14668f
C5920 a_79025_127401# a_83164_127455# 0.03601f
C5921 a_191234_325263# a_191462_324119# 0.00788f
C5922 a_190722_325785# a_190686_324119# 0
C5923 a_314793_198352# a_314697_196700# 0.76336f
C5924 user_project_wrapper_0.analog_io[13] a_192492_108495# 0.01131f
C5925 a_189286_325263# a_188920_324155# 0.01726f
C5926 a_191438_327491# a_192354_328013# 0.00953f
C5927 a_191970_328225# a_191970_328013# 0.01085f
C5928 TOP_ROILIFNEURON_0.MEM a_211921_330026# 0.00657f
C5929 user_project_wrapper_0.sg13g2_IOPadAnalog_14.padres user_project_wrapper_0.sg13g2_IOPadIn$1_1.p2c 0.00346f
C5930 a_360458_301075# a_360458_300745# 0.37213f
C5931 a_278644_29676# a_286861_29836# 0.01778f
C5932 a_191970_326892# a_191970_326677# 0.01056f
C5933 a_301940_196388# a_304090_197941# 5.45326f
C5934 user_project_wrapper_0.VDD1 a_35542_76675# 0
C5935 a_188834_326341# a_189858_328013# 0.01842f
C5936 a_301186_192011# a_296732_200582# 0.00364f
C5937 user_project_wrapper_0.sg13g2_IOPadAnalog_17.padres a_189286_328013# 0.00182f
C5938 user_project_wrapper_0.sg13g2_IOPadAnalog_19.padres a_190501_327491# 0
C5939 a_91090_127895# a_91090_127530# 0.09189f
C5940 user_project_wrapper_0.sg13g2_IOPadAnalog_22.padres a_208103_324155# 6.14017f
C5941 a_189688_330987# a_189835_330987# 0.17736f
C5942 a_208367_325263# a_208103_324155# 4.38251f
C5943 a_35542_298765# a_35542_298435# 0.37213f
C5944 a_360372_74365# IOVDD3 0.01881f
C5945 a_82118_242359# user_project_wrapper_0.analog_io[4] 0.01721f
C5946 a_79038_134366# a_79038_132662# 0.00178f
C5947 a_78219_134797# a_78220_132587# 0.01701f
C5948 a_210137_330851# a_210109_329719# 0
C5949 a_79025_133911# a_79025_133504# 0
C5950 user_project_wrapper_0.sg13g2_IOPadOut4mA$1_1.c2p a_86046_241645# 0
C5951 a_80305_360458# a_80635_360458# 0.37213f
C5952 a_79025_126994# a_79038_125686# 0.71261f
C5953 TOP_ROILIFNEURON_0.MEM a_191970_330453# 0.00105f
C5954 w_188704_327938# a_188920_324155# 0.02406f
C5955 a_189396_324119# a_189609_324119# 0.14709f
C5956 a_268697_100118# user_project_wrapper_0.sg13g2_IOPadAnalog_6.padres 0.43779f
C5957 a_119125_35542# a_119455_35542# 0.37213f
C5958 a_83389_129203# a_82433_130212# 0.00202f
C5959 a_83492_127455# a_79025_127401# 0.01026f
C5960 a_87434_129426# a_87105_130835# 0.01801f
C5961 a_82348_128838# a_83796_129203# 0
C5962 a_93461_128591# user_project_wrapper_0.sg13g2_IOPadOut4mA$1_0.c2p 0.00287f
C5963 a_360372_79645# a_360372_78985# 0.02109f
C5964 user_project_wrapper_0.sg13g2_IOPadAnalog_6.padres a_269079_100182# 0.01229f
C5965 a_191234_325263# a_191438_325263# 0.43471f
C5966 a_304995_198817# VDD3 0.02036f
C5967 a_188760_101343# QDLL_TOP_0.VOUT 0
C5968 IOVDD3 a_360458_297775# 0.06232f
C5969 a_191438_328605# a_191970_329814# 0
C5970 a_208017_326341# a_206201_328627# 0
C5971 a_189858_329327# a_189756_328605# 0.10234f
C5972 user_project_wrapper_0.sg13g2_IOPadAnalog_21.padres a_205385_326221# 0.03171f
C5973 a_189756_325263# a_189858_330241# 0.02322f
C5974 a_190297_326377# a_189756_327491# 0.00215f
C5975 a_190501_326377# a_189184_327491# 0
C5976 a_189184_326377# a_190501_327491# 0
C5977 a_189756_326377# a_190297_327491# 0
C5978 a_299425_360458# user_project_wrapper_0.IOVDD4 0
C5979 a_268967_100118# a_269355_100412# 0.0066f
C5980 a_269079_100182# a_269543_100118# 0.00107f
C5981 a_35542_75355# a_35542_75025# 0.37213f
C5982 a_360372_302065# IOVDD3 0.02119f
C5983 a_258244_355624# a_266461_355784# 0.01916f
C5984 a_189184_328605# a_191438_328605# 0.00136f
C5985 a_190297_328605# a_190722_329327# 0.00962f
C5986 a_190501_328605# a_190926_329327# 0.05272f
C5987 a_186397_108409# a_187518_108496# 0
C5988 a_186960_110495# a_186960_108495# 0.04209f
C5989 a_211153_328693# a_211153_328225# 0.00322f
C5990 a_302065_360458# a_302065_360372# 0.03774f
C5991 a_210621_328605# a_211921_328693# 0
C5992 a_115825_35542# a_116155_35542# 0.37213f
C5993 a_91911_129060# a_92512_127896# 0
C5994 a_83492_127455# a_86594_127531# 0.02453f
C5995 a_35542_304375# a_35542_304045# 0.37213f
C5996 a_207985_330987# a_210051_330987# 0.10143f
C5997 a_208103_324155# a_209905_327491# 0
C5998 a_79975_360458# a_80305_360458# 0.37213f
C5999 user_project_wrapper_0.IOVDD1 a_41636_225661# 1.92793f
C6000 TOP_ROILIFNEURON_0.MEM a_190824_327491# 0
C6001 a_79025_127401# a_82527_127455# 0.14504f
C6002 a_79025_125231# a_82840_127455# 0.00178f
C6003 a_304889_198885# a_296732_197880# 0
C6004 a_78220_123062# a_79038_123516# 0.17968f
C6005 TOP_ROILIFNEURON_0.MEM a_211537_330453# 0.00168f
C6006 user_project_wrapper_0.VDD2 a_243418_56308# -0
C6007 a_360458_301735# a_360458_301405# 0.37213f
C6008 w_207883_330166# a_208103_324155# 0.02201f
C6009 a_237844_29676# a_246061_29836# 0.01778f
C6010 a_192354_327104# a_192354_326892# 0.01085f
C6011 a_208103_324155# a_209041_325785# 0
C6012 a_369296_217444# IOVDD3 0.16358f
C6013 a_35456_79315# user_project_wrapper_0.VDD1 0
C6014 a_78824_126541# user_project_wrapper_0.sg13g2_IOPadAnalog_9.padres 0.07869f
C6015 user_project_wrapper_0.VDD1 a_35542_77995# 0
C6016 a_210109_326377# a_209684_326377# 0.00499f
C6017 a_188834_327918# a_189184_327491# 0.52312f
C6018 a_189756_325263# a_189756_327491# 0.04275f
C6019 a_189184_325263# a_190501_327491# 0
C6020 a_209041_326377# a_210007_326377# 0
C6021 user_project_wrapper_0.IOVDD2 a_305695_35542# 0
C6022 IOVDD3 user_project_wrapper_0.sg13g2_IOPadIOVdd_3.sg13g2_RCClampResistor_0.p2 0.10479p
C6023 a_89114_127896# a_89114_127531# 0.09189f
C6024 user_project_wrapper_0.sg13g2_IOPadAnalog_27.padres a_343292_284218# 0.0512f
C6025 a_208939_325263# a_209041_330241# 0.02322f
C6026 a_35542_299425# a_35542_299095# 0.37213f
C6027 a_360372_75685# IOVDD3 0.01881f
C6028 a_79025_136081# a_78824_133051# 0
C6029 a_78824_135221# a_79025_133911# 0
C6030 a_79645_360458# a_79975_360458# 0.37213f
C6031 a_79025_135674# a_79038_134366# 0.71261f
C6032 a_78219_134883# a_78219_134797# 0.01435f
C6033 a_79025_129571# a_78824_130881# 0
C6034 a_86594_129426# a_85127_131750# 0.20542f
C6035 a_190868_330987# a_190297_329719# 0
C6036 a_189184_328605# a_190926_328013# 0
C6037 a_190501_328605# a_190722_328013# 0.00101f
C6038 a_83492_127455# a_86507_127725# 2.59185f
C6039 a_89953_129061# a_91090_129425# 0.0526f
C6040 a_35542_306025# a_35542_305695# 0.37213f
C6041 w_188700_330166# a_191438_329719# 0.07951f
C6042 w_207887_326203# a_206201_328627# 0
C6043 a_189148_101407# a_189395_101343# 0.24485f
C6044 a_188296_101407# user_project_wrapper_0.sg13g2_IOPadAnalog_6.padres 0.00155f
C6045 a_190757_324686# a_188920_324155# 0
C6046 user_project_wrapper_0.sg13g2_IOPadAnalog_22.padres user_project_wrapper_0.sg13g2_IOPadIn$1_2.p2c 0
C6047 user_project_wrapper_0.sg13g2_IOPadIn$1_2.p2c a_208367_325263# 0
C6048 a_79025_125231# a_79025_138251# 0.39325f
C6049 a_191234_326377# a_189672_324776# 0
C6050 a_118465_35542# a_118795_35542# 0.37213f
C6051 a_79025_129571# a_82433_130212# 0
C6052 a_355624_135844# analog_io[19] 25.1197f
C6053 a_83492_130212# a_83796_129203# 0.00129f
C6054 a_360372_80305# a_360372_79645# 0.02109f
C6055 a_188572_99046# a_188184_99046# 0.0066f
C6056 user_project_wrapper_0.analog_io[13] a_186960_110495# 0.04372f
C6057 a_190501_325263# a_191234_325263# 0.00662f
C6058 a_190297_325263# a_190824_325263# 0.20188f
C6059 a_296626_197740# VDD3 46.0936f
C6060 a_185968_102197# QDLL_TOP_0.VOUT 0.01219f
C6061 IOVDD3 a_360372_298765# 0.02181f
C6062 a_190297_328605# a_190926_329719# 0
C6063 a_210007_326377# a_210007_327491# 0.01118f
C6064 a_189756_325263# a_191234_329719# 0
C6065 a_189756_329719# a_190297_329719# 0.21118f
C6066 a_188834_326341# a_190824_329719# 0
C6067 a_191987_330851# a_192354_330453# 0.00399f
C6068 a_35542_76015# a_35542_75685# 0.37213f
C6069 a_208103_324155# a_210417_325263# 0
C6070 a_298105_360458# user_project_wrapper_0.IOVDD4 0
C6071 a_88393_125210# a_86507_127725# 0.02948f
C6072 TOP_ROILIFNEURON_0.MEM a_210007_326377# 0
C6073 m2_82112_130096# a_82433_130212# 0.01213f
C6074 m2_83010_126180# a_79025_125231# 0
C6075 a_217444_355624# a_225661_355784# 0.01916f
C6076 a_360372_303385# IOVDD3 0.02079f
C6077 a_190824_327491# a_190926_327491# 0.1023f
C6078 a_190297_327491# a_191970_327586# 0
C6079 a_190501_327491# a_192354_327586# 0
C6080 a_189184_328605# a_190501_328605# 0.72543f
C6081 a_301405_360458# a_301405_360372# 0.03774f
C6082 a_82840_127455# a_79025_133911# 0.00246f
C6083 user_project_wrapper_0.VDD1 a_79025_131334# 1.75375f
C6084 a_115165_35542# a_115495_35542# 0.37213f
C6085 a_90579_129060# a_89953_127531# 0
C6086 a_89953_129061# a_84332_125209# 0
C6087 a_35542_305035# a_35542_304705# 0.37213f
C6088 a_35542_81625# a_35542_81295# 0.37213f
C6089 TOP_ROILIFNEURON_0.MEM a_211921_328905# 0.00699f
C6090 user_project_wrapper_0.analog_io[14] a_190218_98097# 0.14984f
C6091 w_188704_327938# a_190501_327491# 0.10247f
C6092 a_191751_90472# a_192309_90557# 0.04279f
C6093 a_82433_130212# a_83389_128838# 0
C6094 a_79025_125231# a_79038_128322# 0
C6095 user_project_wrapper_0.sg13g2_IOPadAnalog_22.padres a_208367_326377# 0.18129f
C6096 a_79025_127401# a_78220_128106# 0
C6097 a_209480_329719# a_210109_329327# 0
C6098 user_project_wrapper_0.VDD1 a_83398_130212# 0.42553f
C6099 a_208939_325263# a_206547_324106# 0.01526f
C6100 a_208367_325263# a_208367_326377# 0.6272f
C6101 a_208017_327918# a_208939_326377# 0.01056f
C6102 a_314793_198352# a_314793_201808# 1.91882f
C6103 a_304889_198885# a_296732_200582# 0.01647f
C6104 a_296731_208493# a_301509_202742# 0
C6105 TOP_ROILIFNEURON_0.MEM a_213462_327536# 0.02949f
C6106 user_project_wrapper_0.sg13g2_IOPadAnalog_19.padres a_189858_327099# 0.00916f
C6107 a_360458_302395# a_360458_302065# 0.37213f
C6108 a_197044_29676# a_205261_29836# 0.01778f
C6109 w_207883_330166# a_210109_330241# 0.01287f
C6110 a_190722_328605# a_189184_327491# 0
C6111 a_35456_80635# user_project_wrapper_0.VDD1 0.00157f
C6112 a_213376_328627# a_211921_325997# 0
C6113 a_208855_324776# a_210007_326377# 0
C6114 a_87775_125210# a_84332_125209# 0
C6115 a_211153_327104# a_209480_326377# 0
C6116 a_211537_327104# a_209684_326377# 0
C6117 user_project_wrapper_0.VDD1 a_35542_79315# 0
C6118 user_project_wrapper_0.IOVDD2 a_304375_35542# 0
C6119 a_298765_39542# a_299425_39542# 0.02109f
C6120 a_360458_75355# a_360458_75025# 0.37213f
C6121 user_project_wrapper_0.analog_io[13] a_197044_29676# 9.69836f
C6122 user_project_wrapper_0.VDD1 a_92512_127531# 0
C6123 user_project_wrapper_0.IOVDD4 user_project_wrapper_0.analog_io[35] 0.10967p
C6124 a_208017_327918# a_209480_329719# 0
C6125 a_208367_325263# a_210007_329719# 0
C6126 user_project_wrapper_0.IOVDD4 a_304375_360458# 0
C6127 a_189016_99480# QDLL_TOP_0.VDD 0.20601f
C6128 a_35542_300085# a_35542_299755# 0.37213f
C6129 a_208939_325263# a_209684_329719# 0.01748f
C6130 a_360372_77005# IOVDD3 0.01881f
C6131 a_79025_138251# a_79025_133911# 0.37095f
C6132 a_78219_135283# a_79025_135674# 0
C6133 a_79038_136536# a_78824_135221# 0
C6134 a_78985_360458# a_79315_360458# 0.37213f
C6135 a_82658_129203# a_79025_136081# 0.14517f
C6136 a_84598_130577# a_86507_129255# 0.28178f
C6137 a_79038_130026# a_79025_131334# 0.71261f
C6138 a_191970_325358# a_189672_324776# 0.00129f
C6139 a_190218_102763# QDLL_TOP_0.VDD 0.15314f
C6140 a_89114_129426# a_86507_127725# 0
C6141 w_188704_327938# a_194279_327536# 0
C6142 a_213462_327536# a_208855_324776# 0.02043f
C6143 a_190584_102855# user_project_wrapper_0.sg13g2_IOPadAnalog_6.padres 0
C6144 a_188184_101343# a_188572_101637# 0.0066f
C6145 a_188296_101407# a_188760_101343# 0.00107f
C6146 a_191970_330026# a_191970_329814# 0.01085f
C6147 a_92512_127531# user_project_wrapper_0.sg13g2_IOPadIn$1_1.p2c 0
C6148 a_209905_327491# a_208367_326377# 0
C6149 a_189756_326377# a_190722_327099# 0.00596f
C6150 a_190297_326377# a_191234_326377# 0.02229f
C6151 a_190501_326377# a_189286_327099# 0
C6152 a_84598_130577# a_84288_130212# 0.07331f
C6153 a_117805_35542# a_118135_35542# 0.37213f
C6154 m1_81567_127343# a_79025_131741# 0.00492f
C6155 user_project_wrapper_0.sg13g2_IOPadAnalog_19.padres a_190501_329719# 0
C6156 a_360372_80965# a_360372_80305# 0.02109f
C6157 a_211921_326677# a_211921_326465# 0.01085f
C6158 a_190501_328605# a_188920_324155# 0
C6159 a_360372_75025# VDD3 0
C6160 a_208939_326377# a_208939_327491# 0.27199f
C6161 a_57810_281517# a_58798_281249# 0.14668f
C6162 user_project_wrapper_0.sg13g2_IOPadIn$1_2.p2c a_210307_324119# 0.0016f
C6163 a_35542_76675# a_35542_76345# 0.37213f
C6164 a_82645_240231# a_82846_240684# 1.02588f
C6165 m1_82112_127957# a_79025_125231# 0
C6166 m1_81998_130507# a_82433_130212# 0.00521f
C6167 a_156244_355624# a_164461_355784# 0.01916f
C6168 a_360372_304705# IOVDD3 0.02056f
C6169 a_360458_298435# a_360458_298105# 0.37213f
C6170 m5_6924_10284# m6_7020_10380# 0.42828p
C6171 a_209041_328605# a_208367_327491# 0.0018f
C6172 a_190824_327491# a_192354_328013# 0
C6173 a_190501_327491# a_191970_327798# 0
C6174 a_83925_130212# user_project_wrapper_0.sg13g2_IOPadIn$1_0.p2c 0.0032f
C6175 a_300745_360458# a_300745_360372# 0.03774f
C6176 a_210417_328605# a_211537_329120# 0
C6177 a_210007_328605# a_211921_329120# 0
C6178 a_114505_35542# a_114835_35542# 0.37213f
C6179 a_209041_325785# a_208367_326377# 0.00113f
C6180 user_project_wrapper_0.VDD1 a_79038_132662# 0.09485f
C6181 a_209905_329719# a_209684_328605# 0
C6182 a_83492_127455# a_86594_127896# 0.1985f
C6183 a_82348_128838# a_82527_127455# 0
C6184 a_83079_128838# a_83164_127820# 0
C6185 user_project_wrapper_0.VDD1 a_93204_129062# 0.71554f
C6186 a_35542_305695# a_35542_305365# 0.37213f
C6187 TOP_ROILIFNEURON_0.MEM a_211537_329120# 0.01055f
C6188 a_187018_328627# user_project_wrapper_0.analog_io[27] 0.00548f
C6189 a_343292_202618# VDD3 0
C6190 w_207887_327938# a_209905_328605# 0.01266f
C6191 a_190638_90472# a_191196_90557# 0.04279f
C6192 a_190490_102497# user_project_wrapper_0.analog_io[13] 0
C6193 a_296731_208493# a_296625_208423# 16.6941f
C6194 a_188834_327918# a_189286_327099# 0.00138f
C6195 a_188834_326341# a_190824_326377# 0
C6196 a_189756_325263# a_191234_326377# 0.00216f
C6197 user_project_wrapper_0.IOVDD1 a_41636_266461# 1.92793f
C6198 user_project_wrapper_0.sg13g2_IOPadAnalog_17.padres a_190297_326377# 0
C6199 a_210137_331163# a_209480_329719# 0
C6200 a_208939_325263# a_210109_328013# 0.00123f
C6201 a_208367_329719# a_208469_328013# 0.00139f
C6202 a_208939_329719# a_209041_328013# 0.00194f
C6203 user_project_wrapper_0.sg13g2_IOPadAnalog_19.padres a_187364_324106# 0.03117f
C6204 a_360458_303055# a_360458_302725# 0.37213f
C6205 a_210621_325263# a_211153_325358# 0.00193f
C6206 user_project_wrapper_0.sg13g2_IOPadAnalog_21.padres a_209041_328013# 0
C6207 w_207883_330166# a_210007_329719# 0.11271f
C6208 user_project_wrapper_0.sg13g2_IOPadAnalog_14.padres a_56308_243418# 0.0512f
C6209 a_208939_325263# a_210621_328605# 0.00124f
C6210 a_208939_329719# a_209905_329327# 0
C6211 a_209041_327099# a_208939_326377# 0.10231f
C6212 a_208469_327099# a_208367_326377# 0.10231f
C6213 a_88291_125210# a_84332_125209# 0
C6214 a_83592_125209# a_82527_127455# 0
C6215 user_project_wrapper_0.sg13g2_IOPadAnalog_5.padres user_project_wrapper_0.analog_io[15] 0.33115f
C6216 user_project_wrapper_0.IOVDD2 a_303055_35542# 0
C6217 a_210983_324119# a_206547_324106# 0
C6218 user_project_wrapper_0.sg13g2_IOPadOut4mA$1_0.sg13g2_GateLevelUpInv_noptap$1$1_0.ngate user_project_wrapper_0.sg13g2_IOPadOut4mA$1_0.c2p 0.03235f
C6219 a_298105_39542# a_298765_39542# 0.02109f
C6220 a_189921_330987# a_188834_326341# 0
C6221 a_188802_330987# a_189184_329719# 0
C6222 a_360458_76015# a_360458_75685# 0.37213f
C6223 a_211153_326892# a_210621_327491# 0
C6224 a_188888_330987# user_project_wrapper_0.sg13g2_IOPadAnalog_17.padres 0.00275f
C6225 a_58798_179951# user_project_wrapper_0.sg13g2_IOPadOut4mA$1_0.c2p 1.75397f
C6226 user_project_wrapper_0.VDD1 a_93208_127531# 0.35604f
C6227 user_project_wrapper_0.IOVDD1 a_35542_297775# 0.06232f
C6228 user_project_wrapper_0.IOVDD4 a_303055_360458# 0
C6229 a_35542_300745# a_35542_300415# 0.37213f
C6230 a_188296_99070# QDLL_TOP_0.VDD 0.21439f
C6231 user_project_wrapper_0.analog_io[15] a_237844_41476# 25.1197f
C6232 a_360372_78325# IOVDD3 0.01881f
C6233 user_project_wrapper_0.sg13g2_IOPadIn$1_2.p2c a_191124_324119# 0.0187f
C6234 a_210137_330851# a_209480_329719# 0.00258f
C6235 a_78824_137391# a_78219_135283# 0.00173f
C6236 a_79025_137844# a_79038_137002# 0.70614f
C6237 a_79025_138251# a_79038_136536# 0
C6238 a_78325_360458# a_78655_360458# 0.37213f
C6239 a_192738_325785# a_189672_324776# 0
C6240 a_210007_325263# a_209684_326377# 0
C6241 a_209480_325263# a_209480_326377# 0.00495f
C6242 a_209684_325263# a_210007_326377# 0
C6243 a_208367_325263# a_208939_329719# 0.00459f
C6244 a_208017_327918# a_208017_326341# 0.04203f
C6245 a_79025_129571# a_79025_129164# 0
C6246 user_project_wrapper_0.sg13g2_IOPadAnalog_22.padres a_208939_329719# 0.0036f
C6247 user_project_wrapper_0.sg13g2_IOPadAnalog_21.padres user_project_wrapper_0.sg13g2_IOPadAnalog_22.padres 22.8507f
C6248 a_314793_198352# VDD3 0.76067f
C6249 a_209905_325263# a_208855_324776# 0
C6250 user_project_wrapper_0.sg13g2_IOPadAnalog_21.padres a_208367_325263# 0.07754f
C6251 a_360458_74365# IOVDD3 0
C6252 a_191438_329719# a_191970_329814# 0.00193f
C6253 a_189184_325263# a_190501_329719# 0
C6254 a_188834_327918# a_189184_329719# 0.40028f
C6255 a_189756_325263# a_189756_329719# 0.26653f
C6256 user_project_wrapper_0.sg13g2_IOPadAnalog_17.padres a_189756_325263# 0.00455f
C6257 a_187364_324106# a_189184_326377# 0.00328f
C6258 user_project_wrapper_0.sg13g2_IOPadAnalog_8.padres a_78824_133051# 0.12051f
C6259 user_project_wrapper_0.IOVDD2 a_298765_35542# 0
C6260 a_117145_35542# a_117475_35542# 0.37213f
C6261 m2_81563_127336# a_79025_136081# 0.0102f
C6262 user_project_wrapper_0.sg13g2_IOPadAnalog_19.padres a_186202_326221# 0.03171f
C6263 a_208367_325263# a_208469_326377# 0.00236f
C6264 user_project_wrapper_0.IOVDD4 a_80965_360458# 0
C6265 user_project_wrapper_0.IOVDD1 a_35456_73375# 0.01409f
C6266 a_360372_76345# VDD3 0.00238f
C6267 a_190319_97955# QDLL_TOP_0.VDD 0.23218f
C6268 a_190954_330851# a_190297_329719# 0.00258f
C6269 a_35542_77335# a_35542_77005# 0.37213f
C6270 a_82846_241091# a_82846_240684# 0
C6271 a_82859_241546# a_82645_240231# 0
C6272 a_208367_327491# a_210109_328013# 0.0266f
C6273 a_209684_327491# a_209905_328013# 0.05425f
C6274 a_208939_327491# a_210621_327491# 0
C6275 user_project_wrapper_0.VDD1 user_project_wrapper_0.sg13g2_IOPadOut4mA$1_0.sg13g2_GateLevelUpInv_noptap$1$1_0.pgate 0.40724f
C6276 user_project_wrapper_0.ui_PAD[31] user_project_wrapper_0.IOVDD4 84.7563f
C6277 a_115444_355624# a_123661_355784# 0.01916f
C6278 a_85875_125209# a_83492_127455# 0
C6279 a_85435_125173# a_86507_127725# 0
C6280 a_190501_327491# a_190926_328013# 0.00499f
C6281 m3_6878_10238# m4_6878_10238# 1.04272p
C6282 a_360458_299095# a_360458_298765# 0.37213f
C6283 a_189184_327491# a_191438_327491# 0.00152f
C6284 a_79025_127401# user_project_wrapper_0.sg13g2_IOPadIn$1_0.p2c 0.16579f
C6285 w_188704_326203# a_190824_326377# 0.11544f
C6286 a_314793_197200# a_315347_192648# 0.17013f
C6287 a_83796_128838# a_79025_136081# 0
C6288 a_343292_243418# analog_io[23] 0.05479f
C6289 a_192138_324119# a_189672_324776# 0.38445f
C6290 a_210007_328605# a_209905_329327# 0.1023f
C6291 a_209480_328605# a_210109_329327# 0.01814f
C6292 user_project_wrapper_0.VDD1 a_79025_135674# 1.75375f
C6293 a_309917_194695# user_project_wrapper_0.sg13g2_IOPadAnalog_29.padres 1.37629f
C6294 a_82658_129203# a_83796_128838# 0.0242f
C6295 a_211537_330026# a_211537_329814# 0.01085f
C6296 a_91090_129425# a_91090_129060# 0.09189f
C6297 a_208103_324155# a_208939_328605# 1.1099f
C6298 a_78824_128711# a_79038_127856# 0
C6299 a_87434_129426# a_88274_127896# 0
C6300 user_project_wrapper_0.VDD1 a_89953_129061# 1.28264f
C6301 w_207887_327938# a_210621_327491# 0.08621f
C6302 a_79038_126152# a_79025_125231# 0.00221f
C6303 a_306025_360458# user_project_wrapper_0.IOVDD4 0
C6304 a_79038_125686# a_79025_127401# 0
C6305 a_79038_123982# user_project_wrapper_0.sg13g2_IOPadAnalog_8.padres 0.07028f
C6306 a_189524_90472# a_190082_90557# 0.04279f
C6307 a_189756_327491# a_189756_328605# 0.29973f
C6308 a_364458_81295# a_360458_81625# 0.03774f
C6309 a_189184_325263# a_187364_324106# 0.00805f
C6310 TOP_ROILIFNEURON_0.MEM a_211153_325785# 0.00115f
C6311 a_89953_129061# user_project_wrapper_0.sg13g2_IOPadIn$1_1.p2c 0.0534f
C6312 a_87627_124843# a_87571_125210# 0.02303f
C6313 a_87468_125419# a_87775_125210# 0.00793f
C6314 a_208017_327918# a_209684_327491# 0
C6315 a_208367_325263# a_209480_327491# 0
C6316 a_208939_325263# a_208367_327491# 0.25529f
C6317 a_208017_326341# a_208939_327491# 0.46504f
C6318 user_project_wrapper_0.sg13g2_IOPadAnalog_22.padres a_209480_327491# 0
C6319 a_360458_303715# a_360458_303385# 0.37213f
C6320 a_189184_328605# a_190297_327491# 0.00251f
C6321 a_190501_328605# a_190501_327491# 0.00874f
C6322 a_190297_328605# a_189184_327491# 0.00158f
C6323 a_208017_327918# a_209480_328605# 0
C6324 user_project_wrapper_0.sg13g2_IOPadAnalog_22.padres a_210007_328605# 0
C6325 a_85211_124842# a_84332_125209# 0.81217f
C6326 a_211921_327104# a_211921_327586# 0.0031f
C6327 a_87775_125210# user_project_wrapper_0.VDD1 0.14011f
C6328 a_208579_324119# a_206547_324106# 0.03412f
C6329 a_209104_331163# a_208367_329719# 0
C6330 TOP_ROILIFNEURON_0.MEM a_192738_328693# 0.00499f
C6331 user_project_wrapper_0.IOVDD2 a_301735_35542# 0
C6332 w_207887_326203# a_208017_327918# 0.18775f
C6333 w_207883_330166# a_208939_329719# 0.21627f
C6334 w_207887_327938# a_208017_326341# 0.17713f
C6335 a_360458_76675# a_360458_76345# 0.37213f
C6336 user_project_wrapper_0.IOVDD1 a_35456_305695# 0.01587f
C6337 user_project_wrapper_0.sg13g2_IOPadAnalog_21.padres w_207883_330166# 0.00127f
C6338 a_208939_325263# a_210109_325785# 0.00142f
C6339 a_208367_325263# a_211153_325997# 0
C6340 w_188806_323975# a_188834_327918# 0
C6341 w_188704_326203# a_188834_326341# 0.35435f
C6342 user_project_wrapper_0.VDD1 a_83164_127820# 0.45457f
C6343 a_246061_355784# user_project_wrapper_0.IOVDD4 1.92793f
C6344 user_project_wrapper_0.IOVDD4 a_301735_360458# 0
C6345 a_35542_301405# a_35542_301075# 0.37213f
C6346 a_360372_79645# IOVDD3 0.01881f
C6347 a_78218_138281# a_79025_138251# 0
C6348 a_77665_360458# a_77995_360458# 0.37213f
C6349 TOP_ROILIFNEURON_0.MEM a_211537_327104# 0.00168f
C6350 a_74695_360458# a_75025_360458# 0.37213f
C6351 a_192354_325997# a_189672_324776# 0
C6352 a_79025_129571# a_79025_138251# 0
C6353 a_189286_325263# a_187364_324106# 0
C6354 a_369296_115444# IOVDD3 0.16358f
C6355 a_189395_99046# QDLL_TOP_0.VOUT 0
C6356 a_211153_325785# a_208855_324776# 0
C6357 user_project_wrapper_0.sg13g2_IOPadAnalog_9.padres a_78220_130691# 0.16553f
C6358 a_208071_330851# a_208367_329719# 0.00338f
C6359 a_209104_330851# a_208939_329719# 0.00656f
C6360 a_192354_330453# a_192354_330241# 0.01085f
C6361 user_project_wrapper_0.VDD1 a_82118_240839# 0.00428f
C6362 user_project_wrapper_0.sg13g2_IOPadAnalog_21.padres a_209104_330851# 0
C6363 a_186202_326221# a_189184_325263# 0
C6364 user_project_wrapper_0.sg13g2_IOPadAnalog_8.padres a_79025_136081# 0.5697f
C6365 user_project_wrapper_0.IOVDD2 a_122425_35542# 0
C6366 a_212178_331163# a_212178_331343# 0.02961f
C6367 m2_82112_130096# a_79025_138251# 0.01327f
C6368 user_project_wrapper_0.IOVDD1 a_35456_74695# 0.01409f
C6369 a_208939_325263# a_209905_327099# 0.00101f
C6370 a_208017_326341# a_209041_327099# 0.00128f
C6371 a_360372_77665# VDD3 0.00238f
C6372 a_190501_326377# a_190722_327491# 0
C6373 a_211153_328013# a_211153_328225# 0.01085f
C6374 a_211537_328013# a_210621_327491# 0.00953f
C6375 a_210109_327491# a_209684_327491# 0.05288f
C6376 a_209905_327491# a_209480_327491# 0.00962f
C6377 a_78220_130291# user_project_wrapper_0.sg13g2_IOPadAnalog_9.padres 0.01143f
C6378 user_project_wrapper_0.VDD2 a_121765_39542# 0.00238f
C6379 user_project_wrapper_0.sg13g2_IOPadAnalog_21.padres a_208469_327099# 0
C6380 w_188704_326203# a_190926_325263# 0
C6381 user_project_wrapper_0.IOVDD1 a_35456_303715# 0.01452f
C6382 a_209480_325263# a_209041_325263# 0
C6383 a_210417_325263# a_211921_325570# 0
C6384 a_209684_325263# a_209905_325263# 0.01614f
C6385 a_35542_77995# a_35542_77665# 0.37213f
C6386 a_86046_241645# a_86407_241748# 0.13046f
C6387 a_85989_241383# a_85989_241748# 0.1219f
C6388 a_82846_241091# a_82859_241546# 0.03016f
C6389 a_208939_327491# a_209684_327491# 0.20572f
C6390 a_82826_124842# a_83492_127455# 0
C6391 m2_6878_10238# m3_6878_10238# 1.04272p
C6392 a_360458_299755# a_360458_299425# 0.37213f
C6393 user_project_wrapper_0.sg13g2_IOPadAnalog_22.padres a_210137_331343# 0.00147f
C6394 a_360458_73705# VDD3 0
C6395 user_project_wrapper_0.VDD1 a_78824_137391# 2.73525f
C6396 a_189609_324119# a_189672_324776# 0.45527f
C6397 a_189737_324155# a_189756_326377# 0
C6398 a_121018_343292# user_project_wrapper_0.analog_io[27] 0.05479f
C6399 a_84598_130577# a_89953_127531# 0.08518f
C6400 a_369296_197044# analog_io[22] 9.69836f
C6401 TOP_ROILIFNEURON_0.MEM a_192354_327586# 0.00168f
C6402 a_79025_129571# a_79038_128322# 0.01113f
C6403 a_311189_211724# a_314793_198352# 0.00867f
C6404 a_301575_211562# a_304889_198885# 0.07519f
C6405 a_296731_208493# a_305619_211562# 0.00724f
C6406 user_project_wrapper_0.VDD1 a_87434_129426# 0.42036f
C6407 w_207887_326203# a_208939_327491# 0.0623f
C6408 w_207887_327938# a_209684_327491# 0.10247f
C6409 a_189921_331343# user_project_wrapper_0.sg13g2_IOPadAnalog_19.padres 0
C6410 user_project_wrapper_0.IOVDD1 a_35542_299095# 0
C6411 w_207887_327938# a_209480_328605# 0.08797f
C6412 a_188408_90472# a_188966_90557# 0.04279f
C6413 w_207883_330166# a_210007_328605# 0
C6414 a_191987_331163# a_190868_330987# 0.02034f
C6415 TOP_ROILIFNEURON_0.MEM w_188704_327938# 0.02545f
C6416 a_190297_327491# a_188920_324155# 0.00153f
C6417 a_209684_325263# a_210109_326377# 0
C6418 a_78221_125094# a_79025_124824# 0
C6419 a_85211_124842# a_85155_125209# 0.02303f
C6420 a_85052_125418# a_85359_125209# 0.00793f
C6421 a_87468_125419# a_88291_125210# 0.23138f
C6422 a_87627_124843# a_87673_125210# 0.08174f
C6423 w_207887_326203# a_209905_325785# 0.01266f
C6424 a_78985_360458# user_project_wrapper_0.IOVDD4 0
C6425 a_360458_304375# a_360458_304045# 0.37213f
C6426 a_210417_326377# a_209684_326377# 0.00663f
C6427 a_192354_326892# a_191438_326377# 0.0091f
C6428 a_191970_326677# a_190824_326377# 0
C6429 a_82826_124842# a_82527_127455# 0.0067f
C6430 a_208071_331163# user_project_wrapper_0.sg13g2_IOPadAnalog_22.padres 0.03143f
C6431 a_88291_125210# user_project_wrapper_0.VDD1 0.21289f
C6432 a_210137_330851# a_209480_328605# 0
C6433 user_project_wrapper_0.sg13g2_IOPadVdd_3.sg13g2_RCClampInverter_noptap_0.out user_project_wrapper_0.IOVDD4 49.206f
C6434 user_project_wrapper_0.IOVDD2 a_300415_35542# 0
C6435 a_208071_331163# a_208367_325263# 0
C6436 user_project_wrapper_0.sg13g2_IOPadAnalog_5.padres user_project_wrapper_0.IOVDD2 1.36563f
C6437 a_121765_39542# a_122095_35542# 0.03774f
C6438 a_121435_35456# a_122095_35456# 0.02109f
C6439 w_188704_327938# a_191970_328693# 0.0018f
C6440 a_360458_77335# a_360458_77005# 0.37213f
C6441 a_189921_330987# a_189921_330851# 0.29305f
C6442 a_210109_327099# a_208939_327491# 0
C6443 a_209905_327099# a_208367_327491# 0
C6444 a_192738_325570# a_192738_325358# 0.01085f
C6445 m2_81766_242000# user_project_wrapper_0.sg13g2_IOPadAnalog_15.padres 0.02868f
C6446 w_188704_327938# a_186202_326221# 0
C6447 w_188700_330166# a_187018_328627# 0
C6448 a_144061_355784# user_project_wrapper_0.IOVDD4 1.92793f
C6449 user_project_wrapper_0.VDD1 a_78220_128192# 0.00901f
C6450 user_project_wrapper_0.IOVDD4 a_300415_360458# 0
C6451 a_35542_302065# a_35542_301735# 0.37213f
C6452 a_360372_80965# IOVDD3 0.01881f
C6453 a_311108_215937# analog_io[23] 19.8213f
C6454 a_77005_360458# a_77335_360458# 0.37213f
C6455 a_343292_141418# analog_io[19] 0.05479f
C6456 user_project_wrapper_0.IOVDD2 a_237844_41476# 58.9173f
C6457 a_284218_343292# user_project_wrapper_0.analog_io[35] 0.05479f
C6458 TOP_ROILIFNEURON_0.MEM a_192738_326465# 0.00499f
C6459 a_74035_360458# a_74365_360458# 0.37213f
C6460 a_211921_326677# a_210007_326377# 0
C6461 a_191438_325263# a_191234_326377# 0.00165f
C6462 a_190824_325263# a_189672_324776# 0.01039f
C6463 a_191234_325263# a_191438_326377# 0.00165f
C6464 a_190304_110495# QDLL_TOP_0.CPIN 0.00327f
C6465 w_207887_326203# a_210645_324119# 0
C6466 a_190862_108410# a_191417_108495# 0.04298f
C6467 w_207989_323975# a_209940_324686# 0.09549f
C6468 a_304375_364458# a_305035_364458# 0.02109f
C6469 user_project_wrapper_0.sg13g2_IOPadAnalog_9.padres a_79038_134832# 0.16101f
C6470 a_210645_324119# a_210621_325263# 0.0021f
C6471 a_211921_325358# a_211921_325570# 0.01085f
C6472 user_project_wrapper_0.VDD2 a_182218_56308# -0
C6473 a_191234_329719# a_192738_330026# 0
C6474 a_190297_329719# a_189858_329719# 0
C6475 a_208939_328605# a_208367_326377# 0
C6476 user_project_wrapper_0.VDD1 a_85989_241383# 0.34867f
C6477 a_189921_330851# a_188834_326341# 0.00312f
C6478 user_project_wrapper_0.sg13g2_IOPadAnalog_17.padres a_188888_330851# 0.00404f
C6479 user_project_wrapper_0.VDD1 user_project_wrapper_0.sg13g2_IOPadAnalog_15.padres 2.15788f
C6480 user_project_wrapper_0.IOVDD2 a_121105_39542# 0.01881f
C6481 m1_81998_130507# a_79025_138251# 0.00368f
C6482 a_188802_330987# a_188888_331343# 0.00565f
C6483 a_79025_129571# m1_82112_127957# 0
C6484 user_project_wrapper_0.IOVDD1 a_35456_76015# 0.01409f
C6485 a_75355_364458# user_project_wrapper_0.IOVDD4 0.01409f
C6486 TOP_ROILIFNEURON_0.MEM a_210007_325263# 0
C6487 a_35542_80305# a_35542_79975# 0.37213f
C6488 a_360372_78985# VDD3 0.00198f
C6489 user_project_wrapper_0.sg13g2_IOPadAnalog_1.padres a_343292_141418# 0.0512f
C6490 a_82348_128838# user_project_wrapper_0.sg13g2_IOPadIn$1_0.p2c 0.00402f
C6491 a_208367_325263# a_209230_324119# 0.00131f
C6492 a_208367_328605# a_209905_328605# 0.00477f
C6493 a_208939_328605# a_210109_328605# 0
C6494 user_project_wrapper_0.IOVDD1 a_35456_305035# 0.01567f
C6495 a_35542_78655# a_35542_78325# 0.37213f
C6496 a_85287_241383# a_82846_241091# 0.00631f
C6497 user_project_wrapper_0.sg13g2_IOPadIn$1_1.p2c a_85989_241383# 0.00869f
C6498 TOP_ROILIFNEURON_0.MEM a_211921_328225# 0.00499f
C6499 m2_81563_127336# user_project_wrapper_0.sg13g2_IOPadAnalog_8.padres 0.00446f
C6500 a_57810_180219# user_project_wrapper_0.sg13g2_IOPadOut4mA$1_0.sg13g2_GateLevelUpInv_noptap$1$1_0.ngate 0.01958f
C6501 a_190757_324686# a_187364_324106# 0
C6502 a_211921_330453# a_211921_330241# 0.01085f
C6503 a_209684_329719# a_209684_328605# 0.07618f
C6504 a_78824_124371# user_project_wrapper_0.sg13g2_IOPadAnalog_9.padres 0.08679f
C6505 a_309516_194555# user_project_wrapper_0.sg13g2_IOPadAnalog_29.padres 0.2406f
C6506 a_210621_329719# a_211537_330026# 0.0091f
C6507 a_304196_197873# a_296625_189595# 8.39194f
C6508 a_209480_329719# a_208367_328605# 0.00246f
C6509 a_307232_196607# a_296731_189665# 1.93931f
C6510 a_209940_324686# a_208855_324776# 0.40357f
C6511 a_78220_128592# a_78220_128106# 0.01273f
C6512 a_86594_129426# a_88274_129061# 0.00441f
C6513 a_87434_129426# a_86594_129061# 0
C6514 TOP_ROILIFNEURON_0.MEM a_191970_327798# 0.0011f
C6515 a_41636_205261# a_41476_197044# 0.01916f
C6516 a_57810_180219# a_58798_179951# 0.14668f
C6517 a_210307_324119# a_211928_324776# 0
C6518 a_210645_324119# a_211321_324119# 0
C6519 a_209940_324686# a_209997_324870# 0.00596f
C6520 a_188888_331343# a_188834_327918# 0
C6521 w_188704_327938# a_190926_327491# 0
C6522 a_305619_187719# user_project_wrapper_0.sg13g2_IOPadAnalog_1.padres 0.16157f
C6523 user_project_wrapper_0.IOVDD1 a_35542_300415# 0
C6524 a_187294_90472# a_187852_90557# 0.04279f
C6525 a_186731_92558# a_188966_92557# 0
C6526 a_82872_125209# m2_83010_126180# 0.011f
C6527 a_189921_331163# a_188802_330987# 0.02034f
C6528 a_191754_330987# TOP_ROILIFNEURON_0.MEM 0.00186f
C6529 a_83592_125209# user_project_wrapper_0.sg13g2_IOPadIn$1_0.p2c 0.02875f
C6530 a_79025_131334# a_79038_130492# 0.70614f
C6531 a_86594_130470# a_86507_129255# 0.06764f
C6532 a_210417_325263# a_210621_326377# 0.00165f
C6533 a_210007_325263# a_208855_324776# 0.01039f
C6534 a_85435_125173# a_85875_125209# 0.3249f
C6535 a_85211_124842# a_87468_125419# 0.0218f
C6536 a_82667_125418# a_82974_125209# 0.00793f
C6537 a_82826_124842# a_82770_125209# 0.02303f
C6538 w_188806_323975# a_191124_324119# 0.23842f
C6539 w_188704_326203# a_191800_324119# 0
C6540 a_360458_305035# a_360458_304705# 0.37213f
C6541 a_77665_360458# user_project_wrapper_0.IOVDD4 0
C6542 a_191970_326892# a_190297_326377# 0
C6543 a_192354_326892# a_190501_326377# 0
C6544 a_189286_326377# a_189756_326377# 0
C6545 a_305695_35542# a_305695_35456# 0.03774f
C6546 a_85211_124842# user_project_wrapper_0.VDD1 0.82958f
C6547 QDLL_TOP_0.VDD a_269931_100182# 0.23003f
C6548 TOP_ROILIFNEURON_0.MEM a_191438_328605# 0.121f
C6549 a_360458_77995# a_360458_77665# 0.37213f
C6550 user_project_wrapper_0.sg13g2_IOPadAnalog_8.padres a_85591_241748# 0.00143f
C6551 a_121105_39542# a_121435_35542# 0.03774f
C6552 a_120775_35456# a_121435_35456# 0.02109f
C6553 a_188888_331163# user_project_wrapper_0.sg13g2_IOPadAnalog_17.padres 0.03143f
C6554 m1_85051_241246# a_82846_241091# 0.01204f
C6555 TOP_ROILIFNEURON_0.MEM a_212178_330987# 0.0091f
C6556 a_191438_325263# a_191970_325358# 0.00193f
C6557 user_project_wrapper_0.sg13g2_IOPadIOVdd_1.sg13g2_Clamp_N43N43D4R_0.gate user_project_wrapper_0.sg13g2_IOPadIOVdd_1.sg13g2_RCClampResistor_0.p2 22.6715f
C6558 user_project_wrapper_0.VDD2 a_116485_39542# 0.00199f
C6559 user_project_wrapper_0.VDD1 a_91090_129060# 0
C6560 a_35542_302725# a_35542_302395# 0.37213f
C6561 user_project_wrapper_0.sg13g2_IOPadAnalog_17.padres a_188988_324119# 0
C6562 a_189756_325263# a_189609_324119# 0.0033f
C6563 a_189184_325263# a_190455_324119# 0.0018f
C6564 a_190501_329719# a_192354_329814# 0
C6565 a_189756_329719# a_189756_328605# 0.25935f
C6566 a_83796_129203# a_84288_130212# 0.10424f
C6567 user_project_wrapper_0.sg13g2_IOPadAnalog_17.padres a_189756_328605# 0.00777f
C6568 user_project_wrapper_0.IOVDD2 a_156244_41476# 58.9173f
C6569 a_83398_130212# a_83925_130212# 0.08253f
C6570 a_76345_360458# a_76675_360458# 0.37213f
C6571 a_190824_325263# a_190297_326377# 0
C6572 a_189286_325785# a_189184_326377# 0.04925f
C6573 a_189858_325785# a_189756_326377# 0.04179f
C6574 a_190297_325263# a_190824_326377# 0
C6575 a_73375_360458# a_73705_360458# 0.37213f
C6576 TOP_ROILIFNEURON_0.MEM a_211537_325358# 0.00168f
C6577 a_191438_328605# a_191970_328693# 0.002f
C6578 a_189748_108410# a_190304_108495# 0.04298f
C6579 w_207989_323975# a_211537_325358# 0
C6580 w_207887_326203# a_208171_324119# 0.00157f
C6581 user_project_wrapper_0.analog_io[15] a_190287_102497# 0
C6582 a_190218_102763# a_190490_102497# 0.01008f
C6583 a_303715_364458# a_304375_364458# 0.02109f
C6584 user_project_wrapper_0.sg13g2_IOPadAnalog_9.padres a_78219_136982# 0.01215f
C6585 a_207985_330987# a_208017_326341# 0
C6586 a_190501_329719# a_190501_328605# 0.07618f
C6587 a_189184_329719# a_190297_328605# 0.00102f
C6588 a_189756_329719# a_190824_328605# 0
C6589 a_91090_129060# user_project_wrapper_0.sg13g2_IOPadIn$1_1.p2c 0.00115f
C6590 a_189756_327491# a_191234_327491# 0
C6591 a_189184_327491# a_190824_327491# 0.38483f
C6592 a_190501_327491# a_190297_327491# 0.83555f
C6593 user_project_wrapper_0.sg13g2_IOPadAnalog_17.padres a_190824_328605# 0
C6594 a_78824_128711# user_project_wrapper_0.sg13g2_IOPadAnalog_9.padres 0.07869f
C6595 user_project_wrapper_0.sg13g2_IOPadAnalog_21.padres a_207638_330987# 0
C6596 a_208103_324155# a_210007_326377# 0
C6597 a_207638_331163# a_207638_331343# 0.02961f
C6598 user_project_wrapper_0.IOVDD2 a_119785_39542# 0.01881f
C6599 a_364458_73375# a_360458_73375# 0.03774f
C6600 VDD3 a_343292_263818# 0
C6601 user_project_wrapper_0.IOVDD1 a_57810_282219# 0.87642f
C6602 a_74035_364458# user_project_wrapper_0.IOVDD4 0.01409f
C6603 a_209684_328605# a_210109_328013# 0
C6604 user_project_wrapper_0.IOVDD1 a_35456_77335# 0.01409f
C6605 a_35542_80965# a_35542_80635# 0.37213f
C6606 a_360372_80305# VDD3 0.00175f
C6607 w_188704_326203# a_191970_325997# 0.0018f
C6608 a_83492_130212# user_project_wrapper_0.sg13g2_IOPadIn$1_0.p2c 0.00103f
C6609 user_project_wrapper_0.VDD2 a_119125_39542# 0.00238f
C6610 a_209684_328605# a_210621_328605# 0.00395f
C6611 a_211921_329814# a_211921_329332# 0.0031f
C6612 a_35542_79315# a_35542_78985# 0.37213f
C6613 user_project_wrapper_0.sg13g2_IOPadAnalog_25.padres a_343292_243418# 0.0512f
C6614 user_project_wrapper_0.sg13g2_IOPadAnalog_14.padres a_82846_240684# 0.2538f
C6615 m1_6878_10238# m2_6878_10238# 1.04272p
C6616 a_313884_185173# a_311108_179669# 7.72255f
C6617 a_187914_99087# user_project_wrapper_0.analog_io[13] 0
C6618 a_209684_329719# a_209041_329719# 0
C6619 a_210417_329719# a_211537_330026# 0
C6620 a_210007_329719# a_211921_330026# 0
C6621 a_210621_329719# a_211153_330453# 0.002f
C6622 user_project_wrapper_0.VDD1 a_35542_74365# 0
C6623 a_115444_355624# user_project_wrapper_0.analog_io[27] 25.1197f
C6624 a_301940_196388# a_296731_189665# 0.00896f
C6625 a_211537_325358# a_208855_324776# 0.00141f
C6626 a_304995_198817# a_304196_200821# 6.82922f
C6627 a_311108_215937# a_313884_211353# 7.72255f
C6628 a_211921_325358# a_211928_324776# 0.00339f
C6629 a_209638_324119# a_209940_324686# 0.02904f
C6630 a_189756_325263# a_190824_325263# 0.01814f
C6631 a_189184_325263# a_189286_325785# 0.22414f
C6632 a_188834_326341# a_190297_325263# 0
C6633 user_project_wrapper_0.sg13g2_IOPadAnalog_17.padres a_190501_325263# 0
C6634 user_project_wrapper_0.IOVDD1 a_35542_301735# 0
C6635 user_project_wrapper_0.sg13g2_IOPadAnalog_9.padres a_79038_127856# 0
C6636 a_208017_326341# a_208367_328605# 0.02896f
C6637 a_208939_329719# a_208939_328605# 0.25935f
C6638 a_208939_325263# a_209684_328605# 0.02017f
C6639 a_85875_125209# user_project_wrapper_0.sg13g2_IOPadIn$1_0.p2c 0
C6640 user_project_wrapper_0.sg13g2_IOPadAnalog_21.padres a_208939_328605# 0.17489f
C6641 a_84707_131750# a_85127_131750# 0.10061f
C6642 a_79025_131741# a_78824_130881# 0.0506f
C6643 a_305365_360372# a_305365_360458# 0.03774f
C6644 a_209684_325263# a_209940_324686# 0.00141f
C6645 a_209480_325263# a_209869_324119# 0
C6646 a_82826_124842# a_85435_125173# 0
C6647 a_82667_125418# a_85257_125209# 0
C6648 user_project_wrapper_0.sg13g2_IOPadOut4mA$1_0.sg13g2_GateLevelUpInv_noptap$1$1_0.ngate a_57810_179517# 0.24368f
C6649 TOP_ROILIFNEURON_0.MEM a_192354_329814# 0.00168f
C6650 w_188704_326203# a_189396_324119# 0
C6651 a_189148_101407# QDLL_TOP_0.VDD 0.24901f
C6652 user_project_wrapper_0.VDD1 a_59490_159238# 1.1848f
C6653 a_76345_360458# user_project_wrapper_0.IOVDD4 0
C6654 a_360458_305695# a_360458_305365# 0.37213f
C6655 a_191462_324119# a_192138_324119# 0
C6656 a_190757_324686# a_190814_324870# 0.00596f
C6657 a_191124_324119# a_192745_324776# 0
C6658 user_project_wrapper_0.VDD1 a_58798_179249# 1.36886f
C6659 a_58798_179951# a_57810_179517# 0.00367f
C6660 a_190218_98097# user_project_wrapper_0.analog_io[13] 0.00165f
C6661 a_78824_126541# a_78220_128106# 0.00986f
C6662 a_305035_35542# a_305035_35456# 0.03774f
C6663 user_project_wrapper_0.IOVDD1 a_41476_197044# 58.9173f
C6664 a_78221_125094# user_project_wrapper_0.VDD1 0.50594f
C6665 TOP_ROILIFNEURON_0.MEM a_190501_328605# 0
C6666 a_82433_130212# a_79025_131741# 0.00268f
C6667 user_project_wrapper_0.IOVDD2 a_115825_39542# 0.01881f
C6668 a_120445_39542# a_120775_35542# 0.03774f
C6669 a_120115_35456# a_120775_35456# 0.02109f
C6670 a_93461_128591# a_87105_130835# 0.00234f
C6671 a_360458_78655# a_360458_78325# 0.37213f
C6672 w_188704_327938# a_190722_329327# 0
C6673 TOP_ROILIFNEURON_0.MEM a_192995_330987# 0.0091f
C6674 a_209904_331163# a_210051_330987# 0.03813f
C6675 a_190501_325263# a_191970_325358# 0
C6676 a_190297_325263# a_190926_325263# 0.01814f
C6677 a_190824_325263# a_190722_325263# 0.1023f
C6678 a_209684_325263# a_210007_325263# 0.35388f
C6679 w_207883_330166# a_210051_330987# 0
C6680 user_project_wrapper_0.VDD2 a_115165_39542# 0.00299f
C6681 a_237844_369296# user_project_wrapper_0.analog_io[33] 9.69836f
C6682 a_35542_303385# a_35542_303055# 0.37213f
C6683 a_190501_329719# a_191970_330026# 0
C6684 a_189756_325263# a_189858_329719# 0.01743f
C6685 a_79025_125231# a_83070_130577# 0.10649f
C6686 a_82746_130212# a_82433_130212# 0.02784f
C6687 user_project_wrapper_0.sg13g2_IOPadIn$1_2.p2c a_202114_326125# 0.05002f
C6688 a_82846_241091# a_82846_243261# 0.00468f
C6689 a_75685_360458# a_76015_360458# 0.37213f
C6690 TOP_ROILIFNEURON_0.MEM a_210417_326377# 0.00567f
C6691 user_project_wrapper_0.sg13g2_IOPadAnalog_15.padres a_82645_242401# 0.05069f
C6692 a_190824_328605# a_192354_328905# 0
C6693 a_188632_108410# a_189190_108495# 0.04255f
C6694 a_303055_364458# a_303715_364458# 0.02109f
C6695 a_187018_328627# a_189184_328605# 0
C6696 a_194279_327536# a_194687_324142# 4.49535f
C6697 a_58798_281951# a_58798_281249# 0.00123f
C6698 user_project_wrapper_0.sg13g2_IOPadOut4mA$1_1.c2p a_58170_281249# 0.12491f
C6699 a_35542_80635# user_project_wrapper_0.IOVDD1 0
C6700 a_190954_331163# a_190954_331343# 0.12339f
C6701 user_project_wrapper_0.IOVDD2 a_118465_39542# 0.01881f
C6702 a_360458_74365# a_360458_74035# 0.37213f
C6703 TOP_ROILIFNEURON_0.MEM a_211537_326465# 0.00168f
C6704 user_project_wrapper_0.IOVDD1 a_35456_78655# 0.01409f
C6705 a_208939_328605# a_209480_327491# 0.00139f
C6706 a_208367_328605# a_209684_327491# 0
C6707 a_209684_328605# a_208367_327491# 0
C6708 w_188704_326203# a_190297_325263# 0.08768f
C6709 user_project_wrapper_0.VDD2 a_117805_39542# 0.00238f
C6710 a_87105_130835# a_92512_127896# 0
C6711 a_208367_328605# a_209480_328605# 0.64006f
C6712 a_208939_328605# a_210007_328605# 0.01489f
C6713 a_211537_326465# a_211537_325997# 0.00322f
C6714 a_191438_325263# a_192138_324119# 0.00257f
C6715 a_35456_297775# a_35542_298105# 0.03774f
C6716 a_190926_328013# a_190926_327491# 0
C6717 TOP_ROILIFNEURON_0.MEM a_211921_329814# 0.00497f
C6718 w_207887_326203# a_208367_328605# 0
C6719 a_210417_326377# a_208855_324776# 0
C6720 a_208103_324155# a_209905_325263# 0
C6721 a_296626_197740# a_304196_200821# 0.33018f
C6722 a_301186_192011# a_304196_197873# 0
C6723 a_296625_208423# a_304889_199957# 0.06973f
C6724 a_304090_197941# a_304995_198817# 0.13976f
C6725 a_301940_196388# a_307232_196607# 0.03714f
C6726 user_project_wrapper_0.VDD1 a_35542_75685# 0
C6727 a_206547_324106# a_206201_328627# 0.28931f
C6728 a_189756_326377# a_188920_324155# 1.04211f
C6729 a_208171_324119# a_208792_324119# 0.00811f
C6730 a_209104_331343# a_207985_330987# 0.00565f
C6731 a_355624_237844# a_355784_246061# 0.01916f
C6732 a_82859_242012# user_project_wrapper_0.analog_io[4] 0
C6733 user_project_wrapper_0.IOVDD1 a_35542_303055# 0
C6734 user_project_wrapper_0.sg13g2_IOPadAnalog_18.padres user_project_wrapper_0.analog_io[30] 0.33583f
C6735 a_176644_369296# a_184861_369456# 0.01778f
C6736 a_189756_328605# a_189858_327491# 0.02134f
C6737 a_82826_124842# user_project_wrapper_0.sg13g2_IOPadIn$1_0.p2c 0.70983f
C6738 a_208939_325263# a_209041_329719# 0.01743f
C6739 user_project_wrapper_0.analog_io[11] user_project_wrapper_0.IOVDD2 0.10967p
C6740 a_79038_132662# a_79038_132196# 0.04646f
C6741 a_78220_132587# a_78220_130691# 0.01752f
C6742 a_79025_133504# a_79025_131741# 0.09651f
C6743 user_project_wrapper_0.sg13g2_IOPadAnalog_6.padres a_190584_97917# 0
C6744 a_211153_326677# a_211153_326892# 0.01056f
C6745 a_211921_326465# a_210621_326377# 0
C6746 a_83492_127455# a_86507_129255# 0.15356f
C6747 user_project_wrapper_0.sg13g2_IOPadOut4mA$1_1.c2p a_87832_241383# 0.12339f
C6748 a_209684_325263# a_211537_325358# 0
C6749 TOP_ROILIFNEURON_0.MEM a_191970_330026# 0.00113f
C6750 a_190490_102497# QDLL_TOP_0.VDD 0.22591f
C6751 a_29836_246061# a_29676_237844# 0.01778f
C6752 a_190455_324119# a_190757_324686# 0.02904f
C6753 a_314697_196700# a_315347_192734# 0.0013f
C6754 a_304375_35542# a_304375_35456# 0.03774f
C6755 a_83070_130577# a_79025_133911# 0.00192f
C6756 a_208367_326377# a_210007_326377# 0.3836f
C6757 user_project_wrapper_0.IOVDD2 a_114505_39542# 0.01881f
C6758 a_209684_326377# a_209480_326377# 0.83555f
C6759 a_119785_39542# a_120115_35542# 0.03774f
C6760 a_119455_35456# a_120115_35456# 0.02109f
C6761 a_360458_79315# a_360458_78985# 0.37213f
C6762 w_188700_330166# a_189184_328605# 0.00168f
C6763 user_project_wrapper_0.analog_io[13] a_190862_108410# 0.00725f
C6764 a_301423_196360# VDD3 1.8093f
C6765 a_191438_325263# a_192354_325997# 0
C6766 a_190824_325263# a_191970_325785# 0
C6767 a_313884_185173# VDD3 0.16347f
C6768 a_191438_326377# a_189756_327491# 0
C6769 a_187018_328627# a_188920_324155# 0.02167f
C6770 a_190722_327099# a_190501_327491# 0
C6771 a_190501_329719# a_191438_329719# 0.00396f
C6772 a_191234_326377# a_191234_327491# 0.03297f
C6773 a_269799_100118# a_270178_100118# 0.00555f
C6774 a_88393_125210# a_86507_129255# 0
C6775 a_189184_328605# a_189286_328605# 0.23056f
C6776 a_364458_301075# IOVDD3 0.01563f
C6777 a_190824_328605# a_191970_329120# 0
C6778 a_190297_328605# a_192354_329120# 0
C6779 a_187518_108410# a_188074_108495# 0.04298f
C6780 a_302395_364458# a_303055_364458# 0.02109f
C6781 a_190954_330851# a_190824_328605# 0
C6782 a_190297_329719# a_190824_329719# 0.20539f
C6783 a_187294_90472# user_project_wrapper_0.analog_io[13] 0.04373f
C6784 a_116155_35456# a_116815_35456# 0.02109f
C6785 a_116485_39542# a_116815_35542# 0.03774f
C6786 VDD3 a_343292_161818# 0
C6787 a_192995_330987# a_192995_330851# 0.07033f
C6788 a_79038_123982# a_79025_125231# 0.01108f
C6789 user_project_wrapper_0.IOVDD2 a_117145_39542# 0.01881f
C6790 a_210621_329719# a_211153_329120# 0
C6791 a_208103_324155# a_209041_329327# 0
C6792 a_191234_325263# a_191124_324119# 0.00283f
C6793 a_191438_327491# a_191970_328013# 0.00381f
C6794 TOP_ROILIFNEURON_0.MEM a_211537_330026# 0.01062f
C6795 w_207883_330166# a_210109_329719# 0
C6796 a_364458_301075# a_364458_300415# 0.02109f
C6797 a_360372_300745# a_360458_300745# 0.03774f
C6798 a_190584_102855# QDLL_TOP_0.CPIN 0.00546f
C6799 user_project_wrapper_0.VDD1 a_35542_77005# -0
C6800 a_301186_192011# a_309516_194555# 0.03439f
C6801 a_296626_197740# a_304090_197941# 0.44101f
C6802 user_project_wrapper_0.sg13g2_IOPadAnalog_19.padres a_189184_327491# 0.05592f
C6803 a_84332_125209# a_91090_127530# 0.024f
C6804 a_35456_298435# a_35542_298435# 0.03774f
C6805 a_39542_298765# a_39542_298105# 0.02109f
C6806 a_364458_74695# IOVDD3 0.01409f
C6807 a_79025_133911# a_78824_133051# 0.04905f
C6808 a_82846_242854# user_project_wrapper_0.analog_io[4] 0.25149f
C6809 a_190824_325263# a_190926_326377# 0.00167f
C6810 a_79025_129164# a_79025_131741# 0
C6811 a_89114_129426# a_86507_129255# 0.01093f
C6812 user_project_wrapper_0.sg13g2_IOPadOut4mA$1_1.c2p a_85591_241748# 0
C6813 a_79025_126994# a_78221_125094# 0.25145f
C6814 a_78824_126541# a_79038_125686# 0
C6815 TOP_ROILIFNEURON_0.MEM a_191438_329719# 0.12104f
C6816 w_188700_330166# a_188920_324155# 0.02201f
C6817 a_91911_129060# a_92512_129426# 0.11001f
C6818 a_188988_324119# a_189609_324119# 0.00811f
C6819 a_303715_35542# a_303715_35456# 0.03774f
C6820 a_79025_125231# a_79025_136081# 0.06677f
C6821 a_119125_39542# a_119455_35542# 0.03774f
C6822 a_118795_35456# a_119455_35456# 0.02109f
C6823 a_83079_128838# a_82433_130212# 0.00302f
C6824 a_83389_129203# a_83070_130577# 0
C6825 a_92512_129426# user_project_wrapper_0.sg13g2_IOPadOut4mA$1_0.c2p 0
C6826 a_82658_129203# a_79025_125231# 0
C6827 a_190389_99046# user_project_wrapper_0.analog_io[14] 0.93718f
C6828 a_360458_79975# a_360458_79645# 0.37213f
C6829 a_88274_129426# a_87105_130835# 0.00176f
C6830 a_190824_325263# a_191438_325263# 0.01253f
C6831 a_268697_100118# a_269079_100182# 0.00311f
C6832 user_project_wrapper_0.sg13g2_IOPadIn$1_2.p2c user_project_wrapper_0.sg13g2_IOPadAnalog_19.padres 0
C6833 user_project_wrapper_0.sg13g2_IOPadAnalog_6.padres a_268967_100118# 0.02608f
C6834 user_project_wrapper_0.analog_io[13] a_188632_108410# 0.00726f
C6835 a_188296_101407# QDLL_TOP_0.VOUT 0.00207f
C6836 IOVDD3 a_364458_297775# 0.01588f
C6837 a_301509_202742# VDD3 0.00511f
C6838 user_project_wrapper_0.sg13g2_IOPadAnalog_21.padres a_202114_326125# 0.01576f
C6839 a_369296_115444# analog_io[18] 9.69836f
C6840 a_189756_326377# a_190501_327491# 0
C6841 a_189184_326377# a_189184_327491# 0.25139f
C6842 a_190501_326377# a_189756_327491# 0.00209f
C6843 a_299095_360458# user_project_wrapper_0.IOVDD4 0
C6844 VDD3 IOVDD3 0.15699p
C6845 a_190297_328605# a_189858_329327# 0
C6846 a_190501_328605# a_190722_329327# 0.01614f
C6847 a_364458_302395# IOVDD3 0.01567f
C6848 user_project_wrapper_0.IOVDD1 user_project_wrapper_0.analog_io[7] 0.10967p
C6849 a_186397_108409# a_186960_108495# 0.05559f
C6850 a_211153_328693# a_210621_327491# 0
C6851 a_301735_364458# a_302395_364458# 0.02109f
C6852 a_87434_127896# a_85127_131750# 0
C6853 a_82840_127455# a_79025_131741# 0.08015f
C6854 a_210621_328605# a_211537_328693# 0
C6855 a_211153_329120# a_211153_328905# 0.01056f
C6856 user_project_wrapper_0.VDD1 user_project_wrapper_0.sg13g2_IOPadIn$1_0.sg13g2_LevelDown_noptap$1_0.sg13g2_SecondaryProtection$1$1_0.core 0.56648f
C6857 a_115495_35456# a_116155_35456# 0.02109f
C6858 a_115825_39542# a_116155_35542# 0.03774f
C6859 a_91911_129060# a_91911_127530# 0.00852f
C6860 a_83492_127455# a_83586_127455# 0.11006f
C6861 a_208103_324155# a_209041_327491# 0
C6862 a_207985_330987# a_209104_330987# 0.05294f
C6863 a_79645_360372# a_80305_360372# 0.02109f
C6864 a_79975_364458# a_80305_360458# 0.03774f
C6865 TOP_ROILIFNEURON_0.MEM a_190297_327491# 0
C6866 a_189184_328605# a_189286_326377# 0
C6867 a_79025_127401# a_83164_127820# 0.10502f
C6868 user_project_wrapper_0.sg13g2_IOPadAnalog_21.padres a_210007_326377# 0
C6869 a_304889_198885# a_304196_197873# 1.4451f
C6870 user_project_wrapper_0.sg13g2_IOPadIn$1_2.sg13g2_LevelDown_noptap$1_0.sg13g2_SecondaryProtection$1$1_0.core user_project_wrapper_0.sg13g2_IOPadIn$1_2.p2c 0.10336f
C6871 user_project_wrapper_0.sg13g2_IOPadIn$1_2.p2c a_189184_326377# 0
C6872 a_78220_123062# a_79038_123982# 0
C6873 a_79025_124824# a_79038_123516# 0.71261f
C6874 TOP_ROILIFNEURON_0.MEM a_211153_330453# 0.00105f
C6875 user_project_wrapper_0.VDD2 a_223018_56308# -0
C6876 a_364458_301735# a_364458_301075# 0.02109f
C6877 a_360372_301405# a_360458_301405# 0.03774f
C6878 a_39542_79645# user_project_wrapper_0.VDD1 0
C6879 a_208103_324155# a_208469_325785# 0
C6880 a_355784_225661# IOVDD3 1.92793f
C6881 a_209905_326377# a_209684_326377# 0.05425f
C6882 a_210109_326377# a_208367_326377# 0.026f
C6883 a_208469_326377# a_210007_326377# 0
C6884 a_189184_325263# a_189184_327491# 0.16124f
C6885 a_188834_327918# a_189756_327491# 0.00771f
C6886 user_project_wrapper_0.IOVDD2 a_305365_35542# 0
C6887 a_117475_35456# a_116815_35456# 0.02109f
C6888 a_300085_360458# a_300085_360372# 0.03774f
C6889 a_115444_369296# user_project_wrapper_0.analog_io[27] 9.69836f
C6890 a_87434_127896# a_89114_127531# 0.02463f
C6891 a_82527_127455# a_83586_127455# 0.02421f
C6892 a_91090_127895# a_91911_127530# 0.10325f
C6893 user_project_wrapper_0.sg13g2_IOPadAnalog_22.padres user_project_wrapper_0.IOVDD4 1.36563f
C6894 a_35456_299095# a_35542_299095# 0.03774f
C6895 a_39542_299425# a_39542_298765# 0.02109f
C6896 a_364458_76015# IOVDD3 0.01409f
C6897 a_79025_136081# a_79025_133911# 0.7609f
C6898 a_78824_135221# a_79038_134366# 0
C6899 a_208071_330851# a_208103_324155# 0
C6900 a_79025_138251# a_79025_131741# 0.07098f
C6901 a_79025_135674# a_78219_134797# 0.25143f
C6902 a_82658_129203# a_79025_133911# 0.16706f
C6903 TOP_ROILIFNEURON_0.MEM a_194687_324142# 0
C6904 VDD3 analog_io[26] 19.8007f
C6905 a_189184_328605# a_190722_328013# 0
C6906 a_89953_129061# a_86507_127725# 0.05025f
C6907 a_83492_127455# a_90579_129060# 0.11173f
C6908 a_35456_305695# a_35542_305695# 0.03774f
C6909 w_188700_330166# a_190926_330241# 0.01287f
C6910 w_207887_326203# a_205385_326221# 0
C6911 a_188184_101343# user_project_wrapper_0.sg13g2_IOPadAnalog_6.padres 0.00409f
C6912 a_189016_101343# a_189395_101343# 0.00555f
C6913 a_314793_201808# a_315347_192734# 0.01473f
C6914 a_309516_194555# a_315347_192648# 0.00252f
C6915 a_303055_35542# a_303055_35456# 0.03774f
C6916 a_82746_130212# a_79025_138251# 0.00197f
C6917 a_208103_324155# a_209940_324686# 0
C6918 user_project_wrapper_0.sg13g2_IOPadIn$1_2.p2c a_189184_325263# 0
C6919 a_190824_326377# a_189672_324776# 0
C6920 a_191234_326377# a_191438_326377# 0.43471f
C6921 a_118465_39542# a_118795_35542# 0.03774f
C6922 a_118135_35456# a_118795_35456# 0.02109f
C6923 a_189148_99070# a_189395_99046# 0.24485f
C6924 a_83492_130212# a_83398_130212# 0.11341f
C6925 a_188296_99070# a_188184_99046# 0.55452f
C6926 a_360458_80635# a_360458_80305# 0.37213f
C6927 a_83070_130212# a_83796_129203# 0
C6928 a_190501_325263# a_190824_325263# 0.35388f
C6929 user_project_wrapper_0.analog_io[13] a_186397_108409# 0.02661f
C6930 IOVDD3 a_364458_299095# 0.01447f
C6931 a_296625_208423# VDD3 30.4114f
C6932 a_209480_326377# a_210007_327491# 0
C6933 a_192738_328693# a_194193_328627# 0
C6934 a_190501_328605# a_190926_329719# 0
C6935 a_210007_326377# a_209480_327491# 0
C6936 a_191987_330851# a_191970_330453# 0.00331f
C6937 a_188834_326341# a_190297_329719# 0.00141f
C6938 a_189756_325263# a_190824_329719# 0.00161f
C6939 a_297775_360458# user_project_wrapper_0.IOVDD4 0.06232f
C6940 a_208103_324155# a_210007_325263# 0.00133f
C6941 a_29676_258244# user_project_wrapper_0.analog_io[7] 9.69836f
C6942 m2_81563_127336# a_79025_125231# 0
C6943 TOP_ROILIFNEURON_0.MEM a_209480_326377# 0
C6944 a_87775_125210# a_86507_127725# 0.023f
C6945 a_364458_303715# IOVDD3 0.01452f
C6946 a_190824_327491# a_190722_327491# 0.1023f
C6947 a_190297_327491# a_190926_327491# 0.01814f
C6948 a_190501_327491# a_191970_327586# 0
C6949 a_301075_364458# a_301735_364458# 0.02109f
C6950 user_project_wrapper_0.analog_io[10] user_project_wrapper_0.IOVDD2 0.10967p
C6951 a_210007_328605# a_211921_328905# 0
C6952 a_209905_329327# a_209905_328605# 0
C6953 a_79038_128322# a_79025_131741# 0.00175f
C6954 a_211537_329332# a_211537_329120# 0.01085f
C6955 user_project_wrapper_0.VDD1 a_78824_130881# 2.73558f
C6956 a_114835_35456# a_115495_35456# 0.02109f
C6957 a_115165_39542# a_115495_35542# 0.03774f
C6958 a_83492_127455# a_89953_127531# 0
C6959 a_35456_81295# a_35542_81295# 0.03774f
C6960 TOP_ROILIFNEURON_0.MEM a_211537_328905# 0.01123f
C6961 a_189729_99046# a_190490_98199# 0
C6962 w_188704_327938# a_189184_327491# 0.23685f
C6963 w_207887_327938# a_211921_328693# 0.0018f
C6964 a_191751_90558# a_192309_90557# 0.06619f
C6965 user_project_wrapper_0.sg13g2_IOPadAnalog_22.padres a_208939_326377# 0.00534f
C6966 a_208017_327918# a_206547_324106# 0.00188f
C6967 a_208367_325263# a_208939_326377# 0.0304f
C6968 a_87105_130835# a_89114_129061# 0
C6969 a_83070_130577# a_83389_128838# 0
C6970 a_209684_329719# a_210109_329327# 0
C6971 user_project_wrapper_0.VDD1 a_82433_130212# 0.37618f
C6972 a_296731_208493# a_301423_202742# 2.33177f
C6973 a_188834_326341# a_189672_324776# 0
C6974 a_189858_325785# a_188920_324155# 0
C6975 TOP_ROILIFNEURON_0.MEM a_213376_328627# 0.10442f
C6976 user_project_wrapper_0.sg13g2_IOPadAnalog_19.padres a_189286_327099# 0
C6977 a_360372_302065# a_360458_302065# 0.03774f
C6978 a_364458_302395# a_364458_301735# 0.02109f
C6979 w_207883_330166# a_209905_330241# 0.01266f
C6980 a_211153_325570# a_211153_325358# 0.01085f
C6981 a_39542_80965# user_project_wrapper_0.VDD1 0.00238f
C6982 a_189858_328605# a_189184_327491# 0.0018f
C6983 a_211153_327104# a_209684_326377# 0
C6984 a_87571_125210# a_84332_125209# 0
C6985 a_210621_326377# a_210007_326377# 0.01253f
C6986 user_project_wrapper_0.IOVDD2 a_304045_35542# 0
C6987 a_364458_75355# a_364458_74695# 0.02109f
C6988 a_360372_75025# a_360458_75025# 0.03774f
C6989 a_298765_35542# a_299095_35542# 0.37213f
C6990 a_299425_360458# a_299425_360372# 0.03774f
C6991 user_project_wrapper_0.VDD1 a_91090_127530# 0
C6992 user_project_wrapper_0.IOVDD4 a_278644_369296# 0.16358f
C6993 a_208017_327918# a_209684_329719# 0
C6994 a_188184_99046# QDLL_TOP_0.VDD 0.26601f
C6995 a_39542_300085# a_39542_299425# 0.02109f
C6996 a_35456_299755# a_35542_299755# 0.03774f
C6997 user_project_wrapper_0.sg13g2_IOPadAnalog_7.padres user_project_wrapper_0.IOVDD2 1.36563f
C6998 user_project_wrapper_0.IOVDD4 a_304375_364458# 0.0145f
C6999 a_364458_77335# IOVDD3 0.01409f
C7000 a_79025_138251# a_79038_134366# 0
C7001 a_79038_136536# a_79025_136081# 0.02826f
C7002 a_78219_135283# a_78824_135221# 0.00928f
C7003 a_79038_130026# a_78824_130881# 0
C7004 a_83389_129203# a_79025_136081# 0.00184f
C7005 user_project_wrapper_0.VDD1 user_project_wrapper_0.analog_io[6] 19.8007f
C7006 a_84598_130577# a_86594_130470# 0
C7007 a_78220_128592# a_79025_131334# 0.25156f
C7008 a_187364_324106# user_project_wrapper_0.analog_io[27] 0
C7009 a_190926_325263# a_189672_324776# 0
C7010 a_87434_129426# a_86507_127725# 0
C7011 a_83389_129203# a_82658_129203# 0.0561f
C7012 w_188704_327938# a_194193_328627# 0
C7013 a_190319_102855# user_project_wrapper_0.sg13g2_IOPadAnalog_6.padres 0.10704f
C7014 a_91090_127530# user_project_wrapper_0.sg13g2_IOPadIn$1_1.p2c 0.00115f
C7015 a_213376_328627# a_208855_324776# 0.28963f
C7016 a_302395_35542# a_302395_35456# 0.03774f
C7017 a_190501_326377# a_191234_326377# 0.00663f
C7018 a_189184_326377# a_189286_327099# 0.10231f
C7019 a_190297_326377# a_190824_326377# 0.20174f
C7020 a_189756_326377# a_189858_327099# 0.10231f
C7021 a_84598_130577# a_83796_129203# 0.01434f
C7022 user_project_wrapper_0.sg13g2_IOPadAnalog_19.padres a_189184_329719# 0.01189f
C7023 a_117805_39542# a_118135_35542# 0.03774f
C7024 a_117475_35456# a_118135_35456# 0.02109f
C7025 a_360458_81295# a_360458_80965# 0.37213f
C7026 a_187914_99087# a_188296_99070# 0.00311f
C7027 m1_82112_127957# a_79025_131741# 0
C7028 a_189184_328605# a_188920_324155# 0.05728f
C7029 a_364458_75355# VDD3 0
C7030 user_project_wrapper_0.analog_io[30] a_194687_324142# 18.338f
C7031 a_188888_330851# a_189286_330241# 0
C7032 user_project_wrapper_0.sg13g2_IOPadIn$1_2.p2c a_209940_324686# 0.00115f
C7033 a_82645_240231# a_82118_239118# 0.0726f
C7034 a_79025_125231# user_project_wrapper_0.sg13g2_IOPadAnalog_8.padres 0.07541f
C7035 a_57810_281517# a_58170_281249# 0.3766f
C7036 m1_82116_130103# a_79025_125231# 0
C7037 m1_81567_127343# a_79025_127401# 0
C7038 a_364458_305035# IOVDD3 0.01567f
C7039 a_88291_125210# a_86507_127725# 0.10685f
C7040 a_84288_130212# user_project_wrapper_0.sg13g2_IOPadIn$1_0.p2c 0.00202f
C7041 a_360372_298105# a_360458_298105# 0.03774f
C7042 a_364458_298435# a_364458_297775# 0.02109f
C7043 a_209041_328605# a_208939_327491# 0
C7044 a_208469_328605# a_208367_327491# 0.00181f
C7045 w_188704_326203# a_189672_324776# 0.00101f
C7046 a_190824_327491# a_191970_328013# 0
C7047 a_83796_128838# a_79025_133911# 0
C7048 a_87434_129061# a_85127_131750# 0.02398f
C7049 a_210007_328605# a_211537_329120# 0
C7050 a_210417_328605# a_211153_329120# 0
C7051 user_project_wrapper_0.VDD1 a_79025_133504# 1.75375f
C7052 a_209905_329719# a_208367_328605# 0
C7053 a_114505_39542# a_114835_35542# 0.03774f
C7054 a_208469_325785# a_208367_326377# 0.04925f
C7055 a_209041_325785# a_208939_326377# 0.04179f
C7056 a_114175_35456# a_114835_35456# 0.02109f
C7057 a_83079_128838# a_82840_127455# 0
C7058 a_93204_129062# a_93400_129062# 0.00876f
C7059 user_project_wrapper_0.VDD1 a_93461_128591# 0.6183f
C7060 TOP_ROILIFNEURON_0.MEM a_211153_329120# 0.0011f
C7061 a_186202_326221# user_project_wrapper_0.analog_io[27] 0.17614f
C7062 a_83490_125209# a_79025_125231# 0.00109f
C7063 a_315347_192734# VDD3 0.03341f
C7064 w_207887_327938# a_209041_328605# 0.01325f
C7065 a_190638_90558# a_191196_90557# 0.06619f
C7066 a_190287_102497# user_project_wrapper_0.analog_io[13] 0
C7067 a_188802_330987# a_190868_330987# 0.10143f
C7068 a_189858_328013# a_189756_328605# 0.03255f
C7069 a_296731_208493# a_301186_192011# 12.3478f
C7070 a_188834_326341# a_190297_326377# 0.00135f
C7071 a_189756_325263# a_190824_326377# 0.00366f
C7072 a_189184_325263# a_189286_327099# 0
C7073 user_project_wrapper_0.sg13g2_IOPadAnalog_17.padres a_190501_326377# 0
C7074 w_207887_326203# a_210109_325263# 0
C7075 a_210137_331163# a_209684_329719# 0
C7076 a_208017_326341# a_209041_328013# 0.01842f
C7077 a_208939_325263# a_209905_328013# 0.00175f
C7078 a_360372_302725# a_360458_302725# 0.03774f
C7079 a_364458_303055# a_364458_302395# 0.02109f
C7080 w_207883_330166# a_209480_329719# 0.08762f
C7081 a_211537_325785# a_211537_325570# 0.01056f
C7082 a_208367_329719# a_208469_329327# 0.0352f
C7083 a_208939_329719# a_209041_329327# 0.03526f
C7084 a_208939_325263# a_210109_329327# 0
C7085 a_369296_237844# IOVDD3 0.16358f
C7086 user_project_wrapper_0.analog_io[0] a_41476_115444# 25.1197f
C7087 user_project_wrapper_0.sg13g2_IOPadAnalog_21.padres a_209041_329327# 0.00867f
C7088 a_82974_125209# a_82527_127455# 0
C7089 a_87673_125210# a_84332_125209# 0
C7090 a_79038_123516# user_project_wrapper_0.VDD1 0.09349f
C7091 user_project_wrapper_0.IOVDD2 a_302725_35542# 0
C7092 a_210645_324119# a_206547_324106# 0
C7093 user_project_wrapper_0.IOVDD1 user_project_wrapper_0.analog_io[0] 0.10967p
C7094 a_189921_330987# a_189756_325263# 0
C7095 a_188802_330987# a_189756_329719# 0
C7096 a_360372_75685# a_360458_75685# 0.03774f
C7097 a_364458_76015# a_364458_75355# 0.02109f
C7098 a_298105_35542# a_298435_35542# 0.37213f
C7099 a_188802_330987# user_project_wrapper_0.sg13g2_IOPadAnalog_17.padres 0.06845f
C7100 a_298765_360458# a_298765_360372# 0.03774f
C7101 a_87434_127896# a_89114_127896# 0.05056f
C7102 a_190218_98097# a_190319_97955# 0.02609f
C7103 a_58170_179951# user_project_wrapper_0.sg13g2_IOPadOut4mA$1_0.c2p 0.12494f
C7104 user_project_wrapper_0.VDD1 a_92512_127896# 0.47465f
C7105 user_project_wrapper_0.IOVDD1 a_35542_298105# 0
C7106 a_39542_300745# a_39542_300085# 0.02109f
C7107 user_project_wrapper_0.IOVDD4 a_303055_364458# 0.01555f
C7108 a_35456_300415# a_35542_300415# 0.03774f
C7109 a_187914_99087# QDLL_TOP_0.VDD 0.34569f
C7110 w_188806_323975# user_project_wrapper_0.sg13g2_IOPadAnalog_19.padres 0.00149f
C7111 a_364458_78655# IOVDD3 0.01409f
C7112 user_project_wrapper_0.sg13g2_IOPadIn$1_2.p2c a_190757_324686# 0.00947f
C7113 a_369296_217444# analog_io[23] 9.69836f
C7114 a_210137_330851# a_209684_329719# 0
C7115 a_209104_330851# a_209480_329719# 0.00112f
C7116 a_78824_137391# a_79038_137002# 0.05038f
C7117 a_79025_137844# a_78219_136982# 0
C7118 a_79025_129571# a_79025_136081# 0.30708f
C7119 a_192354_325785# a_189672_324776# 0
C7120 a_210007_325263# a_208367_326377# 0
C7121 user_project_wrapper_0.sg13g2_IOPadAnalog_22.padres a_208017_326341# 0.0213f
C7122 a_208017_327918# a_208939_325263# 0.0024f
C7123 a_208367_325263# a_208017_326341# 0.11794f
C7124 a_79025_129571# a_82658_129203# 0.07567f
C7125 a_305619_211562# VDD3 0.00664f
C7126 a_186430_102197# a_186431_100948# 0.00515f
C7127 user_project_wrapper_0.sg13g2_IOPadVdd_0.sg13g2_RCClampResistor_0.p2 user_project_wrapper_0.sg13g2_IOPadVdd_0.sg13g2_RCClampInverter_noptap_0.out 22.6705f
C7128 a_92512_127896# user_project_wrapper_0.sg13g2_IOPadIn$1_1.p2c 0.00215f
C7129 a_210983_324119# a_211153_325358# 0
C7130 a_360458_74695# IOVDD3 0
C7131 a_301735_35542# a_301735_35456# 0.03774f
C7132 a_192354_330241# a_192354_330026# 0.01056f
C7133 a_369296_278644# a_369456_286861# 0.01778f
C7134 a_189756_325263# a_188834_326341# 0.45505f
C7135 a_189184_325263# a_189184_329719# 0.34198f
C7136 a_188834_327918# a_189756_329719# 0.03192f
C7137 user_project_wrapper_0.sg13g2_IOPadAnalog_17.padres a_188834_327918# 4.08351f
C7138 a_187364_324106# a_189756_326377# 0.00685f
C7139 user_project_wrapper_0.IOVDD2 a_298765_39542# 0.02181f
C7140 user_project_wrapper_0.sg13g2_IOPadAnalog_8.padres a_79025_133911# 0.09503f
C7141 m2_82112_130096# a_79025_136081# 0.01035f
C7142 a_117145_39542# a_117475_35542# 0.03774f
C7143 user_project_wrapper_0.sg13g2_IOPadAnalog_19.padres a_182931_326125# 0.01576f
C7144 user_project_wrapper_0.IOVDD1 a_39542_73705# 0.01881f
C7145 user_project_wrapper_0.IOVDD4 a_80635_360458# 0
C7146 a_364458_76675# VDD3 0.00153f
C7147 a_210109_327491# a_210109_328013# 0
C7148 a_190218_98097# QDLL_TOP_0.VDD 0.15306f
C7149 a_217444_355624# user_project_wrapper_0.analog_io[32] 25.1197f
C7150 m7_6440_9800# user_project_wrapper_0.IOVSS1 0.50416p $ **FLOATING
C7151 m6_7020_10380# user_project_wrapper_0.IOVSS1 0.28818p $ **FLOATING
C7152 m6_6440_9800# user_project_wrapper_0.IOVSS1 0.28943p $ **FLOATING
C7153 m5_6924_10284# user_project_wrapper_0.IOVSS1 0.2122p $ **FLOATING
C7154 m5_6440_9800# user_project_wrapper_0.IOVSS1 0.21312p $ **FLOATING
C7155 m4_6878_10238# user_project_wrapper_0.IOVSS1 0.2242p $ **FLOATING
C7156 m4_6440_9800# user_project_wrapper_0.IOVSS1 0.22517p $ **FLOATING
C7157 m3_6878_10238# user_project_wrapper_0.IOVSS1 0.24169p $ **FLOATING
C7158 m3_6440_9800# user_project_wrapper_0.IOVSS1 0.24274p $ **FLOATING
C7159 m2_83010_126180# user_project_wrapper_0.IOVSS1 0.02471f $ **FLOATING
C7160 m2_81563_127336# user_project_wrapper_0.IOVSS1 0.04233f $ **FLOATING
C7161 m2_82112_130096# user_project_wrapper_0.IOVSS1 0.02351f $ **FLOATING
C7162 m2_81766_242000# user_project_wrapper_0.IOVSS1 0.0512f $ **FLOATING
C7163 m2_6878_10238# user_project_wrapper_0.IOVSS1 0.26825p $ **FLOATING
C7164 m2_6440_9800# user_project_wrapper_0.IOVSS1 0.26942p $ **FLOATING
C7165 m1_83011_126179# user_project_wrapper_0.IOVSS1 0.02621f $ **FLOATING
C7166 m1_81567_127343# user_project_wrapper_0.IOVSS1 0.07155f $ **FLOATING
C7167 m1_82112_127957# user_project_wrapper_0.IOVSS1 0.03254f $ **FLOATING
C7168 m1_82116_130103# user_project_wrapper_0.IOVSS1 0.06049f $ **FLOATING
C7169 m1_81998_130507# user_project_wrapper_0.IOVSS1 0.02335f $ **FLOATING
C7170 m1_84637_201313# user_project_wrapper_0.IOVSS1 0.0666f $ **FLOATING
C7171 m1_85051_241246# user_project_wrapper_0.IOVSS1 0.09993f $ **FLOATING
C7172 m1_81768_242005# user_project_wrapper_0.IOVSS1 0.04806f $ **FLOATING
C7173 m1_6878_10238# user_project_wrapper_0.IOVSS1 0.84826p $ **FLOATING
C7174 m1_6440_9800# user_project_wrapper_0.IOVSS1 0.84812p $ **FLOATING
C7175 a_286861_29836# user_project_wrapper_0.IOVSS1 0.56457f $ **FLOATING
C7176 a_278644_29676# user_project_wrapper_0.IOVSS1 27.0586f
C7177 a_266461_29836# user_project_wrapper_0.IOVSS1 0.56457f $ **FLOATING
C7178 a_258244_29676# user_project_wrapper_0.IOVSS1 27.0586f
C7179 a_246061_29836# user_project_wrapper_0.IOVSS1 0.56457f $ **FLOATING
C7180 a_237844_29676# user_project_wrapper_0.IOVSS1 27.0586f
C7181 a_225661_29836# user_project_wrapper_0.IOVSS1 0.56457f $ **FLOATING
C7182 a_217444_29676# user_project_wrapper_0.IOVSS1 27.0586f
C7183 a_205261_29836# user_project_wrapper_0.IOVSS1 0.56457f $ **FLOATING
C7184 a_197044_29676# user_project_wrapper_0.IOVSS1 27.0586f
C7185 a_184861_29836# user_project_wrapper_0.IOVSS1 0.56457f $ **FLOATING
C7186 a_176644_29676# user_project_wrapper_0.IOVSS1 27.0586f
C7187 a_164461_29836# user_project_wrapper_0.IOVSS1 0.56457f $ **FLOATING
C7188 a_156244_29676# user_project_wrapper_0.IOVSS1 27.0586f
C7189 a_144061_29836# user_project_wrapper_0.IOVSS1 0.56457f $ **FLOATING
C7190 a_135844_29676# user_project_wrapper_0.IOVSS1 27.0586f
C7191 a_306025_35542# user_project_wrapper_0.IOVSS1 3.53966f $ **FLOATING
C7192 a_305695_35456# user_project_wrapper_0.IOVSS1 0.46084f
C7193 a_305695_35542# user_project_wrapper_0.IOVSS1 3.04229f $ **FLOATING
C7194 a_305365_35542# user_project_wrapper_0.IOVSS1 3.04218f $ **FLOATING
C7195 a_305365_39542# user_project_wrapper_0.IOVSS1 0.41869f
C7196 a_305035_35456# user_project_wrapper_0.IOVSS1 0.43535f
C7197 a_305035_35542# user_project_wrapper_0.IOVSS1 3.04229f $ **FLOATING
C7198 a_304705_35542# user_project_wrapper_0.IOVSS1 3.04218f $ **FLOATING
C7199 a_304705_39542# user_project_wrapper_0.IOVSS1 0.41869f
C7200 a_304375_35456# user_project_wrapper_0.IOVSS1 0.43536f
C7201 a_304375_35542# user_project_wrapper_0.IOVSS1 3.04226f $ **FLOATING
C7202 a_304045_35542# user_project_wrapper_0.IOVSS1 3.04218f $ **FLOATING
C7203 a_304045_39542# user_project_wrapper_0.IOVSS1 0.41869f
C7204 a_303715_35456# user_project_wrapper_0.IOVSS1 0.43539f
C7205 a_303715_35542# user_project_wrapper_0.IOVSS1 3.04218f $ **FLOATING
C7206 a_303385_35542# user_project_wrapper_0.IOVSS1 3.04218f $ **FLOATING
C7207 a_303385_39542# user_project_wrapper_0.IOVSS1 0.41869f
C7208 a_303055_35456# user_project_wrapper_0.IOVSS1 0.43538f
C7209 a_303055_35542# user_project_wrapper_0.IOVSS1 3.04218f $ **FLOATING
C7210 a_302725_35542# user_project_wrapper_0.IOVSS1 3.04229f $ **FLOATING
C7211 a_302725_39542# user_project_wrapper_0.IOVSS1 0.41869f
C7212 a_302395_35456# user_project_wrapper_0.IOVSS1 0.43535f
C7213 a_302395_35542# user_project_wrapper_0.IOVSS1 3.04218f $ **FLOATING
C7214 a_302065_35542# user_project_wrapper_0.IOVSS1 3.04229f $ **FLOATING
C7215 a_302065_39542# user_project_wrapper_0.IOVSS1 0.41869f
C7216 a_301735_35456# user_project_wrapper_0.IOVSS1 0.43535f
C7217 a_301735_35542# user_project_wrapper_0.IOVSS1 3.04218f $ **FLOATING
C7218 a_301405_35542# user_project_wrapper_0.IOVSS1 3.04229f $ **FLOATING
C7219 a_301405_39542# user_project_wrapper_0.IOVSS1 0.41869f
C7220 a_301075_35456# user_project_wrapper_0.IOVSS1 0.43537f
C7221 a_301075_35542# user_project_wrapper_0.IOVSS1 3.04218f $ **FLOATING
C7222 a_300745_35542# user_project_wrapper_0.IOVSS1 3.04224f $ **FLOATING
C7223 a_300745_39542# user_project_wrapper_0.IOVSS1 0.41869f
C7224 a_300415_35456# user_project_wrapper_0.IOVSS1 0.43541f
C7225 a_300415_35542# user_project_wrapper_0.IOVSS1 3.04218f $ **FLOATING
C7226 a_300085_35542# user_project_wrapper_0.IOVSS1 3.04218f $ **FLOATING
C7227 a_300085_39542# user_project_wrapper_0.IOVSS1 0.41869f
C7228 a_299755_35456# user_project_wrapper_0.IOVSS1 0.43539f
C7229 a_299755_35542# user_project_wrapper_0.IOVSS1 3.04218f $ **FLOATING
C7230 a_299425_35542# user_project_wrapper_0.IOVSS1 3.04218f $ **FLOATING
C7231 a_299425_39542# user_project_wrapper_0.IOVSS1 0.41869f
C7232 a_299095_35456# user_project_wrapper_0.IOVSS1 0.43539f
C7233 a_299095_35542# user_project_wrapper_0.IOVSS1 3.04229f $ **FLOATING
C7234 a_298765_35542# user_project_wrapper_0.IOVSS1 3.04218f $ **FLOATING
C7235 a_298765_39542# user_project_wrapper_0.IOVSS1 0.41869f
C7236 a_298435_35456# user_project_wrapper_0.IOVSS1 0.43535f
C7237 a_298435_35542# user_project_wrapper_0.IOVSS1 3.04229f $ **FLOATING
C7238 a_298105_35542# user_project_wrapper_0.IOVSS1 3.04218f $ **FLOATING
C7239 a_298105_39542# user_project_wrapper_0.IOVSS1 0.41869f
C7240 a_297775_35456# user_project_wrapper_0.IOVSS1 0.46084f
C7241 a_297775_35542# user_project_wrapper_0.IOVSS1 3.53976f $ **FLOATING
C7242 a_122425_35542# user_project_wrapper_0.IOVSS1 3.53966f $ **FLOATING
C7243 a_122095_35456# user_project_wrapper_0.IOVSS1 0.46084f
C7244 a_122095_35542# user_project_wrapper_0.IOVSS1 3.04229f $ **FLOATING
C7245 a_121765_35542# user_project_wrapper_0.IOVSS1 3.04218f $ **FLOATING
C7246 a_121765_39542# user_project_wrapper_0.IOVSS1 0.41869f
C7247 a_121435_35456# user_project_wrapper_0.IOVSS1 0.43535f
C7248 a_121435_35542# user_project_wrapper_0.IOVSS1 3.04229f $ **FLOATING
C7249 a_121105_35542# user_project_wrapper_0.IOVSS1 3.04218f $ **FLOATING
C7250 a_121105_39542# user_project_wrapper_0.IOVSS1 0.41869f
C7251 a_120775_35456# user_project_wrapper_0.IOVSS1 0.43536f
C7252 a_120775_35542# user_project_wrapper_0.IOVSS1 3.04226f $ **FLOATING
C7253 a_120445_35542# user_project_wrapper_0.IOVSS1 3.04218f $ **FLOATING
C7254 a_120445_39542# user_project_wrapper_0.IOVSS1 0.41869f
C7255 a_120115_35456# user_project_wrapper_0.IOVSS1 0.43539f
C7256 a_120115_35542# user_project_wrapper_0.IOVSS1 3.04218f $ **FLOATING
C7257 a_119785_35542# user_project_wrapper_0.IOVSS1 3.04218f $ **FLOATING
C7258 a_119785_39542# user_project_wrapper_0.IOVSS1 0.41869f
C7259 a_119455_35456# user_project_wrapper_0.IOVSS1 0.43538f
C7260 a_119455_35542# user_project_wrapper_0.IOVSS1 3.04218f $ **FLOATING
C7261 a_119125_35542# user_project_wrapper_0.IOVSS1 3.04229f $ **FLOATING
C7262 a_119125_39542# user_project_wrapper_0.IOVSS1 0.41869f
C7263 a_118795_35456# user_project_wrapper_0.IOVSS1 0.43535f
C7264 a_118795_35542# user_project_wrapper_0.IOVSS1 3.04218f $ **FLOATING
C7265 a_118465_35542# user_project_wrapper_0.IOVSS1 3.04229f $ **FLOATING
C7266 a_118465_39542# user_project_wrapper_0.IOVSS1 0.41869f
C7267 a_118135_35456# user_project_wrapper_0.IOVSS1 0.43535f
C7268 a_118135_35542# user_project_wrapper_0.IOVSS1 3.04218f $ **FLOATING
C7269 a_117805_35542# user_project_wrapper_0.IOVSS1 3.04229f $ **FLOATING
C7270 a_117805_39542# user_project_wrapper_0.IOVSS1 0.41869f
C7271 a_117475_35456# user_project_wrapper_0.IOVSS1 0.43537f
C7272 a_117475_35542# user_project_wrapper_0.IOVSS1 3.04218f $ **FLOATING
C7273 a_117145_35542# user_project_wrapper_0.IOVSS1 3.04224f $ **FLOATING
C7274 a_117145_39542# user_project_wrapper_0.IOVSS1 0.41869f
C7275 a_116815_35456# user_project_wrapper_0.IOVSS1 0.43541f
C7276 a_116815_35542# user_project_wrapper_0.IOVSS1 3.04218f $ **FLOATING
C7277 a_116485_35542# user_project_wrapper_0.IOVSS1 3.04218f $ **FLOATING
C7278 a_116485_39542# user_project_wrapper_0.IOVSS1 0.41869f
C7279 a_116155_35456# user_project_wrapper_0.IOVSS1 0.43539f
C7280 a_116155_35542# user_project_wrapper_0.IOVSS1 3.04218f $ **FLOATING
C7281 a_115825_35542# user_project_wrapper_0.IOVSS1 3.04218f $ **FLOATING
C7282 a_115825_39542# user_project_wrapper_0.IOVSS1 0.41869f
C7283 a_115495_35456# user_project_wrapper_0.IOVSS1 0.43539f
C7284 a_115495_35542# user_project_wrapper_0.IOVSS1 3.04229f $ **FLOATING
C7285 a_115165_35542# user_project_wrapper_0.IOVSS1 3.04218f $ **FLOATING
C7286 a_115165_39542# user_project_wrapper_0.IOVSS1 0.41869f
C7287 a_114835_35456# user_project_wrapper_0.IOVSS1 0.43535f
C7288 a_114835_35542# user_project_wrapper_0.IOVSS1 3.04229f $ **FLOATING
C7289 a_114505_35542# user_project_wrapper_0.IOVSS1 3.04218f $ **FLOATING
C7290 a_114505_39542# user_project_wrapper_0.IOVSS1 0.41869f
C7291 a_114175_35456# user_project_wrapper_0.IOVSS1 0.46084f
C7292 a_114175_35542# user_project_wrapper_0.IOVSS1 3.53976f $ **FLOATING
C7293 user_project_wrapper_0.sg13g2_IOPadIOVdd_0.sg13g2_Clamp_N43N43D4R_0.gate user_project_wrapper_0.IOVSS1 0.18346p
C7294 user_project_wrapper_0.sg13g2_IOPadIOVdd_0.sg13g2_RCClampResistor_0.p2 user_project_wrapper_0.IOVSS1 0.15451p
C7295 a_286861_41636# user_project_wrapper_0.IOVSS1 0.05224f $ **FLOATING
C7296 a_278644_41476# user_project_wrapper_0.IOVSS1 0.48855f
C7297 a_266461_41636# user_project_wrapper_0.IOVSS1 0.05224f $ **FLOATING
C7298 a_258244_41476# user_project_wrapper_0.IOVSS1 0.48855f
C7299 a_246061_41636# user_project_wrapper_0.IOVSS1 0.05224f $ **FLOATING
C7300 a_237844_41476# user_project_wrapper_0.IOVSS1 0.48855f
C7301 a_225661_41636# user_project_wrapper_0.IOVSS1 0.05224f $ **FLOATING
C7302 a_217444_41476# user_project_wrapper_0.IOVSS1 0.48855f
C7303 a_205261_41636# user_project_wrapper_0.IOVSS1 0.05224f $ **FLOATING
C7304 a_197044_41476# user_project_wrapper_0.IOVSS1 0.48855f
C7305 a_184861_41636# user_project_wrapper_0.IOVSS1 0.05224f $ **FLOATING
C7306 a_176644_41476# user_project_wrapper_0.IOVSS1 0.48855f
C7307 a_164461_41636# user_project_wrapper_0.IOVSS1 0.05224f $ **FLOATING
C7308 a_156244_41476# user_project_wrapper_0.IOVSS1 0.48855f
C7309 a_144061_41636# user_project_wrapper_0.IOVSS1 0.05224f $ **FLOATING
C7310 a_135844_41476# user_project_wrapper_0.IOVSS1 0.48855f
C7311 user_project_wrapper_0.sg13g2_IOPadVdd_1.sg13g2_RCClampInverter_noptap_0.out user_project_wrapper_0.IOVSS1 0.18345p
C7312 user_project_wrapper_0.sg13g2_IOPadVdd_1.sg13g2_RCClampResistor_0.p2 user_project_wrapper_0.IOVSS1 0.15451p
C7313 a_284218_56308# user_project_wrapper_0.IOVSS1 0.47314f $ **FLOATING
C7314 user_project_wrapper_0.analog_io[16] user_project_wrapper_0.IOVSS1 0.35506p
C7315 a_263818_56308# user_project_wrapper_0.IOVSS1 0.47314f $ **FLOATING
C7316 a_243418_56308# user_project_wrapper_0.IOVSS1 0.47314f $ **FLOATING
C7317 a_223018_56308# user_project_wrapper_0.IOVSS1 0.47314f $ **FLOATING
C7318 a_202618_56308# user_project_wrapper_0.IOVSS1 0.47314f $ **FLOATING
C7319 user_project_wrapper_0.analog_io[12] user_project_wrapper_0.IOVSS1 0.35506p
C7320 a_182218_56308# user_project_wrapper_0.IOVSS1 0.47314f $ **FLOATING
C7321 user_project_wrapper_0.analog_io[11] user_project_wrapper_0.IOVSS1 0.35506p
C7322 a_161818_56308# user_project_wrapper_0.IOVSS1 0.47314f $ **FLOATING
C7323 user_project_wrapper_0.analog_io[10] user_project_wrapper_0.IOVSS1 0.35506p
C7324 a_141418_56308# user_project_wrapper_0.IOVSS1 0.47314f $ **FLOATING
C7325 user_project_wrapper_0.ui_PAD[9] user_project_wrapper_0.IOVSS1 0.22114p
C7326 a_77737_56308# user_project_wrapper_0.IOVSS1 0.47462f $ **FLOATING
C7327 user_project_wrapper_0.sg13g2_IOPadAnalog_7.padres user_project_wrapper_0.IOVSS1 6.48953f
C7328 user_project_wrapper_0.sg13g2_IOPadAnalog_5.padres user_project_wrapper_0.IOVSS1 6.48953f
C7329 user_project_wrapper_0.sg13g2_IOPadAnalog_4.padres user_project_wrapper_0.IOVSS1 6.48953f
C7330 user_project_wrapper_0.sg13g2_IOPadAnalog_30.padres user_project_wrapper_0.IOVSS1 6.48953f
C7331 user_project_wrapper_0.sg13g2_IOPadIn$1_1.sg13g2_LevelDown_noptap$1_0.sg13g2_SecondaryProtection$1$1_0.core user_project_wrapper_0.IOVSS1 5.66599f
C7332 a_77638_59490# user_project_wrapper_0.IOVSS1 0.69694f
C7333 a_360458_73375# user_project_wrapper_0.IOVSS1 3.53976f $ **FLOATING
C7334 a_364458_73375# user_project_wrapper_0.IOVSS1 0.46084f
C7335 a_360458_73705# user_project_wrapper_0.IOVSS1 3.04218f $ **FLOATING
C7336 a_360458_74035# user_project_wrapper_0.IOVSS1 3.04229f $ **FLOATING
C7337 a_360372_73705# user_project_wrapper_0.IOVSS1 0.41869f
C7338 a_364458_74035# user_project_wrapper_0.IOVSS1 0.43535f
C7339 a_360458_74365# user_project_wrapper_0.IOVSS1 3.04218f $ **FLOATING
C7340 a_360458_74695# user_project_wrapper_0.IOVSS1 3.04229f $ **FLOATING
C7341 a_360372_74365# user_project_wrapper_0.IOVSS1 0.41869f
C7342 a_364458_74695# user_project_wrapper_0.IOVSS1 0.43539f
C7343 a_360458_75025# user_project_wrapper_0.IOVSS1 3.04218f $ **FLOATING
C7344 a_360458_75355# user_project_wrapper_0.IOVSS1 3.04218f $ **FLOATING
C7345 a_360372_75025# user_project_wrapper_0.IOVSS1 0.41869f
C7346 a_364458_75355# user_project_wrapper_0.IOVSS1 0.43539f
C7347 a_360458_75685# user_project_wrapper_0.IOVSS1 3.04218f $ **FLOATING
C7348 a_360458_76015# user_project_wrapper_0.IOVSS1 3.04218f $ **FLOATING
C7349 a_360372_75685# user_project_wrapper_0.IOVSS1 0.41869f
C7350 a_364458_76015# user_project_wrapper_0.IOVSS1 0.43541f
C7351 a_360458_76345# user_project_wrapper_0.IOVSS1 3.04224f $ **FLOATING
C7352 a_360458_76675# user_project_wrapper_0.IOVSS1 3.04218f $ **FLOATING
C7353 a_360372_76345# user_project_wrapper_0.IOVSS1 0.41869f
C7354 a_364458_76675# user_project_wrapper_0.IOVSS1 0.43537f
C7355 a_360458_77005# user_project_wrapper_0.IOVSS1 3.04229f $ **FLOATING
C7356 a_360458_77335# user_project_wrapper_0.IOVSS1 3.04218f $ **FLOATING
C7357 a_360372_77005# user_project_wrapper_0.IOVSS1 0.41869f
C7358 a_364458_77335# user_project_wrapper_0.IOVSS1 0.43535f
C7359 a_360458_77665# user_project_wrapper_0.IOVSS1 3.04229f $ **FLOATING
C7360 a_360458_77995# user_project_wrapper_0.IOVSS1 3.04218f $ **FLOATING
C7361 a_360372_77665# user_project_wrapper_0.IOVSS1 0.41869f
C7362 a_364458_77995# user_project_wrapper_0.IOVSS1 0.43535f
C7363 a_360458_78325# user_project_wrapper_0.IOVSS1 3.04229f $ **FLOATING
C7364 a_360458_78655# user_project_wrapper_0.IOVSS1 3.04218f $ **FLOATING
C7365 a_360372_78325# user_project_wrapper_0.IOVSS1 0.41869f
C7366 a_364458_78655# user_project_wrapper_0.IOVSS1 0.43538f
C7367 a_360458_78985# user_project_wrapper_0.IOVSS1 3.04218f $ **FLOATING
C7368 a_360458_79315# user_project_wrapper_0.IOVSS1 3.04218f $ **FLOATING
C7369 a_360372_78985# user_project_wrapper_0.IOVSS1 0.41869f
C7370 a_364458_79315# user_project_wrapper_0.IOVSS1 0.43539f
C7371 a_360458_79645# user_project_wrapper_0.IOVSS1 3.04218f $ **FLOATING
C7372 a_360458_79975# user_project_wrapper_0.IOVSS1 3.04226f $ **FLOATING
C7373 a_360372_79645# user_project_wrapper_0.IOVSS1 0.41869f
C7374 a_364458_79975# user_project_wrapper_0.IOVSS1 0.43536f
C7375 a_360458_80305# user_project_wrapper_0.IOVSS1 3.04218f $ **FLOATING
C7376 a_360458_80635# user_project_wrapper_0.IOVSS1 3.04229f $ **FLOATING
C7377 a_360372_80305# user_project_wrapper_0.IOVSS1 0.41869f
C7378 a_364458_80635# user_project_wrapper_0.IOVSS1 0.43535f
C7379 a_360458_80965# user_project_wrapper_0.IOVSS1 3.04218f $ **FLOATING
C7380 a_360458_81295# user_project_wrapper_0.IOVSS1 3.04229f $ **FLOATING
C7381 a_360372_80965# user_project_wrapper_0.IOVSS1 0.41869f
C7382 a_364458_81295# user_project_wrapper_0.IOVSS1 0.46084f
C7383 a_360458_81625# user_project_wrapper_0.IOVSS1 3.53966f $ **FLOATING
C7384 user_project_wrapper_0.sg13g2_IOPadVdd_0.sg13g2_RCClampInverter_noptap_0.out user_project_wrapper_0.IOVSS1 0.18345p
C7385 user_project_wrapper_0.sg13g2_IOPadVdd_0.sg13g2_RCClampResistor_0.p2 user_project_wrapper_0.IOVSS1 0.15451p
C7386 a_35542_73375# user_project_wrapper_0.IOVSS1 3.53976f $ **FLOATING
C7387 a_35542_73705# user_project_wrapper_0.IOVSS1 3.04218f $ **FLOATING
C7388 a_35456_73375# user_project_wrapper_0.IOVSS1 0.46084f
C7389 a_39542_73705# user_project_wrapper_0.IOVSS1 0.41869f
C7390 a_35542_74035# user_project_wrapper_0.IOVSS1 3.04229f $ **FLOATING
C7391 a_35542_74365# user_project_wrapper_0.IOVSS1 3.04218f $ **FLOATING
C7392 a_35456_74035# user_project_wrapper_0.IOVSS1 0.43535f
C7393 a_39542_74365# user_project_wrapper_0.IOVSS1 0.41869f
C7394 a_35542_74695# user_project_wrapper_0.IOVSS1 3.04229f $ **FLOATING
C7395 a_35542_75025# user_project_wrapper_0.IOVSS1 3.04218f $ **FLOATING
C7396 a_35456_74695# user_project_wrapper_0.IOVSS1 0.43539f
C7397 a_39542_75025# user_project_wrapper_0.IOVSS1 0.41869f
C7398 a_35542_75355# user_project_wrapper_0.IOVSS1 3.04218f $ **FLOATING
C7399 a_35542_75685# user_project_wrapper_0.IOVSS1 3.04218f $ **FLOATING
C7400 a_35456_75355# user_project_wrapper_0.IOVSS1 0.43539f
C7401 a_39542_75685# user_project_wrapper_0.IOVSS1 0.41869f
C7402 a_35542_76015# user_project_wrapper_0.IOVSS1 3.04218f $ **FLOATING
C7403 a_35542_76345# user_project_wrapper_0.IOVSS1 3.04224f $ **FLOATING
C7404 a_35456_76015# user_project_wrapper_0.IOVSS1 0.43541f
C7405 a_39542_76345# user_project_wrapper_0.IOVSS1 0.41869f
C7406 a_35542_76675# user_project_wrapper_0.IOVSS1 3.04218f $ **FLOATING
C7407 a_35542_77005# user_project_wrapper_0.IOVSS1 3.04229f $ **FLOATING
C7408 a_35456_76675# user_project_wrapper_0.IOVSS1 0.43537f
C7409 a_39542_77005# user_project_wrapper_0.IOVSS1 0.41869f
C7410 a_35542_77335# user_project_wrapper_0.IOVSS1 3.04218f $ **FLOATING
C7411 a_35542_77665# user_project_wrapper_0.IOVSS1 3.04229f $ **FLOATING
C7412 a_35456_77335# user_project_wrapper_0.IOVSS1 0.43535f
C7413 a_39542_77665# user_project_wrapper_0.IOVSS1 0.41869f
C7414 a_35542_77995# user_project_wrapper_0.IOVSS1 3.04218f $ **FLOATING
C7415 a_35542_78325# user_project_wrapper_0.IOVSS1 3.04229f $ **FLOATING
C7416 a_35456_77995# user_project_wrapper_0.IOVSS1 0.43535f
C7417 a_39542_78325# user_project_wrapper_0.IOVSS1 0.41869f
C7418 a_35542_78655# user_project_wrapper_0.IOVSS1 3.04218f $ **FLOATING
C7419 a_35542_78985# user_project_wrapper_0.IOVSS1 3.04218f $ **FLOATING
C7420 a_35456_78655# user_project_wrapper_0.IOVSS1 0.43538f
C7421 a_39542_78985# user_project_wrapper_0.IOVSS1 0.41869f
C7422 a_35542_79315# user_project_wrapper_0.IOVSS1 3.04218f $ **FLOATING
C7423 a_35542_79645# user_project_wrapper_0.IOVSS1 3.04218f $ **FLOATING
C7424 a_35456_79315# user_project_wrapper_0.IOVSS1 0.43539f
C7425 a_39542_79645# user_project_wrapper_0.IOVSS1 0.41869f
C7426 a_35542_79975# user_project_wrapper_0.IOVSS1 3.04226f $ **FLOATING
C7427 a_35542_80305# user_project_wrapper_0.IOVSS1 3.04218f $ **FLOATING
C7428 a_35456_79975# user_project_wrapper_0.IOVSS1 0.43536f
C7429 a_39542_80305# user_project_wrapper_0.IOVSS1 0.41869f
C7430 a_35542_80635# user_project_wrapper_0.IOVSS1 3.04229f $ **FLOATING
C7431 a_35542_80965# user_project_wrapper_0.IOVSS1 3.04218f $ **FLOATING
C7432 a_35456_80635# user_project_wrapper_0.IOVSS1 0.43535f
C7433 a_39542_80965# user_project_wrapper_0.IOVSS1 0.41869f
C7434 a_35542_81295# user_project_wrapper_0.IOVSS1 3.04229f $ **FLOATING
C7435 user_project_wrapper_0.sg13g2_IOPadVdd_2.sg13g2_RCClampResistor_0.p2 user_project_wrapper_0.IOVSS1 0.15451p
C7436 a_35542_81625# user_project_wrapper_0.IOVSS1 3.53966f $ **FLOATING
C7437 a_35456_81295# user_project_wrapper_0.IOVSS1 0.46084f
C7438 user_project_wrapper_0.sg13g2_IOPadVdd_2.sg13g2_RCClampInverter_noptap_0.out user_project_wrapper_0.IOVSS1 0.18345p
C7439 a_192826_90558# user_project_wrapper_0.IOVSS1 1.71042f $ **FLOATING
C7440 a_192309_90557# user_project_wrapper_0.IOVSS1 1.62275f $ **FLOATING
C7441 a_192309_92557# user_project_wrapper_0.IOVSS1 0.54036f
C7442 a_191751_90472# user_project_wrapper_0.IOVSS1 0.49696f
C7443 a_191751_90558# user_project_wrapper_0.IOVSS1 1.63254f $ **FLOATING
C7444 a_191196_90557# user_project_wrapper_0.IOVSS1 1.63256f $ **FLOATING
C7445 a_191196_92557# user_project_wrapper_0.IOVSS1 0.53067f
C7446 a_190638_90472# user_project_wrapper_0.IOVSS1 0.50054f
C7447 a_190638_90558# user_project_wrapper_0.IOVSS1 1.63277f $ **FLOATING
C7448 a_190082_90557# user_project_wrapper_0.IOVSS1 1.63279f $ **FLOATING
C7449 a_190082_92557# user_project_wrapper_0.IOVSS1 0.53071f
C7450 a_189524_90472# user_project_wrapper_0.IOVSS1 0.5006f
C7451 a_189524_90558# user_project_wrapper_0.IOVSS1 1.63328f $ **FLOATING
C7452 a_188966_90557# user_project_wrapper_0.IOVSS1 1.63325f $ **FLOATING
C7453 a_188966_92557# user_project_wrapper_0.IOVSS1 0.53126f
C7454 a_188408_90472# user_project_wrapper_0.IOVSS1 0.5006f
C7455 a_188408_90558# user_project_wrapper_0.IOVSS1 1.63277f $ **FLOATING
C7456 a_187852_90557# user_project_wrapper_0.IOVSS1 1.63279f $ **FLOATING
C7457 a_187852_92557# user_project_wrapper_0.IOVSS1 0.53155f
C7458 a_187294_90472# user_project_wrapper_0.IOVSS1 0.49803f
C7459 a_187294_90558# user_project_wrapper_0.IOVSS1 1.63303f $ **FLOATING
C7460 a_186731_90558# user_project_wrapper_0.IOVSS1 1.71657f $ **FLOATING
C7461 a_186731_92558# user_project_wrapper_0.IOVSS1 0.55426f
C7462 a_190584_97917# user_project_wrapper_0.IOVSS1 0.01167f
C7463 a_190490_98199# user_project_wrapper_0.IOVSS1 0.0056f
C7464 a_190287_98223# user_project_wrapper_0.IOVSS1 0.00481f
C7465 a_190319_97955# user_project_wrapper_0.IOVSS1 0.23681f
C7466 a_190218_98097# user_project_wrapper_0.IOVSS1 0.36122f
C7467 a_186430_98275# user_project_wrapper_0.IOVSS1 0.06371f
C7468 user_project_wrapper_0.analog_io[14] user_project_wrapper_0.IOVSS1 0.39452p
C7469 a_189016_99480# user_project_wrapper_0.IOVSS1 0.23416f
C7470 a_188184_99046# user_project_wrapper_0.IOVSS1 0.24822f
C7471 a_190389_99046# user_project_wrapper_0.IOVSS1 2.62346f
C7472 a_189729_99046# user_project_wrapper_0.IOVSS1 1.30482f
C7473 a_189395_99046# user_project_wrapper_0.IOVSS1 0.62408f
C7474 a_189148_99070# user_project_wrapper_0.IOVSS1 0.17891f
C7475 a_188760_99480# user_project_wrapper_0.IOVSS1 0.32247f
C7476 a_188572_99046# user_project_wrapper_0.IOVSS1 0.28917f
C7477 a_188296_99070# user_project_wrapper_0.IOVSS1 0.23681f
C7478 a_187914_99087# user_project_wrapper_0.IOVSS1 0.39629f
C7479 a_186431_99272# user_project_wrapper_0.IOVSS1 0.6178f
C7480 a_185968_98275# user_project_wrapper_0.IOVSS1 0.8638f
C7481 user_project_wrapper_0.analog_io[13] user_project_wrapper_0.IOVSS1 0.48495p
C7482 QDLL_TOP_0.VOUT user_project_wrapper_0.IOVSS1 0.3919p
C7483 a_271172_100118# user_project_wrapper_0.IOVSS1 2.4047f
C7484 a_270512_100118# user_project_wrapper_0.IOVSS1 1.20794f
C7485 a_270178_100118# user_project_wrapper_0.IOVSS1 0.55729f
C7486 a_269931_100182# user_project_wrapper_0.IOVSS1 0.15032f
C7487 a_269799_100118# user_project_wrapper_0.IOVSS1 0.20434f
C7488 a_269355_100412# user_project_wrapper_0.IOVSS1 0.24661f
C7489 a_269543_100118# user_project_wrapper_0.IOVSS1 0.28733f
C7490 a_269079_100182# user_project_wrapper_0.IOVSS1 0.20731f
C7491 a_268967_100118# user_project_wrapper_0.IOVSS1 0.20887f
C7492 user_project_wrapper_0.sg13g2_IOPadAnalog_6.padres user_project_wrapper_0.IOVSS1 0.11265p
C7493 a_268697_100118# user_project_wrapper_0.IOVSS1 0.37072f
C7494 a_190389_101343# user_project_wrapper_0.IOVSS1 2.62949f
C7495 a_189729_101343# user_project_wrapper_0.IOVSS1 1.30814f
C7496 a_189395_101343# user_project_wrapper_0.IOVSS1 0.62615f
C7497 a_189148_101407# user_project_wrapper_0.IOVSS1 0.17977f
C7498 a_189016_101343# user_project_wrapper_0.IOVSS1 0.23514f
C7499 a_188572_101637# user_project_wrapper_0.IOVSS1 0.29075f
C7500 a_188760_101343# user_project_wrapper_0.IOVSS1 0.32367f
C7501 a_188296_101407# user_project_wrapper_0.IOVSS1 0.23778f
C7502 a_188184_101343# user_project_wrapper_0.IOVSS1 0.24939f
C7503 a_186431_100948# user_project_wrapper_0.IOVSS1 0.61779f
C7504 a_187914_101343# user_project_wrapper_0.IOVSS1 0.39742f
C7505 a_190490_102497# user_project_wrapper_0.IOVSS1 0.00559f
C7506 a_190287_102497# user_project_wrapper_0.IOVSS1 0.00481f
C7507 a_186430_102197# user_project_wrapper_0.IOVSS1 0.06241f
C7508 a_185968_102197# user_project_wrapper_0.IOVSS1 0.86322f
C7509 a_190584_102855# user_project_wrapper_0.IOVSS1 0.01166f
C7510 a_190319_102855# user_project_wrapper_0.IOVSS1 0.23674f
C7511 user_project_wrapper_0.analog_io[15] user_project_wrapper_0.IOVSS1 0.40244p
C7512 a_190218_102763# user_project_wrapper_0.IOVSS1 0.36116f
C7513 a_369456_123661# user_project_wrapper_0.IOVSS1 0.56457f $ **FLOATING
C7514 a_369296_115444# user_project_wrapper_0.IOVSS1 27.0586f
C7515 a_355784_123661# user_project_wrapper_0.IOVSS1 0.05224f $ **FLOATING
C7516 a_355624_115444# user_project_wrapper_0.IOVSS1 0.48855f
C7517 analog_io[18] user_project_wrapper_0.IOVSS1 0.35506p
C7518 a_343292_121018# user_project_wrapper_0.IOVSS1 0.47314f $ **FLOATING
C7519 user_project_wrapper_0.sg13g2_IOPadAnalog_0.padres user_project_wrapper_0.IOVSS1 6.48953f
C7520 a_192492_108495# user_project_wrapper_0.IOVSS1 1.70416f $ **FLOATING
C7521 QDLL_TOP_0.CPIN user_project_wrapper_0.IOVSS1 34.9906f
C7522 a_191975_108410# user_project_wrapper_0.IOVSS1 0.5316f
C7523 a_191975_108496# user_project_wrapper_0.IOVSS1 1.61648f $ **FLOATING
C7524 a_191417_108495# user_project_wrapper_0.IOVSS1 1.62628f $ **FLOATING
C7525 a_191417_110495# user_project_wrapper_0.IOVSS1 0.49696f
C7526 a_190862_108410# user_project_wrapper_0.IOVSS1 0.52191f
C7527 a_190862_108496# user_project_wrapper_0.IOVSS1 1.62628f $ **FLOATING
C7528 a_190304_108495# user_project_wrapper_0.IOVSS1 1.62651f $ **FLOATING
C7529 a_190304_110495# user_project_wrapper_0.IOVSS1 0.50054f
C7530 a_189748_108410# user_project_wrapper_0.IOVSS1 0.52195f
C7531 a_189748_108496# user_project_wrapper_0.IOVSS1 1.62652f $ **FLOATING
C7532 a_189190_108495# user_project_wrapper_0.IOVSS1 1.62701f $ **FLOATING
C7533 a_189190_110495# user_project_wrapper_0.IOVSS1 0.5006f
C7534 a_188632_108410# user_project_wrapper_0.IOVSS1 0.52248f
C7535 a_188632_108496# user_project_wrapper_0.IOVSS1 1.62698f $ **FLOATING
C7536 a_188074_108495# user_project_wrapper_0.IOVSS1 1.62468f $ **FLOATING
C7537 a_188074_110495# user_project_wrapper_0.IOVSS1 0.5006f
C7538 a_187518_108410# user_project_wrapper_0.IOVSS1 0.52083f
C7539 a_187518_108496# user_project_wrapper_0.IOVSS1 1.62022f $ **FLOATING
C7540 a_186960_108495# user_project_wrapper_0.IOVSS1 1.62079f $ **FLOATING
C7541 a_186960_110495# user_project_wrapper_0.IOVSS1 0.49803f
C7542 a_186397_108409# user_project_wrapper_0.IOVSS1 0.54442f
C7543 a_186397_108495# user_project_wrapper_0.IOVSS1 1.70854f $ **FLOATING
C7544 a_78220_122262# user_project_wrapper_0.IOVSS1 0.5511f $ **FLOATING
C7545 a_79038_123516# user_project_wrapper_0.IOVSS1 0.59445f
C7546 a_79038_123982# user_project_wrapper_0.IOVSS1 0.71782f
C7547 a_78220_123062# user_project_wrapper_0.IOVSS1 1.29487f
C7548 a_79025_124824# user_project_wrapper_0.IOVSS1 0.41817f
C7549 a_78221_124694# user_project_wrapper_0.IOVSS1 0.25589f $ **FLOATING
C7550 a_78824_124371# user_project_wrapper_0.IOVSS1 0.55584f
C7551 a_88393_125210# user_project_wrapper_0.IOVSS1 0.10898f
C7552 a_87775_125210# user_project_wrapper_0.IOVSS1 0.10725f
C7553 a_87571_125210# user_project_wrapper_0.IOVSS1 0.11028f
C7554 a_85977_125209# user_project_wrapper_0.IOVSS1 0.10909f
C7555 a_85359_125209# user_project_wrapper_0.IOVSS1 0.10737f
C7556 a_85155_125209# user_project_wrapper_0.IOVSS1 0.11008f
C7557 a_83592_125209# user_project_wrapper_0.IOVSS1 0.10898f
C7558 a_82974_125209# user_project_wrapper_0.IOVSS1 0.10725f
C7559 a_82770_125209# user_project_wrapper_0.IOVSS1 0.11395f
C7560 a_88291_125210# user_project_wrapper_0.IOVSS1 0.25855f
C7561 a_87673_125210# user_project_wrapper_0.IOVSS1 0.24939f
C7562 a_87851_125174# user_project_wrapper_0.IOVSS1 0.35379f
C7563 a_87627_124843# user_project_wrapper_0.IOVSS1 1.89175f
C7564 a_87468_125419# user_project_wrapper_0.IOVSS1 1.1582f
C7565 a_85875_125209# user_project_wrapper_0.IOVSS1 0.25597f
C7566 a_85257_125209# user_project_wrapper_0.IOVSS1 0.24698f
C7567 a_85435_125173# user_project_wrapper_0.IOVSS1 0.35401f
C7568 a_85211_124842# user_project_wrapper_0.IOVSS1 1.79154f
C7569 a_85052_125418# user_project_wrapper_0.IOVSS1 1.19418f
C7570 a_83490_125209# user_project_wrapper_0.IOVSS1 0.25584f
C7571 a_82872_125209# user_project_wrapper_0.IOVSS1 0.24289f
C7572 a_83050_125173# user_project_wrapper_0.IOVSS1 0.35379f
C7573 a_82826_124842# user_project_wrapper_0.IOVSS1 1.91075f
C7574 a_82667_125418# user_project_wrapper_0.IOVSS1 1.2403f
C7575 a_79038_125686# user_project_wrapper_0.IOVSS1 0.56968f
C7576 a_78221_125094# user_project_wrapper_0.IOVSS1 1.00406f
C7577 a_79038_126152# user_project_wrapper_0.IOVSS1 0.71784f
C7578 a_78221_126292# user_project_wrapper_0.IOVSS1 0.25823f $ **FLOATING
C7579 a_56308_121018# user_project_wrapper_0.IOVSS1 0.47314f $ **FLOATING
C7580 a_79025_126994# user_project_wrapper_0.IOVSS1 0.17572f
C7581 a_78824_126541# user_project_wrapper_0.IOVSS1 0.54202f
C7582 a_93719_127531# user_project_wrapper_0.IOVSS1 0.07974f
C7583 a_92512_127531# user_project_wrapper_0.IOVSS1 0.07974f
C7584 a_91090_127530# user_project_wrapper_0.IOVSS1 0.07974f
C7585 a_89114_127531# user_project_wrapper_0.IOVSS1 0.07974f
C7586 a_88274_127531# user_project_wrapper_0.IOVSS1 0.07974f
C7587 a_87434_127531# user_project_wrapper_0.IOVSS1 0.07974f
C7588 a_86594_127531# user_project_wrapper_0.IOVSS1 0.07974f
C7589 a_83586_127455# user_project_wrapper_0.IOVSS1 0.07908f
C7590 a_83164_127455# user_project_wrapper_0.IOVSS1 0.08004f
C7591 a_93208_127531# user_project_wrapper_0.IOVSS1 0.37893f
C7592 a_92512_127896# user_project_wrapper_0.IOVSS1 0.34996f
C7593 a_91911_127530# user_project_wrapper_0.IOVSS1 1.01044f
C7594 a_91090_127895# user_project_wrapper_0.IOVSS1 0.39515f
C7595 a_84332_125209# user_project_wrapper_0.IOVSS1 3.38027f
C7596 a_90579_127530# user_project_wrapper_0.IOVSS1 0.36661f
C7597 a_89953_127531# user_project_wrapper_0.IOVSS1 0.64051f
C7598 a_82527_127455# user_project_wrapper_0.IOVSS1 1.01351f
C7599 a_83164_127820# user_project_wrapper_0.IOVSS1 0.17884f
C7600 a_82840_127455# user_project_wrapper_0.IOVSS1 0.3258f
C7601 a_89114_127896# user_project_wrapper_0.IOVSS1 0.40375f
C7602 a_87434_127896# user_project_wrapper_0.IOVSS1 0.72802f
C7603 a_88274_127896# user_project_wrapper_0.IOVSS1 0.37457f
C7604 a_86594_127896# user_project_wrapper_0.IOVSS1 0.62977f
C7605 a_79038_127856# user_project_wrapper_0.IOVSS1 0.56968f
C7606 a_78220_128106# user_project_wrapper_0.IOVSS1 1.10911f
C7607 a_78220_128192# user_project_wrapper_0.IOVSS1 0.25729f $ **FLOATING
C7608 a_79038_128322# user_project_wrapper_0.IOVSS1 0.71784f
C7609 a_83796_128838# user_project_wrapper_0.IOVSS1 0.07974f
C7610 a_83389_128838# user_project_wrapper_0.IOVSS1 0.0851f
C7611 a_82658_128838# user_project_wrapper_0.IOVSS1 0.07974f
C7612 a_93400_129062# user_project_wrapper_0.IOVSS1 0.08614f
C7613 a_93298_129062# user_project_wrapper_0.IOVSS1 0.00261f
C7614 a_92512_129061# user_project_wrapper_0.IOVSS1 0.07823f
C7615 a_91090_129060# user_project_wrapper_0.IOVSS1 0.07974f
C7616 a_89114_129061# user_project_wrapper_0.IOVSS1 0.07974f
C7617 a_88274_129061# user_project_wrapper_0.IOVSS1 0.07974f
C7618 a_87434_129061# user_project_wrapper_0.IOVSS1 0.07991f
C7619 a_86594_129061# user_project_wrapper_0.IOVSS1 0.08041f
C7620 a_93204_129062# user_project_wrapper_0.IOVSS1 0.25389f
C7621 a_93461_128591# user_project_wrapper_0.IOVSS1 0.75388f
C7622 a_92512_129426# user_project_wrapper_0.IOVSS1 0.89565f
C7623 a_91911_129060# user_project_wrapper_0.IOVSS1 0.9804f
C7624 a_91090_129425# user_project_wrapper_0.IOVSS1 0.39415f
C7625 a_86507_127725# user_project_wrapper_0.IOVSS1 4.07836f
C7626 a_90579_129060# user_project_wrapper_0.IOVSS1 0.36539f
C7627 a_83492_127455# user_project_wrapper_0.IOVSS1 3.98013f
C7628 a_89953_129061# user_project_wrapper_0.IOVSS1 1.73109f
C7629 a_79025_129164# user_project_wrapper_0.IOVSS1 0.17572f
C7630 a_82658_129203# user_project_wrapper_0.IOVSS1 0.75622f
C7631 a_83389_129203# user_project_wrapper_0.IOVSS1 0.2525f
C7632 a_83079_128838# user_project_wrapper_0.IOVSS1 0.32373f
C7633 a_82348_128838# user_project_wrapper_0.IOVSS1 0.32792f
C7634 a_78824_128711# user_project_wrapper_0.IOVSS1 0.54706f
C7635 a_89114_129426# user_project_wrapper_0.IOVSS1 0.40286f
C7636 a_87434_129426# user_project_wrapper_0.IOVSS1 0.65056f
C7637 a_88274_129426# user_project_wrapper_0.IOVSS1 0.37368f
C7638 a_86594_129426# user_project_wrapper_0.IOVSS1 0.62802f
C7639 a_79025_129571# user_project_wrapper_0.IOVSS1 1.41946f
C7640 a_84598_130212# user_project_wrapper_0.IOVSS1 0.08089f
C7641 a_83492_130212# user_project_wrapper_0.IOVSS1 0.07884f
C7642 a_83070_130212# user_project_wrapper_0.IOVSS1 0.07993f
C7643 a_369456_144061# user_project_wrapper_0.IOVSS1 0.56457f $ **FLOATING
C7644 a_369296_135844# user_project_wrapper_0.IOVSS1 27.0586f
C7645 a_355784_144061# user_project_wrapper_0.IOVSS1 0.05224f $ **FLOATING
C7646 a_355624_135844# user_project_wrapper_0.IOVSS1 0.48855f
C7647 a_87105_130470# user_project_wrapper_0.IOVSS1 0.07974f
C7648 a_79038_130026# user_project_wrapper_0.IOVSS1 0.56968f
C7649 a_78220_128592# user_project_wrapper_0.IOVSS1 1.24588f
C7650 a_84598_130577# user_project_wrapper_0.IOVSS1 2.26273f
C7651 analog_io[19] user_project_wrapper_0.IOVSS1 0.35506p
C7652 a_343292_141418# user_project_wrapper_0.IOVSS1 0.47314f $ **FLOATING
C7653 a_87105_130835# user_project_wrapper_0.IOVSS1 2.34153f
C7654 a_83925_130212# user_project_wrapper_0.IOVSS1 0.75684f
C7655 a_84288_130212# user_project_wrapper_0.IOVSS1 0.32784f
C7656 a_83796_129203# user_project_wrapper_0.IOVSS1 0.72361f
C7657 a_83398_130212# user_project_wrapper_0.IOVSS1 0.2792f
C7658 a_82433_130212# user_project_wrapper_0.IOVSS1 0.88198f
C7659 a_83070_130577# user_project_wrapper_0.IOVSS1 0.17842f
C7660 a_79025_125231# user_project_wrapper_0.IOVSS1 2.00152f
C7661 a_82746_130212# user_project_wrapper_0.IOVSS1 0.32335f
C7662 a_79025_127401# user_project_wrapper_0.IOVSS1 1.88912f
C7663 a_78220_130291# user_project_wrapper_0.IOVSS1 0.25729f $ **FLOATING
C7664 a_41476_115444# user_project_wrapper_0.IOVSS1 0.48855f
C7665 a_41636_123661# user_project_wrapper_0.IOVSS1 0.05224f $ **FLOATING
C7666 user_project_wrapper_0.analog_io[0] user_project_wrapper_0.IOVSS1 0.35506p
C7667 a_29676_115444# user_project_wrapper_0.IOVSS1 27.0586f
C7668 a_29836_123661# user_project_wrapper_0.IOVSS1 0.56457f $ **FLOATING
C7669 a_79038_130492# user_project_wrapper_0.IOVSS1 0.71784f
C7670 a_86507_129255# user_project_wrapper_0.IOVSS1 2.98338f
C7671 a_86594_130470# user_project_wrapper_0.IOVSS1 0.3817f
C7672 a_79025_131334# user_project_wrapper_0.IOVSS1 0.17572f
C7673 a_78824_130881# user_project_wrapper_0.IOVSS1 0.54706f
C7674 a_85127_131750# user_project_wrapper_0.IOVSS1 2.81263f
C7675 a_84707_131750# user_project_wrapper_0.IOVSS1 0.39334f
C7676 a_79025_131741# user_project_wrapper_0.IOVSS1 4.20296f
C7677 a_79038_132196# user_project_wrapper_0.IOVSS1 0.56987f
C7678 a_78220_130691# user_project_wrapper_0.IOVSS1 1.26517f
C7679 a_78220_132587# user_project_wrapper_0.IOVSS1 0.25729f $ **FLOATING
C7680 a_79038_132662# user_project_wrapper_0.IOVSS1 0.71784f
C7681 a_79025_133504# user_project_wrapper_0.IOVSS1 0.17572f
C7682 a_78824_133051# user_project_wrapper_0.IOVSS1 0.54636f
C7683 a_79025_133911# user_project_wrapper_0.IOVSS1 2.54235f
C7684 a_79038_134366# user_project_wrapper_0.IOVSS1 0.56984f
C7685 a_78219_134797# user_project_wrapper_0.IOVSS1 1.26404f
C7686 a_79038_134832# user_project_wrapper_0.IOVSS1 0.71784f
C7687 a_78219_134883# user_project_wrapper_0.IOVSS1 0.25767f $ **FLOATING
C7688 a_79025_135674# user_project_wrapper_0.IOVSS1 0.17572f
C7689 a_78824_135221# user_project_wrapper_0.IOVSS1 0.54438f
C7690 a_79025_136081# user_project_wrapper_0.IOVSS1 3.25406f
C7691 a_79038_136536# user_project_wrapper_0.IOVSS1 0.56984f
C7692 a_78219_135283# user_project_wrapper_0.IOVSS1 1.23306f
C7693 a_79038_137002# user_project_wrapper_0.IOVSS1 0.72019f
C7694 a_78219_136982# user_project_wrapper_0.IOVSS1 0.25771f $ **FLOATING
C7695 a_79025_137844# user_project_wrapper_0.IOVSS1 0.20113f
C7696 a_78824_137391# user_project_wrapper_0.IOVSS1 0.56236f
C7697 a_79025_138251# user_project_wrapper_0.IOVSS1 2.97646f
C7698 a_78218_138195# user_project_wrapper_0.IOVSS1 0.46821f
C7699 a_78218_138281# user_project_wrapper_0.IOVSS1 0.26211f $ **FLOATING
C7700 a_369456_164461# user_project_wrapper_0.IOVSS1 0.56457f $ **FLOATING
C7701 a_369296_156244# user_project_wrapper_0.IOVSS1 27.0586f
C7702 a_355784_164461# user_project_wrapper_0.IOVSS1 0.05224f $ **FLOATING
C7703 a_355624_156244# user_project_wrapper_0.IOVSS1 0.48855f
C7704 a_343292_161818# user_project_wrapper_0.IOVSS1 0.47314f $ **FLOATING
C7705 a_369456_184861# user_project_wrapper_0.IOVSS1 0.56457f $ **FLOATING
C7706 a_369296_176644# user_project_wrapper_0.IOVSS1 27.0586f
C7707 a_355784_184861# user_project_wrapper_0.IOVSS1 0.05224f $ **FLOATING
C7708 a_355624_176644# user_project_wrapper_0.IOVSS1 0.48855f
C7709 a_343292_182218# user_project_wrapper_0.IOVSS1 0.47314f $ **FLOATING
C7710 user_project_wrapper_0.sg13g2_IOPadAnalog_3.padres user_project_wrapper_0.IOVSS1 6.48953f
C7711 a_56308_141418# user_project_wrapper_0.IOVSS1 0.47314f $ **FLOATING
C7712 user_project_wrapper_0.sg13g2_IOPadAnalog_9.padres user_project_wrapper_0.IOVSS1 18.3186f
C7713 a_41476_135844# user_project_wrapper_0.IOVSS1 0.48855f
C7714 a_41636_144061# user_project_wrapper_0.IOVSS1 0.05224f $ **FLOATING
C7715 user_project_wrapper_0.analog_io[1] user_project_wrapper_0.IOVSS1 0.35506p
C7716 a_29676_135844# user_project_wrapper_0.IOVSS1 27.0586f
C7717 a_29836_144061# user_project_wrapper_0.IOVSS1 0.56457f $ **FLOATING
C7718 user_project_wrapper_0.sg13g2_IOPadIn$1_0.p2c user_project_wrapper_0.IOVSS1 18.4566f
C7719 a_59490_159238# user_project_wrapper_0.IOVSS1 0.69694f
C7720 a_56308_159337# user_project_wrapper_0.IOVSS1 0.47462f $ **FLOATING
C7721 user_project_wrapper_0.sg13g2_IOPadIn$1_0.sg13g2_LevelDown_noptap$1_0.sg13g2_SecondaryProtection$1$1_0.core user_project_wrapper_0.IOVSS1 5.66599f
C7722 user_project_wrapper_0.ui_PAD[2] user_project_wrapper_0.IOVSS1 0.22114p
C7723 a_58798_179249# user_project_wrapper_0.IOVSS1 2.06953f
C7724 a_58170_179249# user_project_wrapper_0.IOVSS1 0.42884f
C7725 a_57810_179517# user_project_wrapper_0.IOVSS1 0.74435f
C7726 user_project_wrapper_0.sg13g2_IOPadOut4mA$1_0.c2p user_project_wrapper_0.IOVSS1 40.6577f
C7727 analog_io[20] user_project_wrapper_0.IOVSS1 0.8029p
C7728 a_311108_179669# user_project_wrapper_0.IOVSS1 19.8436f
C7729 a_311189_185546# user_project_wrapper_0.IOVSS1 2.0354f
C7730 a_313884_185173# user_project_wrapper_0.IOVSS1 5.59673f
C7731 a_58798_179951# user_project_wrapper_0.IOVSS1 1.36737f
C7732 a_58170_179951# user_project_wrapper_0.IOVSS1 0.20048f
C7733 a_57810_180219# user_project_wrapper_0.IOVSS1 0.75266f
C7734 user_project_wrapper_0.sg13g2_IOPadAnalog_1.padres user_project_wrapper_0.IOVSS1 48.6377f
C7735 a_305619_187719# user_project_wrapper_0.IOVSS1 0.95252f $ **FLOATING
C7736 a_301575_187719# user_project_wrapper_0.IOVSS1 2.67682f $ **FLOATING
C7737 a_369456_205261# user_project_wrapper_0.IOVSS1 0.56457f $ **FLOATING
C7738 a_369296_197044# user_project_wrapper_0.IOVSS1 27.0586f
C7739 a_355784_205261# user_project_wrapper_0.IOVSS1 0.05224f $ **FLOATING
C7740 a_355624_197044# user_project_wrapper_0.IOVSS1 0.48855f
C7741 analog_io[22] user_project_wrapper_0.IOVSS1 0.35506p
C7742 a_343292_202618# user_project_wrapper_0.IOVSS1 0.47314f $ **FLOATING
C7743 a_315347_192734# user_project_wrapper_0.IOVSS1 2.08682f $ **FLOATING
C7744 a_315347_192648# user_project_wrapper_0.IOVSS1 7.86967f
C7745 a_314793_197200# user_project_wrapper_0.IOVSS1 8.5743f
C7746 user_project_wrapper_0.sg13g2_IOPadAnalog_29.padres user_project_wrapper_0.IOVSS1 22.9416f
C7747 a_311846_195517# user_project_wrapper_0.IOVSS1 6.60821f
C7748 a_309917_194695# user_project_wrapper_0.IOVSS1 0.44046f
C7749 a_314697_196700# user_project_wrapper_0.IOVSS1 12.8606f
C7750 a_309917_199879# user_project_wrapper_0.IOVSS1 0.42011f
C7751 a_296731_189665# user_project_wrapper_0.IOVSS1 43.9822f
C7752 a_301509_196360# user_project_wrapper_0.IOVSS1 0.12038f $ **FLOATING
C7753 a_301423_196360# user_project_wrapper_0.IOVSS1 2.04024f
C7754 a_296625_189595# user_project_wrapper_0.IOVSS1 6.41658f
C7755 a_296732_197880# user_project_wrapper_0.IOVSS1 1.33031f
C7756 a_304196_197873# user_project_wrapper_0.IOVSS1 1.0378f
C7757 a_304889_199957# user_project_wrapper_0.IOVSS1 4.9266f
C7758 a_304196_200821# user_project_wrapper_0.IOVSS1 1.03689f
C7759 a_307232_196607# user_project_wrapper_0.IOVSS1 27.9116f
C7760 a_304995_198817# user_project_wrapper_0.IOVSS1 21.7278f
C7761 a_301509_202742# user_project_wrapper_0.IOVSS1 0.12038f $ **FLOATING
C7762 a_301423_202742# user_project_wrapper_0.IOVSS1 2.04024f
C7763 a_296732_200582# user_project_wrapper_0.IOVSS1 1.33097f
C7764 a_309516_194555# user_project_wrapper_0.IOVSS1 10.5364f
C7765 a_314793_201808# user_project_wrapper_0.IOVSS1 93.5958f
C7766 a_304090_197941# user_project_wrapper_0.IOVSS1 6.07704f
C7767 a_301940_196388# user_project_wrapper_0.IOVSS1 3.00388f
C7768 a_296626_197740# user_project_wrapper_0.IOVSS1 4.67731f
C7769 a_296625_208423# user_project_wrapper_0.IOVSS1 6.45658f
C7770 a_301186_192011# user_project_wrapper_0.IOVSS1 96.7196f
C7771 user_project_wrapper_0.sg13g2_IOPadOut4mA$1_0.sg13g2_GateLevelUpInv_noptap$1$1_0.pgate user_project_wrapper_0.IOVSS1 11.3207f
C7772 user_project_wrapper_0.uo_PAD[3] user_project_wrapper_0.IOVSS1 0.20495p
C7773 user_project_wrapper_0.sg13g2_IOPadOut4mA$1_0.sg13g2_GateLevelUpInv_noptap$1$1_0.ngate user_project_wrapper_0.IOVSS1 29.8073f
C7774 a_56308_202618# user_project_wrapper_0.IOVSS1 0.47314f $ **FLOATING
C7775 user_project_wrapper_0.sg13g2_IOPadAnalog_28.padres user_project_wrapper_0.IOVSS1 6.48953f
C7776 a_369456_225661# user_project_wrapper_0.IOVSS1 0.56457f $ **FLOATING
C7777 a_369296_217444# user_project_wrapper_0.IOVSS1 27.0586f
C7778 a_355784_225661# user_project_wrapper_0.IOVSS1 0.05224f $ **FLOATING
C7779 a_355624_217444# user_project_wrapper_0.IOVSS1 0.48855f
C7780 a_343292_223018# user_project_wrapper_0.IOVSS1 0.47314f $ **FLOATING
C7781 a_314793_198352# user_project_wrapper_0.IOVSS1 8.68659f
C7782 a_305619_211562# user_project_wrapper_0.IOVSS1 0.95252f $ **FLOATING
C7783 a_304889_198885# user_project_wrapper_0.IOVSS1 4.83261f
C7784 a_301575_211562# user_project_wrapper_0.IOVSS1 2.67677f $ **FLOATING
C7785 a_296731_208493# user_project_wrapper_0.IOVSS1 42.7591f
C7786 a_311189_211724# user_project_wrapper_0.IOVSS1 2.03307f
C7787 a_41476_197044# user_project_wrapper_0.IOVSS1 0.48855f
C7788 a_41636_205261# user_project_wrapper_0.IOVSS1 0.05224f $ **FLOATING
C7789 a_29676_197044# user_project_wrapper_0.IOVSS1 27.0586f
C7790 a_29836_205261# user_project_wrapper_0.IOVSS1 0.56457f $ **FLOATING
C7791 a_313884_211353# user_project_wrapper_0.IOVSS1 5.58988f
C7792 a_311108_215937# user_project_wrapper_0.IOVSS1 19.8436f
C7793 a_369456_246061# user_project_wrapper_0.IOVSS1 0.56457f $ **FLOATING
C7794 a_369296_237844# user_project_wrapper_0.IOVSS1 27.0586f
C7795 a_355784_246061# user_project_wrapper_0.IOVSS1 0.05224f $ **FLOATING
C7796 a_355624_237844# user_project_wrapper_0.IOVSS1 0.48855f
C7797 analog_io[23] user_project_wrapper_0.IOVSS1 0.80026p
C7798 a_343292_243418# user_project_wrapper_0.IOVSS1 0.47314f $ **FLOATING
C7799 user_project_wrapper_0.sg13g2_IOPadAnalog_25.padres user_project_wrapper_0.IOVSS1 6.48953f
C7800 a_56308_223018# user_project_wrapper_0.IOVSS1 0.47314f $ **FLOATING
C7801 a_41476_217444# user_project_wrapper_0.IOVSS1 0.48855f
C7802 a_41636_225661# user_project_wrapper_0.IOVSS1 0.05224f $ **FLOATING
C7803 user_project_wrapper_0.analog_io[5] user_project_wrapper_0.IOVSS1 0.35506p
C7804 a_29676_217444# user_project_wrapper_0.IOVSS1 27.0586f
C7805 a_29836_225661# user_project_wrapper_0.IOVSS1 0.56457f $ **FLOATING
C7806 a_82118_238718# user_project_wrapper_0.IOVSS1 0.28186f $ **FLOATING
C7807 a_82859_239376# user_project_wrapper_0.IOVSS1 0.59387f
C7808 a_82859_239842# user_project_wrapper_0.IOVSS1 0.71782f
C7809 a_82846_240684# user_project_wrapper_0.IOVSS1 0.41702f
C7810 a_82118_239118# user_project_wrapper_0.IOVSS1 1.15769f
C7811 a_82645_240231# user_project_wrapper_0.IOVSS1 0.5641f
C7812 a_82118_240839# user_project_wrapper_0.IOVSS1 0.2553f $ **FLOATING
C7813 a_85591_241383# user_project_wrapper_0.IOVSS1 0.0854f
C7814 a_87832_241383# user_project_wrapper_0.IOVSS1 0.50422f
C7815 a_86407_241748# user_project_wrapper_0.IOVSS1 0
C7816 a_85989_241748# user_project_wrapper_0.IOVSS1 0.00104f
C7817 a_82859_241546# user_project_wrapper_0.IOVSS1 0.56113f
C7818 a_86970_241383# user_project_wrapper_0.IOVSS1 0.35843f
C7819 a_82846_241091# user_project_wrapper_0.IOVSS1 1.58626f
C7820 a_85989_241383# user_project_wrapper_0.IOVSS1 0.80772f
C7821 a_86046_241645# user_project_wrapper_0.IOVSS1 0.41586f
C7822 a_85591_241748# user_project_wrapper_0.IOVSS1 0.27555f
C7823 user_project_wrapper_0.sg13g2_IOPadIn$1_1.p2c user_project_wrapper_0.IOVSS1 82.3648f
C7824 a_85287_241383# user_project_wrapper_0.IOVSS1 0.34092f
C7825 user_project_wrapper_0.sg13g2_IOPadAnalog_15.padres user_project_wrapper_0.IOVSS1 17.6538f
C7826 user_project_wrapper_0.sg13g2_IOPadAnalog_8.padres user_project_wrapper_0.IOVSS1 68.1934f
C7827 a_82859_242012# user_project_wrapper_0.IOVSS1 0.71232f
C7828 user_project_wrapper_0.analog_io[4] user_project_wrapper_0.IOVSS1 0.38456p
C7829 a_82118_242359# user_project_wrapper_0.IOVSS1 0.25429f $ **FLOATING
C7830 a_82846_242854# user_project_wrapper_0.IOVSS1 0.20315f
C7831 a_82645_242401# user_project_wrapper_0.IOVSS1 0.55559f
C7832 a_82846_243261# user_project_wrapper_0.IOVSS1 1.18074f
C7833 a_369456_266461# user_project_wrapper_0.IOVSS1 0.56457f $ **FLOATING
C7834 a_369296_258244# user_project_wrapper_0.IOVSS1 27.0586f
C7835 a_355784_266461# user_project_wrapper_0.IOVSS1 0.05224f $ **FLOATING
C7836 a_355624_258244# user_project_wrapper_0.IOVSS1 0.48855f
C7837 analog_io[25] user_project_wrapper_0.IOVSS1 0.35506p
C7838 a_343292_263818# user_project_wrapper_0.IOVSS1 0.47314f $ **FLOATING
C7839 user_project_wrapper_0.sg13g2_IOPadAnalog_26.padres user_project_wrapper_0.IOVSS1 52.4672f
C7840 a_369456_286861# user_project_wrapper_0.IOVSS1 0.56457f $ **FLOATING
C7841 a_369296_278644# user_project_wrapper_0.IOVSS1 27.0586f
C7842 a_355784_286861# user_project_wrapper_0.IOVSS1 0.05224f $ **FLOATING
C7843 a_355624_278644# user_project_wrapper_0.IOVSS1 0.48855f
C7844 analog_io[26] user_project_wrapper_0.IOVSS1 0.35506p
C7845 a_343292_284218# user_project_wrapper_0.IOVSS1 0.47314f $ **FLOATING
C7846 user_project_wrapper_0.sg13g2_IOPadAnalog_27.padres user_project_wrapper_0.IOVSS1 6.48953f
C7847 a_360458_297775# user_project_wrapper_0.IOVSS1 3.53976f $ **FLOATING
C7848 a_364458_297775# user_project_wrapper_0.IOVSS1 0.46084f
C7849 a_360458_298105# user_project_wrapper_0.IOVSS1 3.04218f $ **FLOATING
C7850 a_360458_298435# user_project_wrapper_0.IOVSS1 3.04229f $ **FLOATING
C7851 a_360372_298105# user_project_wrapper_0.IOVSS1 0.41869f
C7852 a_364458_298435# user_project_wrapper_0.IOVSS1 0.43535f
C7853 a_360458_298765# user_project_wrapper_0.IOVSS1 3.04218f $ **FLOATING
C7854 a_360458_299095# user_project_wrapper_0.IOVSS1 3.04229f $ **FLOATING
C7855 a_360372_298765# user_project_wrapper_0.IOVSS1 0.41869f
C7856 a_364458_299095# user_project_wrapper_0.IOVSS1 0.43539f
C7857 a_360458_299425# user_project_wrapper_0.IOVSS1 3.04218f $ **FLOATING
C7858 a_360458_299755# user_project_wrapper_0.IOVSS1 3.04218f $ **FLOATING
C7859 a_360372_299425# user_project_wrapper_0.IOVSS1 0.41869f
C7860 a_364458_299755# user_project_wrapper_0.IOVSS1 0.43539f
C7861 a_360458_300085# user_project_wrapper_0.IOVSS1 3.04218f $ **FLOATING
C7862 a_360458_300415# user_project_wrapper_0.IOVSS1 3.04218f $ **FLOATING
C7863 a_360372_300085# user_project_wrapper_0.IOVSS1 0.41869f
C7864 a_364458_300415# user_project_wrapper_0.IOVSS1 0.43541f
C7865 a_360458_300745# user_project_wrapper_0.IOVSS1 3.04224f $ **FLOATING
C7866 a_360458_301075# user_project_wrapper_0.IOVSS1 3.04218f $ **FLOATING
C7867 a_360372_300745# user_project_wrapper_0.IOVSS1 0.41869f
C7868 a_364458_301075# user_project_wrapper_0.IOVSS1 0.43537f
C7869 a_360458_301405# user_project_wrapper_0.IOVSS1 3.04229f $ **FLOATING
C7870 a_360458_301735# user_project_wrapper_0.IOVSS1 3.04218f $ **FLOATING
C7871 a_360372_301405# user_project_wrapper_0.IOVSS1 0.41869f
C7872 a_364458_301735# user_project_wrapper_0.IOVSS1 0.43535f
C7873 a_360458_302065# user_project_wrapper_0.IOVSS1 3.04229f $ **FLOATING
C7874 a_360458_302395# user_project_wrapper_0.IOVSS1 3.04218f $ **FLOATING
C7875 a_360372_302065# user_project_wrapper_0.IOVSS1 0.41869f
C7876 a_364458_302395# user_project_wrapper_0.IOVSS1 0.43535f
C7877 a_360458_302725# user_project_wrapper_0.IOVSS1 3.04229f $ **FLOATING
C7878 a_360458_303055# user_project_wrapper_0.IOVSS1 3.04218f $ **FLOATING
C7879 a_360372_302725# user_project_wrapper_0.IOVSS1 0.41869f
C7880 a_364458_303055# user_project_wrapper_0.IOVSS1 0.43538f
C7881 a_360458_303385# user_project_wrapper_0.IOVSS1 3.04218f $ **FLOATING
C7882 a_360458_303715# user_project_wrapper_0.IOVSS1 3.04218f $ **FLOATING
C7883 a_360372_303385# user_project_wrapper_0.IOVSS1 0.41869f
C7884 a_364458_303715# user_project_wrapper_0.IOVSS1 0.43539f
C7885 a_360458_304045# user_project_wrapper_0.IOVSS1 3.04218f $ **FLOATING
C7886 a_360458_304375# user_project_wrapper_0.IOVSS1 3.04226f $ **FLOATING
C7887 a_360372_304045# user_project_wrapper_0.IOVSS1 0.41869f
C7888 a_364458_304375# user_project_wrapper_0.IOVSS1 0.43536f
C7889 a_360458_304705# user_project_wrapper_0.IOVSS1 3.04218f $ **FLOATING
C7890 a_360458_305035# user_project_wrapper_0.IOVSS1 3.04229f $ **FLOATING
C7891 a_360372_304705# user_project_wrapper_0.IOVSS1 0.41869f
C7892 a_364458_305035# user_project_wrapper_0.IOVSS1 0.43535f
C7893 a_360458_305365# user_project_wrapper_0.IOVSS1 3.04218f $ **FLOATING
C7894 a_360458_305695# user_project_wrapper_0.IOVSS1 3.04229f $ **FLOATING
C7895 a_360372_305365# user_project_wrapper_0.IOVSS1 0.41869f
C7896 a_364458_305695# user_project_wrapper_0.IOVSS1 0.46084f
C7897 a_360458_306025# user_project_wrapper_0.IOVSS1 3.53966f $ **FLOATING
C7898 user_project_wrapper_0.sg13g2_IOPadIOVdd_3.sg13g2_Clamp_N43N43D4R_0.gate user_project_wrapper_0.IOVSS1 0.18346p
C7899 user_project_wrapper_0.sg13g2_IOPadIOVdd_3.sg13g2_RCClampResistor_0.p2 user_project_wrapper_0.IOVSS1 0.15451p
C7900 a_56308_243418# user_project_wrapper_0.IOVSS1 0.47314f $ **FLOATING
C7901 user_project_wrapper_0.sg13g2_IOPadAnalog_14.padres user_project_wrapper_0.IOVSS1 14.396f
C7902 a_41476_237844# user_project_wrapper_0.IOVSS1 0.48855f
C7903 a_41636_246061# user_project_wrapper_0.IOVSS1 0.05224f $ **FLOATING
C7904 user_project_wrapper_0.analog_io[6] user_project_wrapper_0.IOVSS1 0.35506p
C7905 a_29676_237844# user_project_wrapper_0.IOVSS1 27.0586f
C7906 a_29836_246061# user_project_wrapper_0.IOVSS1 0.56457f $ **FLOATING
C7907 a_56308_263818# user_project_wrapper_0.IOVSS1 0.47314f $ **FLOATING
C7908 user_project_wrapper_0.sg13g2_IOPadAnalog_13.padres user_project_wrapper_0.IOVSS1 6.48953f
C7909 a_41476_258244# user_project_wrapper_0.IOVSS1 0.48855f
C7910 a_41636_266461# user_project_wrapper_0.IOVSS1 0.05224f $ **FLOATING
C7911 user_project_wrapper_0.analog_io[7] user_project_wrapper_0.IOVSS1 0.37644p
C7912 a_29676_258244# user_project_wrapper_0.IOVSS1 27.0586f
C7913 a_29836_266461# user_project_wrapper_0.IOVSS1 0.56457f $ **FLOATING
C7914 a_58798_281249# user_project_wrapper_0.IOVSS1 2.06953f
C7915 a_58170_281249# user_project_wrapper_0.IOVSS1 0.42884f
C7916 a_57810_281517# user_project_wrapper_0.IOVSS1 0.74435f
C7917 user_project_wrapper_0.sg13g2_IOPadOut4mA$1_1.c2p user_project_wrapper_0.IOVSS1 27.6241f
C7918 a_58798_281951# user_project_wrapper_0.IOVSS1 1.36737f
C7919 a_58170_281951# user_project_wrapper_0.IOVSS1 0.20048f
C7920 a_57810_282219# user_project_wrapper_0.IOVSS1 0.75266f
C7921 user_project_wrapper_0.sg13g2_IOPadOut4mA$1_1.sg13g2_GateLevelUpInv_noptap$1$1_0.pgate user_project_wrapper_0.IOVSS1 11.3207f
C7922 user_project_wrapper_0.uo_PAD[8] user_project_wrapper_0.IOVSS1 0.20495p
C7923 user_project_wrapper_0.sg13g2_IOPadOut4mA$1_1.sg13g2_GateLevelUpInv_noptap$1$1_0.ngate user_project_wrapper_0.IOVSS1 29.8073f
C7924 a_35542_297775# user_project_wrapper_0.IOVSS1 3.53976f $ **FLOATING
C7925 a_35542_298105# user_project_wrapper_0.IOVSS1 3.04218f $ **FLOATING
C7926 a_35456_297775# user_project_wrapper_0.IOVSS1 0.46084f
C7927 a_39542_298105# user_project_wrapper_0.IOVSS1 0.41869f
C7928 a_35542_298435# user_project_wrapper_0.IOVSS1 3.04229f $ **FLOATING
C7929 a_35542_298765# user_project_wrapper_0.IOVSS1 3.04218f $ **FLOATING
C7930 a_35456_298435# user_project_wrapper_0.IOVSS1 0.43535f
C7931 a_39542_298765# user_project_wrapper_0.IOVSS1 0.41869f
C7932 a_35542_299095# user_project_wrapper_0.IOVSS1 3.04229f $ **FLOATING
C7933 a_35542_299425# user_project_wrapper_0.IOVSS1 3.04218f $ **FLOATING
C7934 a_35456_299095# user_project_wrapper_0.IOVSS1 0.43539f
C7935 a_39542_299425# user_project_wrapper_0.IOVSS1 0.41869f
C7936 a_35542_299755# user_project_wrapper_0.IOVSS1 3.04218f $ **FLOATING
C7937 a_35542_300085# user_project_wrapper_0.IOVSS1 3.04218f $ **FLOATING
C7938 a_35456_299755# user_project_wrapper_0.IOVSS1 0.43539f
C7939 a_39542_300085# user_project_wrapper_0.IOVSS1 0.41869f
C7940 a_35542_300415# user_project_wrapper_0.IOVSS1 3.04218f $ **FLOATING
C7941 a_35542_300745# user_project_wrapper_0.IOVSS1 3.04224f $ **FLOATING
C7942 a_35456_300415# user_project_wrapper_0.IOVSS1 0.43541f
C7943 a_39542_300745# user_project_wrapper_0.IOVSS1 0.41869f
C7944 a_35542_301075# user_project_wrapper_0.IOVSS1 3.04218f $ **FLOATING
C7945 a_35542_301405# user_project_wrapper_0.IOVSS1 3.04229f $ **FLOATING
C7946 a_35456_301075# user_project_wrapper_0.IOVSS1 0.43537f
C7947 a_39542_301405# user_project_wrapper_0.IOVSS1 0.41869f
C7948 a_35542_301735# user_project_wrapper_0.IOVSS1 3.04218f $ **FLOATING
C7949 a_35542_302065# user_project_wrapper_0.IOVSS1 3.04229f $ **FLOATING
C7950 a_35456_301735# user_project_wrapper_0.IOVSS1 0.43535f
C7951 a_39542_302065# user_project_wrapper_0.IOVSS1 0.41869f
C7952 a_35542_302395# user_project_wrapper_0.IOVSS1 3.04218f $ **FLOATING
C7953 a_35542_302725# user_project_wrapper_0.IOVSS1 3.04229f $ **FLOATING
C7954 a_35456_302395# user_project_wrapper_0.IOVSS1 0.43535f
C7955 a_39542_302725# user_project_wrapper_0.IOVSS1 0.41869f
C7956 a_35542_303055# user_project_wrapper_0.IOVSS1 3.04218f $ **FLOATING
C7957 a_35542_303385# user_project_wrapper_0.IOVSS1 3.04218f $ **FLOATING
C7958 a_35456_303055# user_project_wrapper_0.IOVSS1 0.43538f
C7959 a_39542_303385# user_project_wrapper_0.IOVSS1 0.41869f
C7960 a_35542_303715# user_project_wrapper_0.IOVSS1 3.04218f $ **FLOATING
C7961 a_35542_304045# user_project_wrapper_0.IOVSS1 3.04218f $ **FLOATING
C7962 a_35456_303715# user_project_wrapper_0.IOVSS1 0.43539f
C7963 a_39542_304045# user_project_wrapper_0.IOVSS1 0.41869f
C7964 a_35542_304375# user_project_wrapper_0.IOVSS1 3.04226f $ **FLOATING
C7965 a_35542_304705# user_project_wrapper_0.IOVSS1 3.04218f $ **FLOATING
C7966 a_35456_304375# user_project_wrapper_0.IOVSS1 0.43536f
C7967 a_39542_304705# user_project_wrapper_0.IOVSS1 0.41869f
C7968 a_35542_305035# user_project_wrapper_0.IOVSS1 3.04229f $ **FLOATING
C7969 a_35542_305365# user_project_wrapper_0.IOVSS1 3.04218f $ **FLOATING
C7970 a_35456_305035# user_project_wrapper_0.IOVSS1 0.43535f
C7971 a_39542_305365# user_project_wrapper_0.IOVSS1 0.41869f
C7972 a_35542_305695# user_project_wrapper_0.IOVSS1 3.04229f $ **FLOATING
C7973 user_project_wrapper_0.sg13g2_IOPadIOVdd_1.sg13g2_RCClampResistor_0.p2 user_project_wrapper_0.IOVSS1 0.15451p
C7974 a_35542_306025# user_project_wrapper_0.IOVSS1 3.53966f $ **FLOATING
C7975 a_35456_305695# user_project_wrapper_0.IOVSS1 0.46084f
C7976 user_project_wrapper_0.sg13g2_IOPadIOVdd_1.sg13g2_Clamp_N43N43D4R_0.gate user_project_wrapper_0.IOVSS1 0.18346p
C7977 a_208920_324155# user_project_wrapper_0.IOVSS1 0.24321f
C7978 a_209997_324870# user_project_wrapper_0.IOVSS1 0.13838f
C7979 a_211928_324776# user_project_wrapper_0.IOVSS1 1.23911f
C7980 a_211321_324119# user_project_wrapper_0.IOVSS1 0.99748f
C7981 a_210983_324119# user_project_wrapper_0.IOVSS1 0.99249f
C7982 a_210645_324119# user_project_wrapper_0.IOVSS1 0.98345f
C7983 a_210307_324119# user_project_wrapper_0.IOVSS1 0.98004f
C7984 a_209940_324686# user_project_wrapper_0.IOVSS1 0.5511f
C7985 a_209869_324119# user_project_wrapper_0.IOVSS1 0.83261f
C7986 a_209638_324119# user_project_wrapper_0.IOVSS1 0.90873f
C7987 a_209230_324119# user_project_wrapper_0.IOVSS1 1.32059f
C7988 a_208792_324119# user_project_wrapper_0.IOVSS1 0.5523f
C7989 a_208579_324119# user_project_wrapper_0.IOVSS1 0.95479f
C7990 a_208171_324119# user_project_wrapper_0.IOVSS1 1.33498f
C7991 a_211921_325358# user_project_wrapper_0.IOVSS1 0.07903f $ **FLOATING
C7992 a_211537_325358# user_project_wrapper_0.IOVSS1 0.08007f $ **FLOATING
C7993 a_211153_325358# user_project_wrapper_0.IOVSS1 0.08072f $ **FLOATING
C7994 a_210109_325263# user_project_wrapper_0.IOVSS1 0.13836f
C7995 a_209905_325263# user_project_wrapper_0.IOVSS1 0.13983f
C7996 a_209041_325263# user_project_wrapper_0.IOVSS1 0.14102f
C7997 a_208469_325263# user_project_wrapper_0.IOVSS1 0.1407f
C7998 a_211921_325570# user_project_wrapper_0.IOVSS1 0.06628f $ **FLOATING
C7999 a_211537_325570# user_project_wrapper_0.IOVSS1 0.04801f $ **FLOATING
C8000 a_211153_325570# user_project_wrapper_0.IOVSS1 0.06596f $ **FLOATING
C8001 a_211921_325785# user_project_wrapper_0.IOVSS1 0.06617f $ **FLOATING
C8002 a_211537_325785# user_project_wrapper_0.IOVSS1 0.048f $ **FLOATING
C8003 a_211153_325785# user_project_wrapper_0.IOVSS1 0.06585f $ **FLOATING
C8004 a_211921_325997# user_project_wrapper_0.IOVSS1 0.07549f $ **FLOATING
C8005 a_211537_325997# user_project_wrapper_0.IOVSS1 0.07479f $ **FLOATING
C8006 a_211153_325997# user_project_wrapper_0.IOVSS1 0.07517f $ **FLOATING
C8007 a_210621_325263# user_project_wrapper_0.IOVSS1 1.8585f
C8008 a_210109_325785# user_project_wrapper_0.IOVSS1 0.24558f
C8009 a_209905_325785# user_project_wrapper_0.IOVSS1 0.24493f
C8010 a_209041_325785# user_project_wrapper_0.IOVSS1 0.24432f
C8011 a_208469_325785# user_project_wrapper_0.IOVSS1 0.24465f
C8012 a_189737_324155# user_project_wrapper_0.IOVSS1 0.24321f
C8013 a_190814_324870# user_project_wrapper_0.IOVSS1 0.13838f
C8014 a_192745_324776# user_project_wrapper_0.IOVSS1 1.23912f
C8015 a_192138_324119# user_project_wrapper_0.IOVSS1 0.98425f
C8016 a_191800_324119# user_project_wrapper_0.IOVSS1 0.98182f
C8017 a_191462_324119# user_project_wrapper_0.IOVSS1 0.97281f
C8018 a_191124_324119# user_project_wrapper_0.IOVSS1 0.96937f
C8019 a_190757_324686# user_project_wrapper_0.IOVSS1 0.54439f
C8020 a_190686_324119# user_project_wrapper_0.IOVSS1 0.81445f
C8021 a_190455_324119# user_project_wrapper_0.IOVSS1 0.90873f
C8022 a_190047_324119# user_project_wrapper_0.IOVSS1 1.30005f
C8023 a_189609_324119# user_project_wrapper_0.IOVSS1 0.55682f
C8024 a_189396_324119# user_project_wrapper_0.IOVSS1 0.95425f
C8025 a_188988_324119# user_project_wrapper_0.IOVSS1 1.34641f
C8026 a_192738_325358# user_project_wrapper_0.IOVSS1 0.07903f $ **FLOATING
C8027 a_192354_325358# user_project_wrapper_0.IOVSS1 0.08005f $ **FLOATING
C8028 a_191970_325358# user_project_wrapper_0.IOVSS1 0.08071f $ **FLOATING
C8029 a_190926_325263# user_project_wrapper_0.IOVSS1 0.13836f
C8030 a_190722_325263# user_project_wrapper_0.IOVSS1 0.13983f
C8031 a_189858_325263# user_project_wrapper_0.IOVSS1 0.14102f
C8032 a_189286_325263# user_project_wrapper_0.IOVSS1 0.1407f
C8033 a_192738_325570# user_project_wrapper_0.IOVSS1 0.06628f $ **FLOATING
C8034 a_192354_325570# user_project_wrapper_0.IOVSS1 0.04801f $ **FLOATING
C8035 a_191970_325570# user_project_wrapper_0.IOVSS1 0.06596f $ **FLOATING
C8036 a_192738_325785# user_project_wrapper_0.IOVSS1 0.06617f $ **FLOATING
C8037 a_192354_325785# user_project_wrapper_0.IOVSS1 0.048f $ **FLOATING
C8038 a_191970_325785# user_project_wrapper_0.IOVSS1 0.06585f $ **FLOATING
C8039 a_210417_325263# user_project_wrapper_0.IOVSS1 1.33945f
C8040 a_210007_325263# user_project_wrapper_0.IOVSS1 0.43379f
C8041 a_209480_325263# user_project_wrapper_0.IOVSS1 1.08162f
C8042 a_209684_325263# user_project_wrapper_0.IOVSS1 0.93884f
C8043 a_192738_325997# user_project_wrapper_0.IOVSS1 0.07549f $ **FLOATING
C8044 a_192354_325997# user_project_wrapper_0.IOVSS1 0.07479f $ **FLOATING
C8045 a_191970_325997# user_project_wrapper_0.IOVSS1 0.07517f $ **FLOATING
C8046 a_191438_325263# user_project_wrapper_0.IOVSS1 1.8585f
C8047 a_190926_325785# user_project_wrapper_0.IOVSS1 0.24558f
C8048 a_190722_325785# user_project_wrapper_0.IOVSS1 0.24493f
C8049 a_189858_325785# user_project_wrapper_0.IOVSS1 0.24432f
C8050 a_189286_325785# user_project_wrapper_0.IOVSS1 0.24465f
C8051 a_191234_325263# user_project_wrapper_0.IOVSS1 1.33945f
C8052 a_190824_325263# user_project_wrapper_0.IOVSS1 0.43379f
C8053 a_190297_325263# user_project_wrapper_0.IOVSS1 1.08162f
C8054 a_190501_325263# user_project_wrapper_0.IOVSS1 0.93884f
C8055 a_211921_326465# user_project_wrapper_0.IOVSS1 0.07548f $ **FLOATING
C8056 a_211537_326465# user_project_wrapper_0.IOVSS1 0.07477f $ **FLOATING
C8057 a_211153_326465# user_project_wrapper_0.IOVSS1 0.07515f $ **FLOATING
C8058 a_211921_326677# user_project_wrapper_0.IOVSS1 0.06614f $ **FLOATING
C8059 a_211537_326677# user_project_wrapper_0.IOVSS1 0.04796f $ **FLOATING
C8060 a_211153_326677# user_project_wrapper_0.IOVSS1 0.06582f $ **FLOATING
C8061 a_210109_326377# user_project_wrapper_0.IOVSS1 0.24559f
C8062 a_209905_326377# user_project_wrapper_0.IOVSS1 0.24497f
C8063 a_209041_326377# user_project_wrapper_0.IOVSS1 0.24512f
C8064 a_208469_326377# user_project_wrapper_0.IOVSS1 0.24624f
C8065 a_211921_326892# user_project_wrapper_0.IOVSS1 0.06625f $ **FLOATING
C8066 a_211537_326892# user_project_wrapper_0.IOVSS1 0.04796f $ **FLOATING
C8067 a_211153_326892# user_project_wrapper_0.IOVSS1 0.06591f $ **FLOATING
C8068 a_211921_327104# user_project_wrapper_0.IOVSS1 0.07788f $ **FLOATING
C8069 a_211537_327104# user_project_wrapper_0.IOVSS1 0.07666f $ **FLOATING
C8070 a_211153_327104# user_project_wrapper_0.IOVSS1 0.07756f $ **FLOATING
C8071 a_208855_324776# user_project_wrapper_0.IOVSS1 4.08841f
C8072 a_210621_326377# user_project_wrapper_0.IOVSS1 1.86896f
C8073 a_210109_327099# user_project_wrapper_0.IOVSS1 0.13855f
C8074 a_209905_327099# user_project_wrapper_0.IOVSS1 0.13998f
C8075 a_209041_327099# user_project_wrapper_0.IOVSS1 0.13989f
C8076 a_208469_327099# user_project_wrapper_0.IOVSS1 0.14012f
C8077 a_192738_326465# user_project_wrapper_0.IOVSS1 0.07548f $ **FLOATING
C8078 a_192354_326465# user_project_wrapper_0.IOVSS1 0.07477f $ **FLOATING
C8079 a_191970_326465# user_project_wrapper_0.IOVSS1 0.07515f $ **FLOATING
C8080 a_192738_326677# user_project_wrapper_0.IOVSS1 0.06614f $ **FLOATING
C8081 a_192354_326677# user_project_wrapper_0.IOVSS1 0.04796f $ **FLOATING
C8082 a_191970_326677# user_project_wrapper_0.IOVSS1 0.06582f $ **FLOATING
C8083 a_190926_326377# user_project_wrapper_0.IOVSS1 0.24559f
C8084 a_190722_326377# user_project_wrapper_0.IOVSS1 0.24497f
C8085 a_189858_326377# user_project_wrapper_0.IOVSS1 0.24512f
C8086 a_189286_326377# user_project_wrapper_0.IOVSS1 0.24621f
C8087 a_192738_326892# user_project_wrapper_0.IOVSS1 0.06625f $ **FLOATING
C8088 a_192354_326892# user_project_wrapper_0.IOVSS1 0.04796f $ **FLOATING
C8089 a_191970_326892# user_project_wrapper_0.IOVSS1 0.06591f $ **FLOATING
C8090 a_192738_327104# user_project_wrapper_0.IOVSS1 0.07788f $ **FLOATING
C8091 a_192354_327104# user_project_wrapper_0.IOVSS1 0.07666f $ **FLOATING
C8092 a_191970_327104# user_project_wrapper_0.IOVSS1 0.07756f $ **FLOATING
C8093 a_210417_326377# user_project_wrapper_0.IOVSS1 1.33733f
C8094 a_210007_326377# user_project_wrapper_0.IOVSS1 0.43817f
C8095 a_209480_326377# user_project_wrapper_0.IOVSS1 1.0677f
C8096 a_209684_326377# user_project_wrapper_0.IOVSS1 0.92523f
C8097 a_208367_326377# user_project_wrapper_0.IOVSS1 1.52782f
C8098 a_208939_326377# user_project_wrapper_0.IOVSS1 1.36548f
C8099 a_206547_324106# user_project_wrapper_0.IOVSS1 3.38391f
C8100 a_189672_324776# user_project_wrapper_0.IOVSS1 3.97582f
C8101 a_191438_326377# user_project_wrapper_0.IOVSS1 1.86896f
C8102 a_190926_327099# user_project_wrapper_0.IOVSS1 0.13855f
C8103 a_190722_327099# user_project_wrapper_0.IOVSS1 0.13998f
C8104 a_189858_327099# user_project_wrapper_0.IOVSS1 0.13989f
C8105 a_189286_327099# user_project_wrapper_0.IOVSS1 0.14012f
C8106 a_191234_326377# user_project_wrapper_0.IOVSS1 1.33733f
C8107 a_190824_326377# user_project_wrapper_0.IOVSS1 0.43817f
C8108 a_190297_326377# user_project_wrapper_0.IOVSS1 1.0677f
C8109 a_190501_326377# user_project_wrapper_0.IOVSS1 0.92523f
C8110 a_189184_326377# user_project_wrapper_0.IOVSS1 1.52714f
C8111 a_189756_326377# user_project_wrapper_0.IOVSS1 1.36548f
C8112 a_187364_324106# user_project_wrapper_0.IOVSS1 3.42071f
C8113 a_211921_327586# user_project_wrapper_0.IOVSS1 0.07783f $ **FLOATING
C8114 a_211537_327586# user_project_wrapper_0.IOVSS1 0.07661f $ **FLOATING
C8115 a_211153_327586# user_project_wrapper_0.IOVSS1 0.07751f $ **FLOATING
C8116 a_210109_327491# user_project_wrapper_0.IOVSS1 0.13835f
C8117 a_209905_327491# user_project_wrapper_0.IOVSS1 0.13981f
C8118 a_209041_327491# user_project_wrapper_0.IOVSS1 0.14098f
C8119 a_208469_327491# user_project_wrapper_0.IOVSS1 0.14129f
C8120 a_211921_327798# user_project_wrapper_0.IOVSS1 0.06628f $ **FLOATING
C8121 a_211537_327798# user_project_wrapper_0.IOVSS1 0.04802f $ **FLOATING
C8122 a_211153_327798# user_project_wrapper_0.IOVSS1 0.06596f $ **FLOATING
C8123 a_211921_328013# user_project_wrapper_0.IOVSS1 0.06616f $ **FLOATING
C8124 a_211537_328013# user_project_wrapper_0.IOVSS1 0.048f $ **FLOATING
C8125 a_211153_328013# user_project_wrapper_0.IOVSS1 0.06583f $ **FLOATING
C8126 a_211921_328225# user_project_wrapper_0.IOVSS1 0.07544f $ **FLOATING
C8127 a_211537_328225# user_project_wrapper_0.IOVSS1 0.07474f $ **FLOATING
C8128 a_211153_328225# user_project_wrapper_0.IOVSS1 0.07512f $ **FLOATING
C8129 a_210621_327491# user_project_wrapper_0.IOVSS1 1.86906f
C8130 a_210109_328013# user_project_wrapper_0.IOVSS1 0.24538f
C8131 a_209905_328013# user_project_wrapper_0.IOVSS1 0.24472f
C8132 a_209041_328013# user_project_wrapper_0.IOVSS1 0.24467f
C8133 a_208469_328013# user_project_wrapper_0.IOVSS1 0.24441f
C8134 a_210417_327491# user_project_wrapper_0.IOVSS1 1.33813f
C8135 a_210007_327491# user_project_wrapper_0.IOVSS1 0.44036f
C8136 a_209480_327491# user_project_wrapper_0.IOVSS1 1.06781f
C8137 a_209684_327491# user_project_wrapper_0.IOVSS1 0.92207f
C8138 a_208367_327491# user_project_wrapper_0.IOVSS1 1.50124f
C8139 a_208939_327491# user_project_wrapper_0.IOVSS1 1.37484f
C8140 a_192738_327586# user_project_wrapper_0.IOVSS1 0.07783f $ **FLOATING
C8141 a_192354_327586# user_project_wrapper_0.IOVSS1 0.07661f $ **FLOATING
C8142 a_191970_327586# user_project_wrapper_0.IOVSS1 0.07751f $ **FLOATING
C8143 a_190926_327491# user_project_wrapper_0.IOVSS1 0.13835f
C8144 a_190722_327491# user_project_wrapper_0.IOVSS1 0.13981f
C8145 a_189858_327491# user_project_wrapper_0.IOVSS1 0.14098f
C8146 a_189286_327491# user_project_wrapper_0.IOVSS1 0.14129f
C8147 a_192738_327798# user_project_wrapper_0.IOVSS1 0.06628f $ **FLOATING
C8148 a_192354_327798# user_project_wrapper_0.IOVSS1 0.04802f $ **FLOATING
C8149 a_191970_327798# user_project_wrapper_0.IOVSS1 0.06596f $ **FLOATING
C8150 a_192738_328013# user_project_wrapper_0.IOVSS1 0.06616f $ **FLOATING
C8151 a_192354_328013# user_project_wrapper_0.IOVSS1 0.048f $ **FLOATING
C8152 a_191970_328013# user_project_wrapper_0.IOVSS1 0.06583f $ **FLOATING
C8153 a_192738_328225# user_project_wrapper_0.IOVSS1 0.07544f $ **FLOATING
C8154 a_192354_328225# user_project_wrapper_0.IOVSS1 0.07474f $ **FLOATING
C8155 a_191970_328225# user_project_wrapper_0.IOVSS1 0.07512f $ **FLOATING
C8156 a_191438_327491# user_project_wrapper_0.IOVSS1 1.86906f
C8157 a_190926_328013# user_project_wrapper_0.IOVSS1 0.24538f
C8158 a_190722_328013# user_project_wrapper_0.IOVSS1 0.24472f
C8159 a_189858_328013# user_project_wrapper_0.IOVSS1 0.24467f
C8160 a_189286_328013# user_project_wrapper_0.IOVSS1 0.24441f
C8161 a_191234_327491# user_project_wrapper_0.IOVSS1 1.33813f
C8162 a_190824_327491# user_project_wrapper_0.IOVSS1 0.44036f
C8163 a_190297_327491# user_project_wrapper_0.IOVSS1 1.06781f
C8164 a_190501_327491# user_project_wrapper_0.IOVSS1 0.92207f
C8165 a_189184_327491# user_project_wrapper_0.IOVSS1 1.50068f
C8166 a_189756_327491# user_project_wrapper_0.IOVSS1 1.37484f
C8167 a_211921_328693# user_project_wrapper_0.IOVSS1 0.07549f $ **FLOATING
C8168 a_211537_328693# user_project_wrapper_0.IOVSS1 0.07479f $ **FLOATING
C8169 a_211153_328693# user_project_wrapper_0.IOVSS1 0.07517f $ **FLOATING
C8170 a_211921_328905# user_project_wrapper_0.IOVSS1 0.06615f $ **FLOATING
C8171 a_211537_328905# user_project_wrapper_0.IOVSS1 0.04797f $ **FLOATING
C8172 a_211153_328905# user_project_wrapper_0.IOVSS1 0.06583f $ **FLOATING
C8173 a_210109_328605# user_project_wrapper_0.IOVSS1 0.24585f
C8174 a_209905_328605# user_project_wrapper_0.IOVSS1 0.24523f
C8175 a_209041_328605# user_project_wrapper_0.IOVSS1 0.24538f
C8176 a_208469_328605# user_project_wrapper_0.IOVSS1 0.24647f
C8177 a_211921_329120# user_project_wrapper_0.IOVSS1 0.06622f $ **FLOATING
C8178 a_211537_329120# user_project_wrapper_0.IOVSS1 0.04794f $ **FLOATING
C8179 a_211153_329120# user_project_wrapper_0.IOVSS1 0.0659f $ **FLOATING
C8180 a_211921_329332# user_project_wrapper_0.IOVSS1 0.07789f $ **FLOATING
C8181 a_211537_329332# user_project_wrapper_0.IOVSS1 0.07687f $ **FLOATING
C8182 a_211153_329332# user_project_wrapper_0.IOVSS1 0.07757f $ **FLOATING
C8183 a_210621_328605# user_project_wrapper_0.IOVSS1 1.86914f
C8184 a_210109_329327# user_project_wrapper_0.IOVSS1 0.13859f
C8185 a_209905_329327# user_project_wrapper_0.IOVSS1 0.14004f
C8186 a_209041_329327# user_project_wrapper_0.IOVSS1 0.14015f
C8187 a_208469_329327# user_project_wrapper_0.IOVSS1 0.14034f
C8188 a_210417_328605# user_project_wrapper_0.IOVSS1 1.33682f
C8189 a_210007_328605# user_project_wrapper_0.IOVSS1 0.4399f
C8190 a_209480_328605# user_project_wrapper_0.IOVSS1 1.06826f
C8191 a_209684_328605# user_project_wrapper_0.IOVSS1 0.92574f
C8192 a_208367_328605# user_project_wrapper_0.IOVSS1 1.67107f
C8193 a_208939_328605# user_project_wrapper_0.IOVSS1 1.38467f
C8194 a_211921_329814# user_project_wrapper_0.IOVSS1 0.07779f $ **FLOATING
C8195 a_211537_329814# user_project_wrapper_0.IOVSS1 0.07697f $ **FLOATING
C8196 a_211153_329814# user_project_wrapper_0.IOVSS1 0.07747f $ **FLOATING
C8197 a_210109_329719# user_project_wrapper_0.IOVSS1 0.13824f
C8198 a_209905_329719# user_project_wrapper_0.IOVSS1 0.13971f
C8199 a_209041_329719# user_project_wrapper_0.IOVSS1 0.14082f
C8200 a_208469_329719# user_project_wrapper_0.IOVSS1 0.14113f
C8201 a_211921_330026# user_project_wrapper_0.IOVSS1 0.06628f $ **FLOATING
C8202 a_211537_330026# user_project_wrapper_0.IOVSS1 0.04862f $ **FLOATING
C8203 a_211153_330026# user_project_wrapper_0.IOVSS1 0.06596f $ **FLOATING
C8204 a_208103_324155# user_project_wrapper_0.IOVSS1 4.68752f
C8205 a_211921_330241# user_project_wrapper_0.IOVSS1 0.06717f $ **FLOATING
C8206 a_211537_330241# user_project_wrapper_0.IOVSS1 0.04903f $ **FLOATING
C8207 a_211153_330241# user_project_wrapper_0.IOVSS1 0.06685f $ **FLOATING
C8208 a_211921_330453# user_project_wrapper_0.IOVSS1 0.07874f $ **FLOATING
C8209 a_211537_330453# user_project_wrapper_0.IOVSS1 0.07601f $ **FLOATING
C8210 a_211153_330453# user_project_wrapper_0.IOVSS1 0.07705f $ **FLOATING
C8211 a_210621_329719# user_project_wrapper_0.IOVSS1 1.92277f
C8212 a_210109_330241# user_project_wrapper_0.IOVSS1 0.24955f
C8213 a_209905_330241# user_project_wrapper_0.IOVSS1 0.24994f
C8214 a_209041_330241# user_project_wrapper_0.IOVSS1 0.2488f
C8215 a_208469_330241# user_project_wrapper_0.IOVSS1 0.2491f
C8216 a_213870_324142# user_project_wrapper_0.IOVSS1 54.0825f
C8217 a_213462_327536# user_project_wrapper_0.IOVSS1 14.0968f
C8218 a_213376_328627# user_project_wrapper_0.IOVSS1 5.15593f
C8219 a_210417_329719# user_project_wrapper_0.IOVSS1 1.35851f
C8220 a_210007_329719# user_project_wrapper_0.IOVSS1 0.48107f
C8221 a_209480_329719# user_project_wrapper_0.IOVSS1 1.06832f
C8222 a_209684_329719# user_project_wrapper_0.IOVSS1 0.93478f
C8223 a_208367_329719# user_project_wrapper_0.IOVSS1 1.73325f
C8224 a_208939_329719# user_project_wrapper_0.IOVSS1 1.43798f
C8225 a_208017_326341# user_project_wrapper_0.IOVSS1 1.64599f
C8226 a_208939_325263# user_project_wrapper_0.IOVSS1 1.97552f
C8227 a_208017_327918# user_project_wrapper_0.IOVSS1 1.55757f
C8228 a_208367_325263# user_project_wrapper_0.IOVSS1 1.83314f
C8229 a_192738_328693# user_project_wrapper_0.IOVSS1 0.07549f $ **FLOATING
C8230 a_192354_328693# user_project_wrapper_0.IOVSS1 0.07479f $ **FLOATING
C8231 a_191970_328693# user_project_wrapper_0.IOVSS1 0.07517f $ **FLOATING
C8232 a_192738_328905# user_project_wrapper_0.IOVSS1 0.06615f $ **FLOATING
C8233 a_192354_328905# user_project_wrapper_0.IOVSS1 0.04797f $ **FLOATING
C8234 a_191970_328905# user_project_wrapper_0.IOVSS1 0.06583f $ **FLOATING
C8235 a_190926_328605# user_project_wrapper_0.IOVSS1 0.24585f
C8236 a_190722_328605# user_project_wrapper_0.IOVSS1 0.24523f
C8237 a_189858_328605# user_project_wrapper_0.IOVSS1 0.24541f
C8238 a_189286_328605# user_project_wrapper_0.IOVSS1 0.2465f
C8239 a_192738_329120# user_project_wrapper_0.IOVSS1 0.06622f $ **FLOATING
C8240 a_192354_329120# user_project_wrapper_0.IOVSS1 0.04794f $ **FLOATING
C8241 a_191970_329120# user_project_wrapper_0.IOVSS1 0.0659f $ **FLOATING
C8242 a_192738_329332# user_project_wrapper_0.IOVSS1 0.07789f $ **FLOATING
C8243 a_192354_329332# user_project_wrapper_0.IOVSS1 0.07687f $ **FLOATING
C8244 a_191970_329332# user_project_wrapper_0.IOVSS1 0.07757f $ **FLOATING
C8245 a_191438_328605# user_project_wrapper_0.IOVSS1 1.86914f
C8246 a_190926_329327# user_project_wrapper_0.IOVSS1 0.13859f
C8247 a_190722_329327# user_project_wrapper_0.IOVSS1 0.14004f
C8248 a_189858_329327# user_project_wrapper_0.IOVSS1 0.14015f
C8249 a_189286_329327# user_project_wrapper_0.IOVSS1 0.14034f
C8250 a_191234_328605# user_project_wrapper_0.IOVSS1 1.33682f
C8251 a_190824_328605# user_project_wrapper_0.IOVSS1 0.4399f
C8252 a_190297_328605# user_project_wrapper_0.IOVSS1 1.06826f
C8253 a_190501_328605# user_project_wrapper_0.IOVSS1 0.92574f
C8254 a_189184_328605# user_project_wrapper_0.IOVSS1 1.67188f
C8255 a_189756_328605# user_project_wrapper_0.IOVSS1 1.38524f
C8256 a_192738_329814# user_project_wrapper_0.IOVSS1 0.07779f $ **FLOATING
C8257 a_192354_329814# user_project_wrapper_0.IOVSS1 0.07697f $ **FLOATING
C8258 a_191970_329814# user_project_wrapper_0.IOVSS1 0.07747f $ **FLOATING
C8259 a_190926_329719# user_project_wrapper_0.IOVSS1 0.13824f
C8260 a_190722_329719# user_project_wrapper_0.IOVSS1 0.13971f
C8261 a_189858_329719# user_project_wrapper_0.IOVSS1 0.14082f
C8262 a_189286_329719# user_project_wrapper_0.IOVSS1 0.14113f
C8263 a_192738_330026# user_project_wrapper_0.IOVSS1 0.06628f $ **FLOATING
C8264 a_192354_330026# user_project_wrapper_0.IOVSS1 0.04862f $ **FLOATING
C8265 a_191970_330026# user_project_wrapper_0.IOVSS1 0.06596f $ **FLOATING
C8266 a_188920_324155# user_project_wrapper_0.IOVSS1 4.71824f
C8267 a_192738_330241# user_project_wrapper_0.IOVSS1 0.06717f $ **FLOATING
C8268 a_192354_330241# user_project_wrapper_0.IOVSS1 0.04903f $ **FLOATING
C8269 a_191970_330241# user_project_wrapper_0.IOVSS1 0.06685f $ **FLOATING
C8270 a_192738_330453# user_project_wrapper_0.IOVSS1 0.07874f $ **FLOATING
C8271 a_192354_330453# user_project_wrapper_0.IOVSS1 0.07601f $ **FLOATING
C8272 a_191970_330453# user_project_wrapper_0.IOVSS1 0.07705f $ **FLOATING
C8273 a_191438_329719# user_project_wrapper_0.IOVSS1 1.92277f
C8274 a_190926_330241# user_project_wrapper_0.IOVSS1 0.24955f
C8275 a_190722_330241# user_project_wrapper_0.IOVSS1 0.24994f
C8276 a_189858_330241# user_project_wrapper_0.IOVSS1 0.2488f
C8277 a_189286_330241# user_project_wrapper_0.IOVSS1 0.2491f
C8278 a_206201_328627# user_project_wrapper_0.IOVSS1 5.06937f
C8279 a_205385_326221# user_project_wrapper_0.IOVSS1 14.0959f
C8280 a_202114_326125# user_project_wrapper_0.IOVSS1 54.0819f
C8281 a_194687_324142# user_project_wrapper_0.IOVSS1 54.082f
C8282 a_194279_327536# user_project_wrapper_0.IOVSS1 14.0968f
C8283 a_194193_328627# user_project_wrapper_0.IOVSS1 5.15593f
C8284 a_191234_329719# user_project_wrapper_0.IOVSS1 1.35851f
C8285 a_190824_329719# user_project_wrapper_0.IOVSS1 0.48107f
C8286 a_190297_329719# user_project_wrapper_0.IOVSS1 1.06832f
C8287 a_190501_329719# user_project_wrapper_0.IOVSS1 0.93478f
C8288 a_189184_329719# user_project_wrapper_0.IOVSS1 1.73403f
C8289 a_189756_329719# user_project_wrapper_0.IOVSS1 1.43875f
C8290 a_188834_326341# user_project_wrapper_0.IOVSS1 1.64631f
C8291 a_189756_325263# user_project_wrapper_0.IOVSS1 1.97552f
C8292 a_188834_327918# user_project_wrapper_0.IOVSS1 1.5576f
C8293 a_189184_325263# user_project_wrapper_0.IOVSS1 1.83295f
C8294 a_187018_328627# user_project_wrapper_0.IOVSS1 5.06937f
C8295 a_186202_326221# user_project_wrapper_0.IOVSS1 14.0959f
C8296 a_182931_326125# user_project_wrapper_0.IOVSS1 54.0815f
C8297 a_212178_330851# user_project_wrapper_0.IOVSS1 0.1587f $ **FLOATING
C8298 a_211170_330851# user_project_wrapper_0.IOVSS1 0.6114f $ **FLOATING
C8299 a_210137_330851# user_project_wrapper_0.IOVSS1 0.57797f $ **FLOATING
C8300 a_209104_330851# user_project_wrapper_0.IOVSS1 0.58038f $ **FLOATING
C8301 a_208071_330851# user_project_wrapper_0.IOVSS1 0.58466f $ **FLOATING
C8302 a_207638_330851# user_project_wrapper_0.IOVSS1 0.15749f $ **FLOATING
C8303 a_192995_330851# user_project_wrapper_0.IOVSS1 0.1587f $ **FLOATING
C8304 a_191987_330851# user_project_wrapper_0.IOVSS1 0.6114f $ **FLOATING
C8305 a_190954_330851# user_project_wrapper_0.IOVSS1 0.57797f $ **FLOATING
C8306 a_189921_330851# user_project_wrapper_0.IOVSS1 0.58038f $ **FLOATING
C8307 a_188888_330851# user_project_wrapper_0.IOVSS1 0.58466f $ **FLOATING
C8308 a_188455_330851# user_project_wrapper_0.IOVSS1 0.15749f $ **FLOATING
C8309 a_212178_330987# user_project_wrapper_0.IOVSS1 0.10572f $ **FLOATING
C8310 a_211170_330987# user_project_wrapper_0.IOVSS1 0.37239f $ **FLOATING
C8311 a_210137_330987# user_project_wrapper_0.IOVSS1 0.3704f $ **FLOATING
C8312 a_210051_330987# user_project_wrapper_0.IOVSS1 1.72138f
C8313 a_209104_330987# user_project_wrapper_0.IOVSS1 0.37026f $ **FLOATING
C8314 a_208071_330987# user_project_wrapper_0.IOVSS1 0.37208f $ **FLOATING
C8315 a_207985_330987# user_project_wrapper_0.IOVSS1 1.67291f
C8316 a_207638_330987# user_project_wrapper_0.IOVSS1 0.10231f $ **FLOATING
C8317 a_192995_330987# user_project_wrapper_0.IOVSS1 0.10572f $ **FLOATING
C8318 a_191987_330987# user_project_wrapper_0.IOVSS1 0.37239f $ **FLOATING
C8319 a_190954_330987# user_project_wrapper_0.IOVSS1 0.3704f $ **FLOATING
C8320 a_190868_330987# user_project_wrapper_0.IOVSS1 1.72138f
C8321 a_189921_330987# user_project_wrapper_0.IOVSS1 0.37026f $ **FLOATING
C8322 a_188888_330987# user_project_wrapper_0.IOVSS1 0.37208f $ **FLOATING
C8323 a_188802_330987# user_project_wrapper_0.IOVSS1 1.67291f
C8324 a_188455_330987# user_project_wrapper_0.IOVSS1 0.10231f $ **FLOATING
C8325 a_212178_331163# user_project_wrapper_0.IOVSS1 0.10792f $ **FLOATING
C8326 TOP_ROILIFNEURON_0.MEM user_project_wrapper_0.IOVSS1 23.1716f
C8327 a_211170_331163# user_project_wrapper_0.IOVSS1 0.40257f $ **FLOATING
C8328 a_211084_330987# user_project_wrapper_0.IOVSS1 0.23819f
C8329 a_210937_330987# user_project_wrapper_0.IOVSS1 0.23858f
C8330 a_210137_331163# user_project_wrapper_0.IOVSS1 0.39862f $ **FLOATING
C8331 a_209904_331163# user_project_wrapper_0.IOVSS1 0.21444f
C8332 a_209104_331163# user_project_wrapper_0.IOVSS1 0.39832f $ **FLOATING
C8333 a_209018_330987# user_project_wrapper_0.IOVSS1 0.2397f
C8334 a_208871_330987# user_project_wrapper_0.IOVSS1 0.23839f
C8335 a_208071_331163# user_project_wrapper_0.IOVSS1 0.40213f $ **FLOATING
C8336 a_207638_331163# user_project_wrapper_0.IOVSS1 0.10469f $ **FLOATING
C8337 a_192995_331163# user_project_wrapper_0.IOVSS1 0.10792f $ **FLOATING
C8338 a_191987_331163# user_project_wrapper_0.IOVSS1 0.40257f $ **FLOATING
C8339 a_191901_330987# user_project_wrapper_0.IOVSS1 0.23819f
C8340 a_191754_330987# user_project_wrapper_0.IOVSS1 0.23858f
C8341 a_190954_331163# user_project_wrapper_0.IOVSS1 0.39862f $ **FLOATING
C8342 a_190721_331163# user_project_wrapper_0.IOVSS1 0.21444f
C8343 a_189921_331163# user_project_wrapper_0.IOVSS1 0.39832f $ **FLOATING
C8344 a_189835_330987# user_project_wrapper_0.IOVSS1 0.2397f
C8345 a_189688_330987# user_project_wrapper_0.IOVSS1 0.23839f
C8346 a_188888_331163# user_project_wrapper_0.IOVSS1 0.40213f $ **FLOATING
C8347 a_188455_331163# user_project_wrapper_0.IOVSS1 0.10469f $ **FLOATING
C8348 a_212178_331343# user_project_wrapper_0.IOVSS1 0.13533f $ **FLOATING
C8349 a_211170_331343# user_project_wrapper_0.IOVSS1 0.54544f $ **FLOATING
C8350 a_210137_331343# user_project_wrapper_0.IOVSS1 0.54325f $ **FLOATING
C8351 a_209104_331343# user_project_wrapper_0.IOVSS1 0.54301f $ **FLOATING
C8352 a_208071_331343# user_project_wrapper_0.IOVSS1 0.5451f $ **FLOATING
C8353 a_207638_331343# user_project_wrapper_0.IOVSS1 0.13131f $ **FLOATING
C8354 a_192995_331343# user_project_wrapper_0.IOVSS1 0.13533f $ **FLOATING
C8355 a_191987_331343# user_project_wrapper_0.IOVSS1 0.54544f $ **FLOATING
C8356 a_190954_331343# user_project_wrapper_0.IOVSS1 0.54325f $ **FLOATING
C8357 a_189921_331343# user_project_wrapper_0.IOVSS1 0.54301f $ **FLOATING
C8358 a_188888_331343# user_project_wrapper_0.IOVSS1 0.5451f $ **FLOATING
C8359 a_188455_331343# user_project_wrapper_0.IOVSS1 0.13131f $ **FLOATING
C8360 user_project_wrapper_0.sg13g2_IOPadIn$1_2.p2c user_project_wrapper_0.IOVSS1 18.9292f
C8361 a_200038_338690# user_project_wrapper_0.IOVSS1 1.88257f
C8362 user_project_wrapper_0.sg13g2_IOPadAnalog_23.padres user_project_wrapper_0.IOVSS1 8.23486f
C8363 a_284218_343292# user_project_wrapper_0.IOVSS1 0.47314f $ **FLOATING
C8364 user_project_wrapper_0.sg13g2_IOPadAnalog_22.padres user_project_wrapper_0.IOVSS1 26.9464f
C8365 a_263818_343292# user_project_wrapper_0.IOVSS1 0.47314f $ **FLOATING
C8366 user_project_wrapper_0.sg13g2_IOPadAnalog_21.padres user_project_wrapper_0.IOVSS1 24.3081f
C8367 a_243418_343292# user_project_wrapper_0.IOVSS1 0.47314f $ **FLOATING
C8368 user_project_wrapper_0.sg13g2_IOPadAnalog_20.padres user_project_wrapper_0.IOVSS1 8.23486f
C8369 a_223018_343292# user_project_wrapper_0.IOVSS1 0.47314f $ **FLOATING
C8370 user_project_wrapper_0.sg13g2_IOPadIn$1_2.sg13g2_LevelDown_noptap$1_0.sg13g2_SecondaryProtection$1$1_0.core user_project_wrapper_0.IOVSS1 6.23261f
C8371 a_200137_343292# user_project_wrapper_0.IOVSS1 0.47462f $ **FLOATING
C8372 user_project_wrapper_0.sg13g2_IOPadAnalog_18.padres user_project_wrapper_0.IOVSS1 8.23036f
C8373 a_182218_343292# user_project_wrapper_0.IOVSS1 0.47314f $ **FLOATING
C8374 user_project_wrapper_0.sg13g2_IOPadAnalog_17.padres user_project_wrapper_0.IOVSS1 20.4369f
C8375 a_161818_343292# user_project_wrapper_0.IOVSS1 0.47314f $ **FLOATING
C8376 user_project_wrapper_0.sg13g2_IOPadAnalog_19.padres user_project_wrapper_0.IOVSS1 25.6239f
C8377 a_141418_343292# user_project_wrapper_0.IOVSS1 0.47314f $ **FLOATING
C8378 user_project_wrapper_0.sg13g2_IOPadAnalog_16.padres user_project_wrapper_0.IOVSS1 8.23486f
C8379 a_121018_343292# user_project_wrapper_0.IOVSS1 0.47314f $ **FLOATING
C8380 a_286861_355784# user_project_wrapper_0.IOVSS1 0.05224f $ **FLOATING
C8381 a_278644_355624# user_project_wrapper_0.IOVSS1 0.48855f
C8382 a_266461_355784# user_project_wrapper_0.IOVSS1 0.05224f $ **FLOATING
C8383 a_258244_355624# user_project_wrapper_0.IOVSS1 0.48855f
C8384 a_246061_355784# user_project_wrapper_0.IOVSS1 0.05224f $ **FLOATING
C8385 a_237844_355624# user_project_wrapper_0.IOVSS1 0.48855f
C8386 a_225661_355784# user_project_wrapper_0.IOVSS1 0.05224f $ **FLOATING
C8387 a_217444_355624# user_project_wrapper_0.IOVSS1 0.48855f
C8388 a_184861_355784# user_project_wrapper_0.IOVSS1 0.05224f $ **FLOATING
C8389 a_176644_355624# user_project_wrapper_0.IOVSS1 0.48855f
C8390 a_164461_355784# user_project_wrapper_0.IOVSS1 0.05224f $ **FLOATING
C8391 a_156244_355624# user_project_wrapper_0.IOVSS1 0.48855f
C8392 a_144061_355784# user_project_wrapper_0.IOVSS1 0.05224f $ **FLOATING
C8393 a_135844_355624# user_project_wrapper_0.IOVSS1 0.48855f
C8394 a_123661_355784# user_project_wrapper_0.IOVSS1 0.05224f $ **FLOATING
C8395 a_115444_355624# user_project_wrapper_0.IOVSS1 0.48855f
C8396 user_project_wrapper_0.sg13g2_IOPadIOVdd_2.sg13g2_RCClampResistor_0.p2 user_project_wrapper_0.IOVSS1 0.15451p
C8397 a_306025_360458# user_project_wrapper_0.IOVSS1 3.53966f $ **FLOATING
C8398 a_305695_360458# user_project_wrapper_0.IOVSS1 3.04229f $ **FLOATING
C8399 a_305695_364458# user_project_wrapper_0.IOVSS1 0.46084f
C8400 a_305365_360372# user_project_wrapper_0.IOVSS1 0.41869f
C8401 a_305365_360458# user_project_wrapper_0.IOVSS1 3.04218f $ **FLOATING
C8402 a_305035_360458# user_project_wrapper_0.IOVSS1 3.04229f $ **FLOATING
C8403 a_305035_364458# user_project_wrapper_0.IOVSS1 0.43535f
C8404 a_304705_360372# user_project_wrapper_0.IOVSS1 0.41869f
C8405 a_304705_360458# user_project_wrapper_0.IOVSS1 3.04218f $ **FLOATING
C8406 a_304375_360458# user_project_wrapper_0.IOVSS1 3.04226f $ **FLOATING
C8407 a_304375_364458# user_project_wrapper_0.IOVSS1 0.43536f
C8408 a_304045_360372# user_project_wrapper_0.IOVSS1 0.41869f
C8409 a_304045_360458# user_project_wrapper_0.IOVSS1 3.04218f $ **FLOATING
C8410 a_303715_360458# user_project_wrapper_0.IOVSS1 3.04218f $ **FLOATING
C8411 a_303715_364458# user_project_wrapper_0.IOVSS1 0.43539f
C8412 a_303385_360372# user_project_wrapper_0.IOVSS1 0.41869f
C8413 a_303385_360458# user_project_wrapper_0.IOVSS1 3.04218f $ **FLOATING
C8414 a_303055_360458# user_project_wrapper_0.IOVSS1 3.04218f $ **FLOATING
C8415 a_303055_364458# user_project_wrapper_0.IOVSS1 0.43538f
C8416 a_302725_360372# user_project_wrapper_0.IOVSS1 0.41869f
C8417 a_302725_360458# user_project_wrapper_0.IOVSS1 3.04229f $ **FLOATING
C8418 a_302395_360458# user_project_wrapper_0.IOVSS1 3.04218f $ **FLOATING
C8419 a_302395_364458# user_project_wrapper_0.IOVSS1 0.43535f
C8420 a_302065_360372# user_project_wrapper_0.IOVSS1 0.41869f
C8421 a_302065_360458# user_project_wrapper_0.IOVSS1 3.04229f $ **FLOATING
C8422 a_301735_360458# user_project_wrapper_0.IOVSS1 3.04218f $ **FLOATING
C8423 a_301735_364458# user_project_wrapper_0.IOVSS1 0.43535f
C8424 a_301405_360372# user_project_wrapper_0.IOVSS1 0.41869f
C8425 a_301405_360458# user_project_wrapper_0.IOVSS1 3.04229f $ **FLOATING
C8426 a_301075_360458# user_project_wrapper_0.IOVSS1 3.04218f $ **FLOATING
C8427 a_301075_364458# user_project_wrapper_0.IOVSS1 0.43537f
C8428 a_300745_360372# user_project_wrapper_0.IOVSS1 0.41869f
C8429 a_300745_360458# user_project_wrapper_0.IOVSS1 3.04224f $ **FLOATING
C8430 a_300415_360458# user_project_wrapper_0.IOVSS1 3.04218f $ **FLOATING
C8431 a_300415_364458# user_project_wrapper_0.IOVSS1 0.43541f
C8432 a_300085_360372# user_project_wrapper_0.IOVSS1 0.41869f
C8433 a_300085_360458# user_project_wrapper_0.IOVSS1 3.04218f $ **FLOATING
C8434 a_299755_360458# user_project_wrapper_0.IOVSS1 3.04218f $ **FLOATING
C8435 a_299755_364458# user_project_wrapper_0.IOVSS1 0.43539f
C8436 a_299425_360372# user_project_wrapper_0.IOVSS1 0.41869f
C8437 a_299425_360458# user_project_wrapper_0.IOVSS1 3.04218f $ **FLOATING
C8438 a_299095_360458# user_project_wrapper_0.IOVSS1 3.04229f $ **FLOATING
C8439 a_299095_364458# user_project_wrapper_0.IOVSS1 0.43539f
C8440 a_298765_360372# user_project_wrapper_0.IOVSS1 0.41869f
C8441 a_298765_360458# user_project_wrapper_0.IOVSS1 3.04218f $ **FLOATING
C8442 a_298435_360458# user_project_wrapper_0.IOVSS1 3.04229f $ **FLOATING
C8443 a_298435_364458# user_project_wrapper_0.IOVSS1 0.43535f
C8444 a_298105_360372# user_project_wrapper_0.IOVSS1 0.41869f
C8445 a_298105_360458# user_project_wrapper_0.IOVSS1 3.04218f $ **FLOATING
C8446 a_297775_360458# user_project_wrapper_0.IOVSS1 3.53976f $ **FLOATING
C8447 a_297775_364458# user_project_wrapper_0.IOVSS1 0.46084f
C8448 user_project_wrapper_0.sg13g2_IOPadIOVdd_2.sg13g2_Clamp_N43N43D4R_0.gate user_project_wrapper_0.IOVSS1 0.18346p
C8449 a_286861_369456# user_project_wrapper_0.IOVSS1 0.56457f $ **FLOATING
C8450 user_project_wrapper_0.analog_io[35] user_project_wrapper_0.IOVSS1 0.52007p
C8451 a_278644_369296# user_project_wrapper_0.IOVSS1 27.0586f
C8452 a_266461_369456# user_project_wrapper_0.IOVSS1 0.56457f $ **FLOATING
C8453 user_project_wrapper_0.analog_io[34] user_project_wrapper_0.IOVSS1 0.37486p
C8454 a_258244_369296# user_project_wrapper_0.IOVSS1 27.0586f
C8455 a_246061_369456# user_project_wrapper_0.IOVSS1 0.56457f $ **FLOATING
C8456 user_project_wrapper_0.analog_io[33] user_project_wrapper_0.IOVSS1 0.37486p
C8457 a_237844_369296# user_project_wrapper_0.IOVSS1 27.0586f
C8458 a_225661_369456# user_project_wrapper_0.IOVSS1 0.56457f $ **FLOATING
C8459 user_project_wrapper_0.analog_io[32] user_project_wrapper_0.IOVSS1 0.49986p
C8460 a_217444_369296# user_project_wrapper_0.IOVSS1 27.0586f
C8461 user_project_wrapper_0.ui_PAD[31] user_project_wrapper_0.IOVSS1 0.2212p
C8462 a_184861_369456# user_project_wrapper_0.IOVSS1 0.56457f $ **FLOATING
C8463 user_project_wrapper_0.analog_io[30] user_project_wrapper_0.IOVSS1 0.50038p
C8464 a_176644_369296# user_project_wrapper_0.IOVSS1 27.0586f
C8465 a_164461_369456# user_project_wrapper_0.IOVSS1 0.56457f $ **FLOATING
C8466 user_project_wrapper_0.analog_io[29] user_project_wrapper_0.IOVSS1 0.37486p
C8467 a_156244_369296# user_project_wrapper_0.IOVSS1 27.0586f
C8468 a_144061_369456# user_project_wrapper_0.IOVSS1 0.56457f $ **FLOATING
C8469 user_project_wrapper_0.analog_io[28] user_project_wrapper_0.IOVSS1 0.37486p
C8470 a_135844_369296# user_project_wrapper_0.IOVSS1 27.0586f
C8471 a_123661_369456# user_project_wrapper_0.IOVSS1 0.56457f $ **FLOATING
C8472 user_project_wrapper_0.analog_io[27] user_project_wrapper_0.IOVSS1 0.51987p
C8473 a_115444_369296# user_project_wrapper_0.IOVSS1 27.0586f
C8474 user_project_wrapper_0.sg13g2_IOPadVdd_3.sg13g2_RCClampResistor_0.p2 user_project_wrapper_0.IOVSS1 0.19066p
C8475 a_81625_360458# user_project_wrapper_0.IOVSS1 3.53996f $ **FLOATING
C8476 a_81295_360458# user_project_wrapper_0.IOVSS1 3.04229f $ **FLOATING
C8477 a_81295_364458# user_project_wrapper_0.IOVSS1 0.46261f
C8478 a_80965_360372# user_project_wrapper_0.IOVSS1 0.42107f
C8479 a_80965_360458# user_project_wrapper_0.IOVSS1 3.04251f $ **FLOATING
C8480 a_80635_360458# user_project_wrapper_0.IOVSS1 3.04229f $ **FLOATING
C8481 a_80635_364458# user_project_wrapper_0.IOVSS1 0.43692f
C8482 a_80305_360372# user_project_wrapper_0.IOVSS1 0.42044f
C8483 a_80305_360458# user_project_wrapper_0.IOVSS1 3.04244f $ **FLOATING
C8484 a_79975_360458# user_project_wrapper_0.IOVSS1 3.04226f $ **FLOATING
C8485 a_79975_364458# user_project_wrapper_0.IOVSS1 0.43577f
C8486 a_79645_360372# user_project_wrapper_0.IOVSS1 0.41869f
C8487 a_79645_360458# user_project_wrapper_0.IOVSS1 3.04229f $ **FLOATING
C8488 a_79315_360458# user_project_wrapper_0.IOVSS1 3.0422f $ **FLOATING
C8489 a_79315_364458# user_project_wrapper_0.IOVSS1 0.43582f
C8490 a_78985_360372# user_project_wrapper_0.IOVSS1 0.42067f
C8491 a_78985_360458# user_project_wrapper_0.IOVSS1 3.04218f $ **FLOATING
C8492 a_78655_360458# user_project_wrapper_0.IOVSS1 3.04235f $ **FLOATING
C8493 a_78655_364458# user_project_wrapper_0.IOVSS1 0.43683f
C8494 a_78325_360372# user_project_wrapper_0.IOVSS1 0.42107f
C8495 a_78325_360458# user_project_wrapper_0.IOVSS1 3.04229f $ **FLOATING
C8496 a_77995_360458# user_project_wrapper_0.IOVSS1 3.0425f $ **FLOATING
C8497 a_77995_364458# user_project_wrapper_0.IOVSS1 0.43692f
C8498 a_77665_360372# user_project_wrapper_0.IOVSS1 0.42107f
C8499 a_77665_360458# user_project_wrapper_0.IOVSS1 3.04229f $ **FLOATING
C8500 a_77335_360458# user_project_wrapper_0.IOVSS1 3.04251f $ **FLOATING
C8501 a_77335_364458# user_project_wrapper_0.IOVSS1 0.43692f
C8502 a_77005_360372# user_project_wrapper_0.IOVSS1 0.42107f
C8503 a_77005_360458# user_project_wrapper_0.IOVSS1 3.04229f $ **FLOATING
C8504 a_76675_360458# user_project_wrapper_0.IOVSS1 3.04243f $ **FLOATING
C8505 a_76675_364458# user_project_wrapper_0.IOVSS1 0.4369f
C8506 a_76345_360372# user_project_wrapper_0.IOVSS1 0.42107f
C8507 a_76345_360458# user_project_wrapper_0.IOVSS1 3.04224f $ **FLOATING
C8508 a_76015_360458# user_project_wrapper_0.IOVSS1 3.04228f $ **FLOATING
C8509 a_76015_364458# user_project_wrapper_0.IOVSS1 0.43686f
C8510 a_75685_360372# user_project_wrapper_0.IOVSS1 0.42068f
C8511 a_75685_360458# user_project_wrapper_0.IOVSS1 3.04222f $ **FLOATING
C8512 a_75355_360458# user_project_wrapper_0.IOVSS1 3.04218f $ **FLOATING
C8513 a_75355_364458# user_project_wrapper_0.IOVSS1 0.43582f
C8514 a_75025_360372# user_project_wrapper_0.IOVSS1 0.41886f
C8515 a_75025_360458# user_project_wrapper_0.IOVSS1 3.04237f $ **FLOATING
C8516 a_74695_360458# user_project_wrapper_0.IOVSS1 3.04229f $ **FLOATING
C8517 a_74695_364458# user_project_wrapper_0.IOVSS1 0.43577f
C8518 a_74365_360372# user_project_wrapper_0.IOVSS1 0.42168f
C8519 a_74365_360458# user_project_wrapper_0.IOVSS1 3.04251f $ **FLOATING
C8520 a_74035_360458# user_project_wrapper_0.IOVSS1 3.04229f $ **FLOATING
C8521 a_74035_364458# user_project_wrapper_0.IOVSS1 0.43692f
C8522 a_73705_360372# user_project_wrapper_0.IOVSS1 0.44953f
C8523 a_73705_360458# user_project_wrapper_0.IOVSS1 3.04251f $ **FLOATING
C8524 a_73375_360458# user_project_wrapper_0.IOVSS1 3.60187f $ **FLOATING
C8525 a_73375_364458# user_project_wrapper_0.IOVSS1 0.46262f
C8526 user_project_wrapper_0.sg13g2_IOPadVdd_3.sg13g2_RCClampInverter_noptap_0.out user_project_wrapper_0.IOVSS1 0.28435p
C8527 user_project_wrapper_0.IOVDD2 user_project_wrapper_0.IOVSS1 4.43279p
C8528 user_project_wrapper_0.VDD2 user_project_wrapper_0.IOVSS1 4.3456p
C8529 QDLL_TOP_0.VDD user_project_wrapper_0.IOVSS1 0.2122p
C8530 w_207989_323975# user_project_wrapper_0.IOVSS1 0.89933f
C8531 w_188806_323975# user_project_wrapper_0.IOVSS1 0.91528f
C8532 w_207887_326203# user_project_wrapper_0.IOVSS1 1.67273f
C8533 w_188704_326203# user_project_wrapper_0.IOVSS1 1.69133f
C8534 w_207887_327938# user_project_wrapper_0.IOVSS1 1.71316f
C8535 w_207883_330166# user_project_wrapper_0.IOVSS1 1.12436f
C8536 w_188704_327938# user_project_wrapper_0.IOVSS1 1.69108f
C8537 w_188700_330166# user_project_wrapper_0.IOVSS1 1.12436f
C8538 user_project_wrapper_0.VDD1 user_project_wrapper_0.IOVSS1 5.03526p
C8539 user_project_wrapper_0.IOVDD1 user_project_wrapper_0.IOVSS1 5.02112p
C8540 VDD3 user_project_wrapper_0.IOVSS1 4.9896p
C8541 IOVDD3 user_project_wrapper_0.IOVSS1 4.70646p
C8542 user_project_wrapper_0.IOVDD4 user_project_wrapper_0.IOVSS1 4.88784p
.ends
